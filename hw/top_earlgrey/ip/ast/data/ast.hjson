// Copyright lowRISC contributors (OpenTitan project).
// Licensed under the Apache License, Version 2.0, see LICENSE for details.
// SPDX-License-Identifier: Apache-2.0
//#############################################################################
// *Name: ast
// *Module Description: Analog Sensors Top Registers
//#############################################################################
{ name:               "ast",
  // Unique comportable IP identifier defined under KNOWN_CIP_IDS in the regtool.
  cip_id:             "34",
  design_spec:        "../doc",
  dv_doc:             "",
  hw_checklist:       "",
  sw_checklist:       "",
  version:            "2.0.0",
  life_stage:         "L1",
  design_stage:       "D1",
  verification_stage: "V2S",
  dif_stage:          "",
  is_split_ip: "true",
  clocking: {
    primary: [
      { clock: "clk_ast_tlul_i",  reset: "rst_ast_tlul_ni", primary: true },
      { clock: "clk_ast_es_i",    reset: "rst_ast_es_ni"},
      { clock: "clk_ast_usb_i",   reset: "rst_ast_usb_ni"},
      // Unmanaged external clock from a pad for FPGA.
      { clock: "clk_ast_ext_i"},
    ],
    secondary: [
      { clock: "clk_ast_adc_i",   reset: "rst_ast_adc_ni"},
      // Primary clock because it controls alerts.
      { clock: "clk_ast_alert_i", reset: "rst_ast_alert_ni", primary: true},
      { clock: "clk_ast_es_i",    reset: "rst_ast_es_ni"},
      { clock: "clk_ast_rng_i",   reset: "rst_ast_rng_ni"},
      { clock: "clk_ast_tlul_i",  reset: "rst_ast_tlul_ni" },
      { clock: "clk_ast_usb_i",   reset: "rst_ast_usb_ni"},
      // Unmanaged external clock from a pad for FPGA.
      { clock: "clk_ast_ext_i"},
    ],
  },
  bus_interfaces: [
    { protocol: "tlul",
      direction: "device"
    }
  ],
  no_auto_alert_regs: "True",
  param_list: [
    { name:    "NumRegsB",
      desc: "Number of registers in the Array-B",
      type:    "int",
      default: "5",
    },
    { name: "NumUsbBeaconPulses",
      desc: "Number of USB valid beacon pulses for clock to re-calibrate",
      type: "int",
      default: "8",
    },
    { name:      "EntropyStreams",
      desc:      "Number of RNG bit streams",
      type:      "int unsigned",
      default:   "4",
      expose:    "true",
    },
    { name:      "UsbCalibWidth",
      desc:      "Width of the USB IO pull-up calibration setting",
      type:      "int unsigned",
      default:   "20",
      expose:    "true",
      local:     "false", // used for signals going to chip
      partition: "secondary",
    },
    { name:      "Pad2AstInWidth",
      desc:      "Width of the DFT pad-to-AST input signal bus",
      type:      "int unsigned",
      default:   "8",
      expose:    "true",
      local:     "false", // used for signals going to chip
      partition: "secondary",
    },
    { name:      "Ast2PadOutWidth",
      desc:      "Width of the DFT AST-to-pad output signal bus",
      type:      "int unsigned",
      default:   "9",
      expose:    "true",
      partition: "secondary",
    },
  ],
  inter_signal_list: [
    ///////////////////////
    // Primary partition //
    ///////////////////////
    { struct:    "logic",
      type:      "uni",
      name:      "rng_b",
      act:       "req",
      width:     "EntropyStreams",
      package:   "",
      desc:      "RNG bit stream(s) generated",
    },
    { struct:    "mubi4",
      type:      "uni",
      name:      "init_done",
      act:       "req",
      package:   "prim_mubi_pkg",
      desc:      "AST (registers) init done",
    },
    { struct:    "logic",
      type:      "uni",
      name:      "rng_en",
      act:       "rcv",
      desc:      "RNG enable",
    },
    { struct:    "logic",
      type:      "uni",
      name:      "rng_fips",
      act:       "rcv",
      desc:      "RNG FIPS",
    },
    { struct:    "logic",
      type:      "uni",
      name:      "rng_val",
      act:       "req",
      desc:      "RNG valid",
    },
    { struct:    "edn",
      type:      "req_rsp",
      name:      "edn",
      act:       "req",
      package:   "edn_pkg",
      desc:      "Entropy distribution request/response",
    },
    { struct:    "mubi4",
      type:      "uni",
      name:      "clk_src_sys_jen",
      act:       "rcv",
      package:   "prim_mubi_pkg",
      desc:      "SYS source clock jitter enable",
    },
    { struct:    "logic",
      type:      "uni",
      name:      "clk_src_sys",
      act:       "req",
      desc:      "SYS source clock",
    },
    { struct:    "logic",
      type:      "uni",
      name:      "clk_src_io",
      act:       "req",
      desc:      "IO source clock",
    },
    { struct:    "mubi4",
      type:      "uni",
      name:      "clk_src_io_48m",
      act:       "req",
      package:   "prim_mubi_pkg",
      desc:      "IO source clock is 48MHz",
    },
    { struct:    "logic",
      type:      "uni",
      name:      "clk_src_usb",
      act:       "req",
      desc:      "USB source clock",
    },
    { struct:    "mubi4",
      type:      "uni",
      name:      "io_clk_byp_ack",
      act:       "req",
      package:   "prim_mubi_pkg",
      desc:      "Switch IO clock to external clock ack",
    },
    { struct:    "mubi4",
      type:      "uni",
      name:      "all_clk_byp_ack",
      act:       "req",
      package:   "prim_mubi_pkg",
      desc:      "Switch all clocks to external clocks ack",
    },

    /////////////////////////
    // Secondary partition //
    /////////////////////////
    { struct:    "logic",
      type:      "uni",
      name:      "usb_io_pu_cal",
      act:       "req",
      width:     "UsbCalibWidth",
      package:   "",
      partition: "secondary",
      desc:      "USB IO pull-up calibration setting",
    },
    { struct:    "adc_ast",
      type:      "req_rsp",
      name:      "adc",
      act:       "rsp",
      package:   "ast_pkg",
      partition: "secondary",
      desc:      "ADC interface",
    },
    { struct:    "awire",
      type:      "uni",
      name:      "adc_a0_a",
      act:       "rcv",
      package:   "ast_pkg",
      partition: "secondary",
      desc:      "ADC A0 Analog Input",
    },
    { struct:    "awire",
      type:      "uni",
      name:      "adc_a1_a",
      act:       "rcv",
      package:   "ast_pkg",
      partition: "secondary",
      desc:      "ADC A1 Analog Input",
    },
    { struct:    "awire",
      type:      "uni",
      name:      "ast2pad_t0_a",
      act:       "req",
      package:   "ast_pkg",
      partition: "secondary",
      desc:      "AST_2_PAD Analog T0 Output Signal",
    },
    { struct:    "awire",
      type:      "uni",
      name:      "ast2pad_t1_a",
      act:       "req",
      package:   "ast_pkg",
      partition: "secondary",
      desc:      "AST_2_PAD Analog T1 Output Signal",
    },
    { struct:    "logic",
      type:      "uni",
      name:      "padmux2ast",
      act:       "rcv",
      width:     "Pad2AstInWidth",
      package:   "",
      partition: "secondary",
      desc:      "IO-to-DFT input signals",
    },
    { struct:    "logic",
      type:      "uni",
      name:      "ast2padmux",
      act:       "req",
      width:     "Ast2PadOutWidth",
      package:   "",
      partition: "secondary",
      desc:      "DFT-to-IO output signals",
    },
    { struct:    "logic",
      type:      "uni",
      name:      "por_n",
      act:       "rcv",
      partition: "secondary",
      desc:      "External power ON reset",
    },
    { struct:    "clkmgr_out",
      type:      "uni",
      name:      "sns_clks",
      act:       "rcv",
      package:   "clkmgr_pkg",
      partition: "secondary",
      desc:      "Sensed clocks",
    },
    { struct:    "rstmgr_out",
      type:      "uni",
      name:      "sns_rsts",
      act:       "rcv",
      package:   "rstmgr_pkg",
      partition: "secondary",
      desc:      "Sensed resets",
    },
    { struct:    "logic",
      type:      "uni",
      name:      "sns_spi_ext_clk",
      act:       "rcv",
      partition: "secondary",
      desc:      "Sensed SPI external clock",
    },
    { struct:    "ast_vx_supp",
      type:      "uni",
      name:      "vx_supp",
      act:       "rcv",
      package:   "ast_pkg",
      partition: "secondary",
      desc:      "Supply voltage tests for OS FPGA",
    },
    { struct:    "ast_pwst",
      type:      "uni",
      name:      "ast_pwst",
      act:       "req",
      package:   "ast_pkg",
      partition: "secondary",
      desc:      "AON, MAIN, IO-0 rail, IO-1 rail power OK @1.1V",
    },
    { struct:    "ast_pwst",
      type:      "uni",
      name:      "ast_pwst_h",
      act:       "req",
      package:   "ast_pkg",
      partition: "secondary",
      desc:      "AON, MAIN, IO-0 rail, IO-1 rail power OK @3.3V",
    },
    { struct:    "logic",
      type:      "uni",
      name:      "rstmgr_por_n",
      act:       "req",
      width:     "2",
      partition: "secondary",
      desc:      "Per-power-domain power-on-reset for rstmgr.por_n",
    },
    { struct:    "ast_status",
      type:      "uni",
      name:      "io_pwr_st",
      act:       "req",
      package:   "ast_pkg",
      partition: "secondary",
      desc:      "IO power state",
    },
    { struct:    "pwr_ast",
      type:      "req_rsp",
      name:      "pwrmgr",
      act:       "rsp",
      package:   "pwrmgr_pkg",
      partition: "secondary",
      desc:      "Interface to pwrmgr",
    },
    { struct:    "logic",
      type:      "uni",
      name:      "flash_power_down_h",
      act:       "req",
      partition: "secondary",
      desc:      "Flash power down",
    },
    { struct:    "logic",
      type:      "uni",
      name:      "flash_power_ready_h",
      act:       "req",
      partition: "secondary",
      desc:      "Flash power ready",
    },
    { struct:    "logic",
      type:      "uni",
      name:      "otp_power_seq",
      act:       "rcv",
      width:     "2",
      partition: "secondary",
      desc:      "OTP power sequencing, in (VDD)",
    },
    { struct:    "logic",
      type:      "uni",
      name:      "otp_power_seq_h",
      act:       "req",
      width:     "2",
      partition: "secondary",
      desc:      "OTP power sequencing masked by PDM, out (VCC)",
    },
    { struct:    "logic",
      type:      "uni",
      name:      "clk_src_aon",
      act:       "req",
      partition: "secondary",
      desc:      "AON source clock",
    },
    { struct:    "logic",
      type:      "uni",
      name:      "usb_ref_pulse",
      act:       "rcv",
      partition: "secondary",
      desc:      "USB reference pulse",
    },
    { struct:    "logic",
      type:      "uni",
      name:      "usb_ref_val",
      act:       "rcv",
      partition: "secondary",
      desc:      "USB reference valid",
    },
    { struct:    "ast_alert",
      type:      "req_rsp",
      name:      "alert",
      act:       "req",
      package:   "ast_pkg",
      partition: "secondary",
      desc:      "Analog alert events to sensor_ctrl",
    },
    { struct:    "dft_strap_test_req",
      type:      "uni",
      name:      "dft_strap_test",
      act:       "rcv",
      package:   "pinmux_pkg",
      partition: "secondary",
      desc:      "DFT straps",
    },
    { struct:    "lc_tx",
      type:      "uni",
      name:      "lc_dft_en",
      act:       "rcv",
      package:   "lc_ctrl_pkg",
      partition: "secondary",
      desc:      "DFT enable (secure bus)",
    },
    { struct:    "ast_obs_bus",
      type:      "uni",
      name:      "obs",
      act:       "rcv",
      package:   "ast_pkg",
      partition: "secondary",
      desc:      "Observe bus",
    },
    { struct:    "ast_obs_ctrl",
      type:      "uni",
      name:      "obs_ctrl",
      act:       "req",
      package:   "ast_pkg",
      partition: "secondary",
      desc:      "Observe control",
    },
    { struct:    "logic",
      type:      "uni",
      name:      "mux_iob_sel",
      act:       "req",
      width:     "4",
      partition: "secondary",
      desc:      "IOB or SPI selector",
    },
    { struct:    "mubi4",
      type:      "uni",
      name:      "flash_bist_en",
      act:       "req",
      package:   "prim_mubi_pkg",
      partition: "secondary",
      desc:      "Flash BIST (TAP) enable",
    },
    { struct:    "mubi4",
      type:      "uni",
      name:      "dft_scan_md",
      act:       "req",
      package:   "prim_mubi_pkg",
      partition: "secondary",
      desc:      "Scan mode output",
    },
    { struct:    "logic",
      type:      "uni",
      name:      "scan_shift_en",
      act:       "req",
      partition: "secondary",
      desc:      "Scan shift enable output",
    },
    { struct:    "logic",
      type:      "uni",
      name:      "scan_reset_n",
      act:       "req",
      partition: "secondary",
      desc:      "Scan reset output",
    },

    /////////////////////////////////////////////////////////////
    // Both partitions - duplicated as 'both' is not supported //
    /////////////////////////////////////////////////////////////
    { struct:    "ast_mem_cfg_primary",
      type:      "req_rsp",
      name:      "mem_cfg",
      act:       "req",
      package:   "ast_pkg",
      partition: "primary",
      desc:      "Memory configuration",
    },
    { struct:    "ast_mem_cfg_secondary",
      type:      "req_rsp",
      name:      "mem_cfg",
      act:       "req",
      package:   "ast_pkg",
      partition: "secondary",
      desc:      "Memory configuration",
    },
    { struct:    "clks_osc_byp",
      type:      "uni",
      name:      "clk_osc_byp",
      act:       "rcv",
      package:   "ast_pkg",
      partition: "primary",
      desc:      "Clocks' oscillator bypass for OS FPGA/Verilator (AST_BYPASS_CLK only)",
    },
    { struct:    "clks_osc_byp",
      type:      "uni",
      name:      "clk_osc_byp",
      act:       "rcv",
      package:   "ast_pkg",
      partition: "secondary",
      desc:      "Clocks' oscillator bypass for OS FPGA/Verilator (AST_BYPASS_CLK only)",
    },
    { struct:    "mubi4",
      type:      "uni",
      name:      "ext_freq_is_96m",
      act:       "rcv",
      package:   "prim_mubi_pkg",
      partition: "primary",
      desc:      "External clock frequency is 96MHz",
    },
    { struct:    "mubi4",
      type:      "uni",
      name:      "ext_freq_is_96m",
      act:       "rcv",
      package:   "prim_mubi_pkg",
      partition: "secondary",
      desc:      "External clock frequency is 96MHz",
    },
    { struct:    "mubi4",
      type:      "uni",
      name:      "all_clk_byp_req",
      act:       "rcv",
      package:   "prim_mubi_pkg",
      partition: "primary",
      desc:      "All clocks bypass request",
    },
    { struct:    "mubi4",
      type:      "uni",
      name:      "all_clk_byp_req",
      act:       "rcv",
      package:   "prim_mubi_pkg",
      partition: "secondary",
      desc:      "All clocks bypass request",
    },
    { struct:    "mubi4",
      type:      "uni",
      name:      "io_clk_byp_req",
      act:       "rcv",
      package:   "prim_mubi_pkg",
      partition: "primary",
      desc:      "IO clock bypass request (for OTP bootstrap)",
    },
    { struct:    "mubi4",
      type:      "uni",
      name:      "io_clk_byp_req",
      act:       "rcv",
      package:   "prim_mubi_pkg",
      partition: "secondary",
      desc:      "IO clock bypass request (for OTP bootstrap)",
    },

    //////////////////////////
    // Intra-IP connections //
    //////////////////////////
    { struct:    "s2p",
      type:      "uni",
      name:      "intraip_s2p",
      act:       "rcv",
      package:   "ast_intraip_pkg",
      desc:      "Secondary-to-Primary partition communication",
    },
    { struct:    "p2s",
      type:      "uni",
      name:      "intraip_p2s",
      act:       "req",
      package:   "ast_intraip_pkg",
      desc:      "Primary-to-Secondary partition communication",
    },
    { struct:    "s2p",
      type:      "uni",
      name:      "intraip_s2p",
      act:       "req",
      package:   "ast_intraip_pkg",
      partition: "secondary",
      desc:      "Secondary-to-Primary partition communication",
    },
    { struct:    "p2s",
      type:      "uni",
      name:      "intraip_p2s",
      act:       "rcv",
      package:   "ast_intraip_pkg",
      partition: "secondary",
      desc:      "Primary-to-Secondary partition communication",
    },
  ],
  regwidth: "32",
  registers: [
    { name: "REGA0",
      desc: "AST Register 0 for OTP/ROM Write Testing",
      swaccess: "ro",
      hwaccess: "hro",
      tags: [ // don't write random data to any of the AST registers
              "excl:CsrAllTests:CsrExclAll" ],
      fields: [
        { bits: "31:0",
          name: "reg32",
          desc: "32-bit Register",
          resval: "0x00",
        },
      ],
    }, //----------------------------------------------------------------------
    { name: "REGA1",
      desc: "AST 1 Register for OTP/ROM Write Testing",
      swaccess: "ro",
      hwaccess: "hro",
      tags: [ // don't write random data to any of the AST registers
              "excl:CsrAllTests:CsrExclAll" ],
      fields: [
        { bits: "31:0",
          name: "reg32",
          desc: "32-bit Register",
          resval: "0x01",
        },
      ],
    }, //----------------------------------------------------------------------
    { name: "REGA2",
      desc: "AST 2 Register for OTP/ROM Write Testing",
      swaccess: "rw",
      hwaccess: "hro",
      tags: [ // don't write random data to any of the AST registers
              "excl:CsrAllTests:CsrExclWrite" ],
      fields: [
        { bits: "31:0",
          name: "reg32",
          desc: "32-bit Register",
          resval: "0x02",
        },
      ],
    }, //----------------------------------------------------------------------
    { name: "REGA3",
      desc: "AST 3 Register for OTP/ROM Write Testing",
      swaccess: "rw",
      hwaccess: "hro",
      tags: [ // don't write random data to any of the AST registers
              "excl:CsrAllTests:CsrExclWrite" ],
      fields: [
        { bits: "31:0",
          name: "reg32",
          desc: "32-bit Register",
          resval: "0x03",
        },
      ],
    }, //----------------------------------------------------------------------
    { name: "REGA4",
      desc: "AST 4 Register for OTP/ROM Write Testing",
      swaccess: "rw",
      hwaccess: "hro",
      tags: [ // don't write random data to any of the AST registers
              "excl:CsrAllTests:CsrExclWrite" ],
      fields: [
        { bits: "31:0",
          name: "reg32",
          desc: "32-bit Register",
          resval: "0x04",
        },
      ],
    }, //----------------------------------------------------------------------
    { name: "REGA5",
      desc: "AST 5 Register for OTP/ROM Write Testing",
      swaccess: "rw",
      hwaccess: "hro",
      tags: [ // don't write random data to any of the AST registers
              "excl:CsrAllTests:CsrExclWrite" ],
      fields: [
        { bits: "31:0",
          name: "reg32",
          desc: "32-bit Register",
          resval: "0x05",
        },
      ],
    }, //----------------------------------------------------------------------
    { name: "REGA6",
      desc: "AST 6 Register for OTP/ROM Write Testing",
      swaccess: "rw",
      hwaccess: "hro",
      tags: [ // don't write random data to any of the AST registers
              "excl:CsrAllTests:CsrExclWrite" ],
      fields: [
        { bits: "31:0",
          name: "reg32",
          desc: "32-bit Register",
          resval: "0x06",
        },
      ],
    }, //----------------------------------------------------------------------
    { name: "REGA7",
      desc: "AST 7 Register for OTP/ROM Write Testing",
      swaccess: "rw",
      hwaccess: "hro",
      tags: [ // don't write random data to any of the AST registers
              "excl:CsrAllTests:CsrExclWrite" ],
      fields: [
        { bits: "31:0",
          name: "reg32",
          desc: "32-bit Register",
          resval: "0x07",
        },
      ],
    }, //----------------------------------------------------------------------
    { name: "REGA8",
      desc: "AST 8 Register for OTP/ROM Write Testing",
      swaccess: "rw",
      hwaccess: "hro",
      tags: [ // don't write random data to any of the AST registers
              "excl:CsrAllTests:CsrExclWrite" ],
      fields: [
        { bits: "31:0",
          name: "reg32",
          desc: "32-bit Register",
          resval: "0x08",
        },
      ],
    }, //----------------------------------------------------------------------
    { name: "REGA9",
      desc: "AST 9 Register for OTP/ROM Write Testing",
      swaccess: "rw",
      hwaccess: "hro",
      tags: [ // don't write random data to any of the AST registers
              "excl:CsrAllTests:CsrExclWrite" ],
      fields: [
        { bits: "31:0",
          name: "reg32",
          desc: "32-bit Register",
          resval: "0x09",
        },
      ],
    }, //----------------------------------------------------------------------
    { name: "REGA10",
      desc: "AST 10 Register for OTP/ROM Write Testing",
      swaccess: "rw",
      hwaccess: "hro",
      tags: [ // don't write random data to any of the AST registers
              "excl:CsrAllTests:CsrExclWrite" ],
      fields: [
        { bits: "31:0",
          name: "reg32",
          desc: "32-bit Register",
          resval: "0x0A",
        },
      ],
    }, //----------------------------------------------------------------------
    { name: "REGA11",
      desc: "AST 11 Register for OTP/ROM Write Testing",
      swaccess: "rw",
      hwaccess: "hro",
      tags: [ // don't write random data to any of the AST registers
              "excl:CsrAllTests:CsrExclWrite" ],
      fields: [
        { bits: "31:0",
          name: "reg32",
          desc: "32-bit Register",
          resval: "0x0B",
        },
      ],
    }, //----------------------------------------------------------------------
    { name: "REGA12",
      desc: "AST 13 Register for OTP/ROM Write Testing",
      swaccess: "rw",
      hwaccess: "hro",
      tags: [ // don't write random data to any of the AST registers
              "excl:CsrAllTests:CsrExclWrite" ],
      fields: [
        { bits: "31:0",
          name: "reg32",
          desc: "32-bit Register",
          resval: "0x0C",
        },
      ],
    }, //----------------------------------------------------------------------
    { name: "REGA13",
      desc: "AST 13 Register for OTP/ROM Write Testing",
      swaccess: "rw",
      hwaccess: "hro",
      tags: [ // don't write random data to any of the AST registers
              "excl:CsrAllTests:CsrExclWrite" ],
      fields: [
        { bits: "31:0",
          name: "reg32",
          desc: "32-bit Register",
          resval: "0x0D",
        },
      ],
    }, //----------------------------------------------------------------------
    { name: "REGA14",
      desc: "AST 14 Register for OTP/ROM Write Testing",
      swaccess: "rw",
      hwaccess: "hro",
      tags: [ // don't write random data to any of the AST registers
              "excl:CsrAllTests:CsrExclWrite" ],
      fields: [
        { bits: "31:0",
          name: "reg32",
          desc: "32-bit Register",
          resval: "0x0E",
        },
      ],
    }, //----------------------------------------------------------------------
    { name: "REGA15",
      desc: "AST 15 Register for OTP/ROM Write Testing",
      swaccess: "rw",
      hwaccess: "hro",
      tags: [ // don't write random data to any of the AST registers
              "excl:CsrAllTests:CsrExclWrite" ],
      fields: [
        { bits: "31:0",
          name: "reg32",
          desc: "32-bit Register",
          resval: "0x0F",
        },
      ],
    }, //----------------------------------------------------------------------
    { name: "REGA16",
      desc: "AST 16 Register for OTP/ROM Write Testing",
      swaccess: "rw",
      hwaccess: "hro",
      tags: [ // don't write random data to any of the AST registers
              "excl:CsrAllTests:CsrExclWrite" ],
      fields: [
        { bits: "31:0",
          name: "reg32",
          desc: "32-bit Register",
          resval: "0x10",
        },
      ],
    }, //----------------------------------------------------------------------
    { name: "REGA17",
      desc: "AST 17 Register for OTP/ROM Write Testing",
      swaccess: "rw",
      hwaccess: "hro",
      tags: [ // don't write random data to any of the AST registers
              "excl:CsrAllTests:CsrExclWrite" ],
      fields: [
        { bits: "31:0",
          name: "reg32",
          desc: "32-bit Register",
          resval: "0x11",
        },
      ],
    }, //----------------------------------------------------------------------
    { name: "REGA18",
      desc: "AST 18 Register for OTP/ROM Write Testing",
      swaccess: "rw",
      hwaccess: "hro",
      tags: [ // don't write random data to any of the AST registers
              "excl:CsrAllTests:CsrExclWrite" ],
      fields: [
        { bits: "31:0",
          name: "reg32",
          desc: "32-bit Register",
          resval: "0x12",
        },
      ],
    }, //----------------------------------------------------------------------
    { name: "REGA19",
      desc: "AST 19 Register for OTP/ROM Write Testing",
      swaccess: "rw",
      hwaccess: "hro",
      tags: [ // don't write random data to any of the AST registers
              "excl:CsrAllTests:CsrExclWrite" ],
      fields: [
        { bits: "31:0",
          name: "reg32",
          desc: "32-bit Register",
          resval: "0x13",
        },
      ],
    }, //----------------------------------------------------------------------
    { name: "REGA20",
      desc: "AST 20 Register for OTP/ROM Write Testing",
      swaccess: "rw",
      hwaccess: "hro",
      tags: [ // don't write random data to any of the AST registers
              "excl:CsrAllTests:CsrExclWrite" ],
      fields: [
        { bits: "31:0",
          name: "reg32",
          desc: "32-bit Register",
          resval: "0x14",
        },
      ],
    }, //----------------------------------------------------------------------
    { name: "REGA21",
      desc: "AST 21 Register for OTP/ROM Write Testing",
      swaccess: "rw",
      hwaccess: "hro",
      tags: [ // don't write random data to any of the AST registers
              "excl:CsrAllTests:CsrExclWrite" ],
      fields: [
        { bits: "31:0",
          name: "reg32",
          desc: "32-bit Register",
          resval: "0x15",
        },
      ],
    }, //----------------------------------------------------------------------
    { name: "REGA22",
      desc: "AST 22 Register for OTP/ROM Write Testing",
      swaccess: "rw",
      hwaccess: "hro",
      tags: [ // don't write random data to any of the AST registers
              "excl:CsrAllTests:CsrExclWrite" ],
      fields: [
        { bits: "31:0",
          name: "reg32",
          desc: "32-bit Register",
          resval: "0x16",
        },
      ],
    }, //----------------------------------------------------------------------
    { name: "REGA23",
      desc: "AST 23 Register for OTP/ROM Write Testing",
      swaccess: "rw",
      hwaccess: "hro",
      tags: [ // don't write random data to any of the AST registers
              "excl:CsrAllTests:CsrExclWrite" ],
      fields: [
        { bits: "31:0",
          name: "reg32",
          desc: "32-bit Register",
          resval: "0x17",
        },
      ],
    }, //----------------------------------------------------------------------
    { name: "REGA24",
      desc: "AST 24 Register for OTP/ROM Write Testing",
      swaccess: "rw",
      hwaccess: "hro",
      tags: [ // don't write random data to any of the AST registers
              "excl:CsrAllTests:CsrExclWrite" ],
      fields: [
        { bits: "31:0",
          name: "reg32",
          desc: "32-bit Register",
          resval: "0x18",
        },
      ],
    }, //----------------------------------------------------------------------
    { name: "REGA25",
      desc: "AST 25 Register for OTP/ROM Write Testing",
      swaccess: "rw",
      hwaccess: "hro",
      tags: [ // don't write random data to any of the AST registers
              "excl:CsrAllTests:CsrExclWrite" ],
      fields: [
        { bits: "31:0",
          name: "reg32",
          desc: "32-bit Register",
          resval: "0x19",
        },
      ],
    }, //----------------------------------------------------------------------
    { name: "REGA26",
      desc: "AST 26 Register for OTP/ROM Write Testing",
      swaccess: "rw",
      hwaccess: "hro",
      tags: [ // don't write random data to any of the AST registers
              "excl:CsrAllTests:CsrExclWrite" ],
      fields: [
        { bits: "31:0",
          name: "reg32",
          desc: "32-bit Register",
          resval: "0x1A",
        },
      ],
    }, //----------------------------------------------------------------------
    { name: "REGA27",
      desc: "AST 27 Register for OTP/ROM Write Testing",
      swaccess: "rw",
      hwaccess: "hro",
      tags: [ // don't write random data to any of the AST registers
              "excl:CsrAllTests:CsrExclWrite" ],
      fields: [
        { bits: "31:0",
          name: "reg32",
          desc: "32-bit Register",
          resval: "0x1B",
        },
      ],
    }, //----------------------------------------------------------------------
    { name: "REGA28",
      desc: "AST 28 Register for OTP/ROM Write Testing",
      swaccess: "ro",
      hwaccess: "hro",
      tags: [ // don't write random data to any of the AST registers
              "excl:CsrAllTests:CsrExclWrite" ],
      fields: [
        { bits: "31:0",
          name: "reg32",
          desc: "32-bit Register",
          resval: "0x1C",
        },
      ],
    }, //----------------------------------------------------------------------
    { name: "REGA29",
      desc: "AST 29 Register for OTP/ROM Write Testing",
      swaccess: "rw",
      hwaccess: "hro",
      tags: [ // don't write random data to any of the AST registers
              "excl:CsrAllTests:CsrExclWrite" ],
      fields: [
        { bits: "31:0",
          name: "reg32",
          desc: "32-bit Register",
          resval: "0x1D",
        },
      ],
    }, //----------------------------------------------------------------------
    { name: "REGA30",
      desc: "AST 30 Register for OTP/ROM Write Testing",
      swaccess: "rw",
      hwaccess: "hro",
      tags: [ // don't write random data to any of the AST registers
              "excl:CsrAllTests:CsrExclWrite" ],
      fields: [
        { bits: "31:0",
          name: "reg32",
          desc: "32-bit Register",
          resval: "0x1E",
        },
      ],
    }, //----------------------------------------------------------------------
    { name: "REGA31",
      desc: "AST 31 Register for OTP/ROM Write Testing",
      swaccess: "rw",
      hwaccess: "hro",
      tags: [ // don't write random data to any of the AST registers
              "excl:CsrAllTests:CsrExclWrite" ],
      fields: [
        { bits: "31:0",
          name: "reg32",
          desc: "32-bit Register",
          resval: "0x1F",
        },
      ],
    }, //----------------------------------------------------------------------
    { name: "REGA32",
      desc: "AST 32 Register for OTP/ROM Write Testing",
      swaccess: "rw",
      hwaccess: "hro",
      tags: [ // don't write random data to any of the AST registers
              "excl:CsrAllTests:CsrExclWrite" ],
      fields: [
        { bits: "31:0",
          name: "reg32",
          desc: "32-bit Register",
          resval: "0x20",
        },
      ],
    }, //----------------------------------------------------------------------
    { name: "REGA33",
      desc: "AST 33 Register for OTP/ROM Write Testing",
      swaccess: "rw",
      hwaccess: "hro",
      tags: [ // don't write random data to any of the AST registers
              "excl:CsrAllTests:CsrExclWrite" ],
      fields: [
        { bits: "31:0",
          name: "reg32",
          desc: "32-bit Register",
          resval: "0x21",
        },
      ],
    }, //----------------------------------------------------------------------
    { name: "REGA34",
      desc: "AST 34 Register for OTP/ROM Write Testing",
      swaccess: "rw",
      hwaccess: "hro",
      tags: [ // don't write random data to any of the AST registers
              "excl:CsrAllTests:CsrExclWrite" ],
      fields: [
        { bits: "31:0",
          name: "reg32",
          desc: "32-bit Register",
          resval: "0x22",
        },
      ],
    }, //----------------------------------------------------------------------
    { name: "REGA35",
      desc: "AST 35 Register for OTP/ROM Write Testing",
      swaccess: "rw",
      hwaccess: "hro",
      tags: [ // don't write random data to any of the AST registers
              "excl:CsrAllTests:CsrExclWrite" ],
      fields: [
        { bits: "31:0",
          name: "reg32",
          desc: "32-bit Register",
          resval: "0x23",
        },
      ],
    }, //----------------------------------------------------------------------
    { name: "REGA36",
      desc: "AST 36 Register for OTP/ROM Write Testing",
      swaccess: "rw",
      hwaccess: "hro",
      tags: [ // don't write random data to any of the AST registers
              "excl:CsrAllTests:CsrExclWrite" ],
      fields: [
        { bits: "31:0",
          name: "reg32",
          desc: "32-bit Register",
          resval: "0x24",
        },
      ],
    }, //----------------------------------------------------------------------
    { name: "REGA37",
      desc: "AST 37 Register for OTP/ROM Write Testing",
      swaccess: "rw",
      hwaccess: "hro",
      tags: [ // don't write random data to any of the AST registers
              "excl:CsrAllTests:CsrExclWrite" ],
      fields: [
        { bits: "31:0",
          name: "reg32",
          desc: "32-bit Register",
          resval: "0x25",
        },
      ],
    }, //----------------------------------------------------------------------
    { name: "REGA38",
      desc: "AST 38 Register for OTP/ROM Write Testing",
      swaccess: "rw",
      hwaccess: "hro",
      tags: [ // don't write random data to any of the AST registers
              "excl:CsrAllTests:CsrExclWrite" ],
      fields: [
        { bits: "31:0",
          name: "reg32",
          desc: "32-bit Register",
          resval: "0x26",
        },
      ],
    }, //----------------------------------------------------------------------
    { name: "REGA39",
      desc: "AST 39 Register for OTP/ROM Write Testing",
      swaccess: "rw",
      hwaccess: "hro",
      tags: [ // don't write random data to any of the AST registers
              "excl:CsrAllTests:CsrExclWrite" ],
      fields: [
        { bits: "31:0",
          name: "reg32",
          desc: "32-bit Register",
          resval: "0x27",
        },
      ],
    }, //----------------------------------------------------------------------
    { name: "REGA40",
      desc: "AST 40 Register for OTP/ROM Write Testing",
      swaccess: "rw",
      hwaccess: "hro",
      tags: [ // don't write random data to any of the AST registers
              "excl:CsrAllTests:CsrExclWrite" ],
      fields: [
        { bits: "31:0",
          name: "reg32",
          desc: "32-bit Register",
          resval: "0x28",
        },
      ],
    }, //----------------------------------------------------------------------
    { name: "REGA41",
      desc: "AST 41 Register for OTP/ROM Write Testing",
      swaccess: "rw",
      hwaccess: "hro",
      tags: [ // don't write random data to any of the AST registers
              "excl:CsrAllTests:CsrExclWrite" ],
      fields: [
        { bits: "31:0",
          name: "reg32",
          desc: "32-bit Register",
          resval: "0x29",
        },
      ],
    }, //----------------------------------------------------------------------
    { name: "REGA42",
      desc: "AST 42 Register for OTP/ROM Write Testing",
      swaccess: "rw",
      hwaccess: "hro",
      tags: [ // don't write random data to any of the AST registers
              "excl:CsrAllTests:CsrExclWrite" ],
      fields: [
        { bits: "31:0",
          name: "reg32",
          desc: "32-bit Register",
          resval: "0x2a",
        },
      ],
    }, //----------------------------------------------------------------------
    { name: "REGA43",
      desc: "AST 43 Register for OTP/ROM Write Testing",
      swaccess: "rw",
      hwaccess: "hro",
      tags: [ // don't write random data to any of the AST registers
              "excl:CsrAllTests:CsrExclWrite" ],
      fields: [
        { bits: "31:0",
          name: "reg32",
          desc: "32-bit Register",
          resval: "0x2b",
        },
      ],
    }, //----------------------------------------------------------------------
    { name: "REGA44",
      desc: "AST 44 Register for OTP/ROM Write Testing",
      swaccess: "rw",
      hwaccess: "hro",
      tags: [ // don't write random data to any of the AST registers
              "excl:CsrAllTests:CsrExclWrite" ],
      fields: [
        { bits: "31:0",
          name: "reg32",
          desc: "32-bit Register",
          resval: "0x2c",
        },
      ],
    }, //----------------------------------------------------------------------
    { name: "REGA45",
      desc: "AST 45 Register for OTP/ROM Write Testing",
      swaccess: "rw",
      hwaccess: "hro",
      tags: [ // don't write random data to any of the AST registers
              "excl:CsrAllTests:CsrExclWrite" ],
      fields: [
        { bits: "31:0",
          name: "reg32",
          desc: "32-bit Register",
          resval: "0x2d",
        },
      ],
    }, //----------------------------------------------------------------------
    { name: "REGA46",
      desc: "AST 46 Register for OTP/ROM Write Testing",
      swaccess: "rw",
      hwaccess: "hro",
      tags: [ // don't write random data to any of the AST registers
              "excl:CsrAllTests:CsrExclWrite" ],
      fields: [
        { bits: "31:0",
          name: "reg32",
          desc: "32-bit Register",
          resval: "0x2e",
        },
      ],
    }, //----------------------------------------------------------------------
    { name: "REGA47",
      desc: "AST 47 Register for OTP/ROM Write Testing",
      swaccess: "rw",
      hwaccess: "hro",
      tags: [ // don't write random data to any of the AST registers
              "excl:CsrAllTests:CsrExclWrite" ],
      fields: [
        { bits: "31:0",
          name: "reg32",
          desc: "32-bit Register",
          resval: "0x2f",
        },
      ],
    }, //----------------------------------------------------------------------
    { name: "REGA48",
      desc: "AST 48 Register for OTP/ROM Write Testing",
      swaccess: "rw",
      hwaccess: "hro",
      tags: [ // don't write random data to any of the AST registers
              "excl:CsrAllTests:CsrExclWrite" ],
      fields: [
        { bits: "31:0",
          name: "reg32",
          desc: "32-bit Register",
          resval: "0x30",
        },
      ],
    }, //----------------------------------------------------------------------
    { name: "REGA49",
      desc: "AST 49 Register for OTP/ROM Write Testing",
      swaccess: "rw",
      hwaccess: "hro",
      tags: [ // don't write random data to any of the AST registers
              "excl:CsrAllTests:CsrExclWrite" ],
      fields: [
        { bits: "31:0",
          name: "reg32",
          desc: "32-bit Register",
          resval: "0x31",
        },
      ],
    }, //----------------------------------------------------------------------
    { name: "REGA50",
      desc: "AST 50 Register for OTP/ROM Write Testing",
      swaccess: "rw",
      hwaccess: "hro",
      tags: [ // don't write random data to any of the AST registers
              "excl:CsrAllTests:CsrExclWrite" ],
      fields: [
        { bits: "31:0",
          name: "reg32",
          desc: "32-bit Register",
          resval: "0x32",
        },
      ],
    }, //----------------------------------------------------------------------
    { name: "REGA51",
      desc: "AST 51 Register for OTP/ROM Write Testing",
      swaccess: "rw",
      hwaccess: "hro",
      tags: [ // don't write random data to any of the AST registers
              "excl:CsrAllTests:CsrExclWrite" ],
      fields: [
        { bits: "31:0",
          name: "reg32",
          desc: "32-bit Register",
          resval: "0x33",
        },
      ],
    }, //----------------------------------------------------------------------
    { name: "REGA52",
      desc: "AST 52 Register for OTP/ROM Write Testing",
      swaccess: "rw",
      hwaccess: "hro",
      tags: [ // don't write random data to any of the AST registers
              "excl:CsrAllTests:CsrExclWrite" ],
      fields: [
        { bits: "31:0",
          name: "reg32",
          desc: "32-bit Register",
          resval: "0x34",
        },
      ],
    }, //----------------------------------------------------------------------
    { name: "REGAL",
      desc: "AST Last Register for OTP/ROM Write Testing",
      swaccess: "wo",
      hwaccess: "hrw",
      hwext:    "true",
      hwqe:     "true",
      tags: [ // don't write random data to any of the AST registers
              "excl:CsrAllTests:CsrExclAll" ],
      fields: [
        { bits: "31:0",
          name: "reg32",
          desc: "32-bit Register",
          resval: "0x35",
        },
      ],
    }, //----------------------------------------------------------------------
    ///////////////////////////////////////////////////////////////////////////
    { skipto: "0x200" }
    ///////////////////////////////////////////////////////////////////////////
    { multireg:
      {
        name: "REGB",
        desc: "AST Registers Array-B to set address space size",
        count: "NumRegsB",
        cname: "REGB",
        swaccess: "rw",
        hwaccess: "hro",
        tags: [ // don't write random data to any of the AST registers
                "excl:CsrAllTests:CsrExclAll" ],
        fields: [
          { bits: "31:0",
            name: "reg32",
            desc: "32-bit Register",
            resval: "0",
          },
        ],
      },
    }, //----------------------------------------------------------------------
  ],
}
