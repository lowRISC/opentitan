// Copyright lowRISC contributors.
// Licensed under the Apache License, Version 2.0, see LICENSE for details.
// SPDX-License-Identifier: Apache-2.0
//#############################################################################
// *Name: ast
// *Module Description: Analog Sensors Top Registers
//#############################################################################
{ name: "ast",
  clocking: [
    { clock: "clk_ast_tlul_i",  reset: "rst_ast_tlul_ni", primary: true },
    { clock: "clk_ast_adc_i",   reset: "rst_ast_adc_ni"},
    { clock: "clk_ast_alert_i", reset: "rst_ast_alert_ni"},
    { clock: "clk_ast_es_i",    reset: "rst_ast_es_ni"},
    { clock: "clk_ast_rng_i",   reset: "rst_ast_rng_ni"},
    { clock: "clk_ast_usb_i",   reset: "rst_ast_usb_ni"},
  ],
  bus_interfaces: [
    { protocol: "tlul",
      direction: "device"
    }
  ],
  no_auto_alert_regs: "True",
  param_list: [
    { name:    "NumRegsA",
      type:    "int",
      default: "31",
      desc: "Number of registers in the Array-A",
      local:   "true",
    },
    { name:    "NumRegsB",
      type:    "int",
      default: "5",
      desc: "Number of registers in the Array-B",
      local:   "true",
    },
  ],
  regwidth: "32",
  registers: [
    { multireg:
      {
        name: "REGA",
        desc: "AST Registers Array-A for OTP/ROM Write Testing",
        count: "NumRegsA",
        cname: "REGA",
        swaccess: "rw",
        hwaccess: "hro",
        fields: [
          { bits: "31:0",
            name: "reg32",
            desc: "32-bit Register",
            resval: "0",
          },
        ],
      },
    }, //----------------------------------------------------------------------
    { name: "REGAL",
      desc: "AST Array-A Last Register for OTP/ROM Write Testing",
      swaccess: "rw",
      hwaccess: "hrw",
      hwext:    "true",
      hwqe:     "true",
      fields: [
        { bits: "31:0",
          name: "reg32",
          desc: "32-bit Register",
          resval: "0",
        },
      ],
    }, //----------------------------------------------------------------------

    ///////////////////////////////////////////////////////////////////////////
    { skipto: "0x200" }
    ///////////////////////////////////////////////////////////////////////////

    { multireg:
      {
        name: "REGB",
        desc: "AST Registers Array-B to set address space size",
        count: "NumRegsB",
        cname: "REGB",
        swaccess: "rw",
        hwaccess: "hro",
        fields: [
          { bits: "31:0",
            name: "reg32",
            desc: "32-bit Register",
            resval: "0",
          },
        ],
      },
    }, //----------------------------------------------------------------------
  ],
}
