// Copyright lowRISC contributors.
// Licensed under the Apache License, Version 2.0, see LICENSE for details.
// SPDX-License-Identifier: Apache-2.0
{
  instance_name: top_earlgrey_clkmgr
  param_values:
  {
    cfg:
    {
      name: earlgrey
      type: top
      rnd_cnst_seed: 4881560218908238235
      datawidth: "32"
      power:
      {
        domains:
        [
          Aon
          "0"
        ]
        default: "0"
      }
      clocks:
      {
        hier_paths:
        {
          top: clkmgr_aon_clocks.
          ext: ""
        }
        srcs:
        [
          {
            name: main
            aon: no
            freq: "100000000"
            derived: no
            params: {}
          }
          {
            name: io
            aon: no
            freq: "96000000"
            derived: no
            params: {}
          }
          {
            name: usb
            aon: no
            freq: "48000000"
            derived: no
            params: {}
          }
          {
            name: aon
            aon: yes
            freq: "200000"
            derived: no
            params: {}
          }
        ]
        derived_srcs:
        [
          {
            name: io_div2
            aon: no
            div: 2
            src: io
            freq: "48000000"
          }
          {
            name: io_div4
            aon: no
            div: 4
            src: io
            freq: "24000000"
          }
        ]
        groups:
        [
          {
            name: powerup
            src: top
            sw_cg: no
            unique: no
            clocks:
            {
              clk_io_div4_powerup: io_div4
              clk_aon_powerup: aon
              clk_main_powerup: main
              clk_io_powerup: io
              clk_usb_powerup: usb
              clk_io_div2_powerup: io_div2
            }
          }
          {
            name: trans
            src: top
            sw_cg: hint
            unique: yes
            clocks:
            {
              clk_main_aes: main
              clk_main_hmac: main
              clk_main_kmac: main
              clk_main_otbn: main
            }
          }
          {
            name: infra
            src: top
            sw_cg: no
            unique: no
            clocks:
            {
              clk_main_infra: main
              clk_io_div4_infra: io_div4
            }
          }
          {
            name: secure
            src: top
            sw_cg: no
            unique: no
            clocks:
            {
              clk_io_div4_secure: io_div4
              clk_main_secure: main
            }
          }
          {
            name: peri
            src: top
            sw_cg: yes
            unique: no
            clocks:
            {
              clk_io_div4_peri: io_div4
              clk_io_div2_peri: io_div2
              clk_aon_peri: aon
              clk_usb_peri: usb
            }
          }
          {
            name: timers
            src: top
            sw_cg: no
            unique: no
            clocks:
            {
              clk_io_div4_timers: io_div4
              clk_main_timers: main
              clk_aon_timers: aon
            }
          }
          {
            name: proc
            src: no
            sw_cg: no
            unique: no
            clocks:
            {
              clk_proc_main: main
            }
          }
        ]
      }
      resets:
      {
        hier_paths:
        {
          top: rstmgr_aon_resets.
          ext: ""
        }
        nodes:
        [
          {
            name: rst_ni
            gen: false
            type: ext
          }
          {
            name: por_aon
            gen: false
            type: top
            domains:
            [
              Aon
            ]
            clk: aon
          }
          {
            name: lc_src
            gen: false
            type: int
            domains:
            [
              Aon
              "0"
            ]
            clk: io_div4
          }
          {
            name: sys_src
            gen: false
            type: int
            domains:
            [
              Aon
              "0"
            ]
            clk: io_div4
          }
          {
            name: por
            gen: true
            type: top
            domains:
            [
              Aon
            ]
            parent: por_aon
            clk: main
          }
          {
            name: por_io
            gen: true
            type: top
            domains:
            [
              Aon
            ]
            parent: por_aon
            clk: io
          }
          {
            name: por_io_div2
            gen: true
            type: top
            domains:
            [
              Aon
            ]
            parent: por_aon
            clk: io_div2
          }
          {
            name: por_io_div4
            gen: true
            type: top
            domains:
            [
              Aon
            ]
            parent: por_aon
            clk: io_div4
          }
          {
            name: por_usb
            gen: true
            type: top
            domains:
            [
              Aon
            ]
            parent: por_aon
            clk: usb
          }
          {
            name: lc
            gen: true
            type: top
            domains:
            [
              "0"
            ]
            parent: lc_src
            clk: main
          }
          {
            name: lc_io_div4
            gen: true
            type: top
            domains:
            [
              "0"
            ]
            parent: lc_src
            clk: io_div4
          }
          {
            name: sys
            gen: true
            type: top
            domains:
            [
              "0"
            ]
            parent: sys_src
            clk: main
          }
          {
            name: sys_io_div4
            gen: true
            type: top
            domains:
            [
              Aon
              "0"
            ]
            parent: sys_src
            clk: io_div4
          }
          {
            name: sys_aon
            gen: true
            type: top
            domains:
            [
              Aon
              "0"
            ]
            parent: sys_src
            clk: aon
          }
          {
            name: spi_device
            gen: true
            type: top
            domains:
            [
              "0"
            ]
            parent: sys_src
            clk: io_div2
            sw: 1
          }
          {
            name: spi_host0
            gen: true
            type: top
            domains:
            [
              "0"
            ]
            parent: sys_src
            clk: io_div2
            sw: 1
          }
          {
            name: spi_host1
            gen: true
            type: top
            domains:
            [
              "0"
            ]
            parent: sys_src
            clk: io_div2
            sw: 1
          }
          {
            name: usb
            gen: true
            type: top
            domains:
            [
              "0"
            ]
            parent: sys_src
            clk: usb
            sw: 1
          }
          {
            name: i2c0
            gen: true
            type: top
            domains:
            [
              "0"
            ]
            parent: sys_src
            clk: io_div2
            sw: 1
          }
          {
            name: i2c1
            gen: true
            type: top
            domains:
            [
              "0"
            ]
            parent: sys_src
            clk: io_div2
            sw: 1
          }
          {
            name: i2c2
            gen: true
            type: top
            domains:
            [
              "0"
            ]
            parent: sys_src
            clk: io_div2
            sw: 1
          }
        ]
      }
      num_cores: "1"
      host:
      [
        {
          name: rv_core_ibex
          type: rv_core_ibex
          inter_signal_list:
          [
            {
              struct: esc_tx
              type: uni
              name: esc_nmi_tx
              act: rcv
              package: prim_esc_pkg
            }
            {
              struct: esc_rx
              type: uni
              name: esc_nmi_rx
              act: req
              package: prim_esc_pkg
            }
            {
              struct: crash_dump
              type: uni
              name: crash_dump
              act: req
              package: ibex_pkg
            }
            {
              struct: lc_tx_t
              type: uni
              name: lc_cpu_en
              act: rcv
              package: lc_ctrl_pkg
            }
            {
              struct: ram_1p_cfg_t
              type: uni
              name: ram_cfg
              act: rcv
              package: prim_ram_1p_pkg
            }
          ]
        }
        {
          name: rv_dm
          type: rv_dm
          inter_signal_list:
          [
            {
              struct: jtag
              type: req_rsp
              name: jtag
              act: rsp
              package: jtag_pkg
            }
          ]
        }
      ]
      module:
      [
        {
          name: uart0
          type: uart
          clock_srcs:
          {
            clk_i: io_div4
          }
          reset_connections:
          {
            rst_ni: sys_io_div4
          }
          base_addr: 0x40000000
          clock_group: secure
          clock_connections:
          {
            clk_i: clkmgr_aon_clocks.clk_io_div4_secure
          }
        }
        {
          name: uart1
          type: uart
          clock_srcs:
          {
            clk_i: io_div4
          }
          reset_connections:
          {
            rst_ni: sys_io_div4
          }
          base_addr: 0x40010000
          clock_group: secure
          clock_connections:
          {
            clk_i: clkmgr_aon_clocks.clk_io_div4_secure
          }
        }
        {
          name: uart2
          type: uart
          clock_srcs:
          {
            clk_i: io_div4
          }
          reset_connections:
          {
            rst_ni: sys_io_div4
          }
          base_addr: 0x40020000
          clock_group: secure
          clock_connections:
          {
            clk_i: clkmgr_aon_clocks.clk_io_div4_secure
          }
        }
        {
          name: uart3
          type: uart
          clock_srcs:
          {
            clk_i: io_div4
          }
          reset_connections:
          {
            rst_ni: sys_io_div4
          }
          base_addr: 0x40030000
          clock_group: secure
          clock_connections:
          {
            clk_i: clkmgr_aon_clocks.clk_io_div4_secure
          }
        }
        {
          name: gpio
          type: gpio
          clock_srcs:
          {
            clk_i: io_div4
          }
          clock_group: peri
          reset_connections:
          {
            rst_ni: sys_io_div4
          }
          base_addr: 0x40040000
          clock_connections:
          {
            clk_i: clkmgr_aon_clocks.clk_io_div4_peri
          }
        }
        {
          name: spi_device
          type: spi_device
          clock_srcs:
          {
            clk_i: io_div4
            scan_clk_i: io_div2
          }
          clock_group: peri
          reset_connections:
          {
            rst_ni: spi_device
          }
          base_addr: 0x40050000
          clock_connections:
          {
            clk_i: clkmgr_aon_clocks.clk_io_div4_peri
            scan_clk_i: clkmgr_aon_clocks.clk_io_div2_peri
          }
        }
        {
          name: spi_host0
          type: spi_host
          clock_srcs:
          {
            clk_i: io_div4
            clk_core_i: io_div2
          }
          clock_group: peri
          reset_connections:
          {
            rst_ni: spi_host0
            rst_core_ni: spi_host0
          }
          base_addr: 0x40060000
          clock_connections:
          {
            clk_i: clkmgr_aon_clocks.clk_io_div4_peri
            clk_core_i: clkmgr_aon_clocks.clk_io_div2_peri
          }
        }
        {
          name: spi_host1
          type: spi_host
          clock_srcs:
          {
            clk_i: io_div4
            clk_core_i: io_div2
          }
          clock_group: peri
          reset_connections:
          {
            rst_ni: spi_host1
            rst_core_ni: spi_host1
          }
          base_addr: 0x40070000
          clock_connections:
          {
            clk_i: clkmgr_aon_clocks.clk_io_div4_peri
            clk_core_i: clkmgr_aon_clocks.clk_io_div2_peri
          }
        }
        {
          name: i2c0
          type: i2c
          clock_srcs:
          {
            clk_i: io_div4
          }
          clock_group: peri
          reset_connections:
          {
            rst_ni: i2c0
          }
          base_addr: 0x40080000
          clock_connections:
          {
            clk_i: clkmgr_aon_clocks.clk_io_div4_peri
          }
        }
        {
          name: i2c1
          type: i2c
          clock_srcs:
          {
            clk_i: io_div4
          }
          clock_group: peri
          reset_connections:
          {
            rst_ni: i2c1
          }
          base_addr: 0x40090000
          clock_connections:
          {
            clk_i: clkmgr_aon_clocks.clk_io_div4_peri
          }
        }
        {
          name: i2c2
          type: i2c
          clock_srcs:
          {
            clk_i: io_div4
          }
          clock_group: peri
          reset_connections:
          {
            rst_ni: i2c2
          }
          base_addr: 0x400A0000
          clock_connections:
          {
            clk_i: clkmgr_aon_clocks.clk_io_div4_peri
          }
        }
        {
          name: pattgen
          type: pattgen
          clock_srcs:
          {
            clk_i: io_div4
          }
          clock_group: peri
          reset_connections:
          {
            rst_ni: sys_io_div4
          }
          base_addr: 0x400E0000
          clock_connections:
          {
            clk_i: clkmgr_aon_clocks.clk_io_div4_peri
          }
        }
        {
          name: rv_timer
          type: rv_timer
          clock_srcs:
          {
            clk_i: io_div4
          }
          clock_group: timers
          reset_connections:
          {
            rst_ni: sys_io_div4
          }
          base_addr: 0x40100000
          clock_connections:
          {
            clk_i: clkmgr_aon_clocks.clk_io_div4_timers
          }
        }
        {
          name: usbdev
          type: usbdev
          clock_srcs:
          {
            clk_i: io_div4
            clk_aon_i: aon
            clk_usb_48mhz_i: usb
          }
          clock_group: peri
          clock_reset_export:
          [
            ast
          ]
          reset_connections:
          {
            rst_ni: sys_io_div4
            rst_aon_ni: sys_aon
            rst_usb_48mhz_ni: usb
          }
          base_addr: 0x40110000
          clock_connections:
          {
            clk_i: clkmgr_aon_clocks.clk_io_div4_peri
            clk_aon_i: clkmgr_aon_clocks.clk_aon_peri
            clk_usb_48mhz_i: clkmgr_aon_clocks.clk_usb_peri
          }
        }
        {
          name: otp_ctrl
          type: otp_ctrl
          clock_srcs:
          {
            clk_i: io_div4
            clk_edn_i: main
          }
          clock_group: timers
          reset_connections:
          {
            rst_ni: lc_io_div4
            rst_edn_ni: sys
          }
          base_addr: 0x40130000
          clock_connections:
          {
            clk_i: clkmgr_aon_clocks.clk_io_div4_timers
            clk_edn_i: clkmgr_aon_clocks.clk_main_timers
          }
        }
        {
          name: lc_ctrl
          type: lc_ctrl
          clock_srcs:
          {
            clk_i: io_div4
          }
          clock_group: timers
          reset_connections:
          {
            rst_ni: lc_io_div4
          }
          base_addr: 0x40140000
          clock_connections:
          {
            clk_i: clkmgr_aon_clocks.clk_io_div4_timers
          }
        }
        {
          name: alert_handler
          type: alert_handler
          clock_srcs:
          {
            clk_i: io_div4
            clk_edn_i: main
          }
          clock_group: timers
          reset_connections:
          {
            rst_ni: sys_io_div4
            rst_edn_ni: sys
          }
          base_addr: 0x40150000
          attr: templated
          localparam:
          {
            EscCntDw: 32
            AccuCntDw: 16
            LfsrSeed: 0x7FFFFFFF
          }
          clock_connections:
          {
            clk_i: clkmgr_aon_clocks.clk_io_div4_timers
            clk_edn_i: clkmgr_aon_clocks.clk_main_timers
          }
        }
        {
          name: pwrmgr_aon
          type: pwrmgr
          clock_srcs:
          {
            clk_i: io_div4
            clk_slow_i: aon
          }
          clock_group: powerup
          reset_connections:
          {
            rst_ni: por
            rst_slow_ni: por_aon
          }
          domain: Aon
          base_addr: 0x40400000
          attr: templated
          clock_connections:
          {
            clk_i: clkmgr_aon_clocks.clk_io_div4_powerup
            clk_slow_i: clkmgr_aon_clocks.clk_aon_powerup
          }
        }
        {
          name: rstmgr_aon
          type: rstmgr
          clock_srcs:
          {
            clk_i: io_div4
            clk_aon_i: aon
            clk_main_i: main
            clk_io_i: io
            clk_usb_i: usb
            clk_io_div2_i: io_div2
            clk_io_div4_i: io_div4
          }
          clock_group: powerup
          reset_connections:
          {
            rst_ni: rst_ni
          }
          domain: Aon
          base_addr: 0x40410000
          attr: templated
          clock_connections:
          {
            clk_i: clkmgr_aon_clocks.clk_io_div4_powerup
            clk_aon_i: clkmgr_aon_clocks.clk_aon_powerup
            clk_main_i: clkmgr_aon_clocks.clk_main_powerup
            clk_io_i: clkmgr_aon_clocks.clk_io_powerup
            clk_usb_i: clkmgr_aon_clocks.clk_usb_powerup
            clk_io_div2_i: clkmgr_aon_clocks.clk_io_div2_powerup
            clk_io_div4_i: clkmgr_aon_clocks.clk_io_div4_powerup
          }
        }
        {
          name: clkmgr_aon
          type: clkmgr
          clock_srcs:
          {
            clk_i: io_div4
          }
          clock_group: powerup
          reset_connections:
          {
            rst_ni: por_io_div4
            rst_main_ni: por
            rst_io_ni: por_io
            rst_usb_ni: por_usb
            rst_io_div2_ni: por_io_div2
            rst_io_div4_ni: por_io_div4
          }
          domain: Aon
          base_addr: 0x40420000
          attr: templated
          clock_connections:
          {
            clk_i: clkmgr_aon_clocks.clk_io_div4_powerup
          }
        }
        {
          name: adc_ctrl_aon
          type: dcd
          clock_srcs:
          {
            clk_i: io_div4
            clk_aon_i: aon
          }
          clock_group: peri
          reset_connections:
          {
            rst_ni: sys_io_div4
            rst_slow_ni: sys_aon
          }
          clock_reset_export:
          [
            ast
          ]
          domain: Aon
          base_addr: 0x40440000
          clock_connections:
          {
            clk_i: clkmgr_aon_clocks.clk_io_div4_peri
            clk_aon_i: clkmgr_aon_clocks.clk_aon_peri
          }
        }
        {
          name: pinmux_aon
          type: pinmux
          clock_srcs:
          {
            clk_i: io_div4
            clk_aon_i: aon
          }
          clock_group: powerup
          reset_connections:
          {
            rst_ni: sys_io_div4
            rst_aon_ni: sys_aon
          }
          domain: Aon
          base_addr: 0x40460000
          attr: templated
          clock_connections:
          {
            clk_i: clkmgr_aon_clocks.clk_io_div4_powerup
            clk_aon_i: clkmgr_aon_clocks.clk_aon_powerup
          }
        }
        {
          name: aon_timer_aon
          type: aon_timer
          clock_srcs:
          {
            clk_i: io_div4
            clk_aon_i: aon
          }
          clock_group: timers
          reset_connections:
          {
            rst_ni: sys_io_div4
            rst_aon_ni: sys_aon
          }
          domain: Aon
          base_addr: 0x40470000
          attr: templated
          clock_connections:
          {
            clk_i: clkmgr_aon_clocks.clk_io_div4_timers
            clk_aon_i: clkmgr_aon_clocks.clk_aon_timers
          }
        }
        {
          name: ast
          type: ast
          clock_srcs:
          {
            clk_i: io_div4
          }
          clock_group: secure
          clock_reset_export:
          [
            ast
          ]
          reset_connections:
          {
            rst_ni: sys_io_div4
          }
          base_addr: 0x40480000
          attr: reggen_only
          clock_connections:
          {
            clk_i: clkmgr_aon_clocks.clk_io_div4_secure
          }
        }
        {
          name: sensor_ctrl_aon
          type: sensor_ctrl
          clock_srcs:
          {
            clk_i: io_div4
          }
          clock_group: secure
          clock_reset_export:
          [
            ast
          ]
          reset_connections:
          {
            rst_ni: sys_io_div4
          }
          domain: Aon
          base_addr: 0x40490000
          attr: reggen_top
          clock_connections:
          {
            clk_i: clkmgr_aon_clocks.clk_io_div4_secure
          }
        }
        {
          name: sram_ctrl_ret_aon
          type: sram_ctrl
          clock_srcs:
          {
            clk_i: io_div4
            clk_otp_i: io_div4
          }
          clock_group: peri
          reset_connections:
          {
            rst_ni: sys_io_div4
            rst_otp_ni: lc_io_div4
          }
          domain: Aon
          base_addr: 0x40500000
          clock_connections:
          {
            clk_i: clkmgr_aon_clocks.clk_io_div4_peri
            clk_otp_i: clkmgr_aon_clocks.clk_io_div4_peri
          }
        }
        {
          name: flash_ctrl
          type: flash_ctrl
          clock_srcs:
          {
            clk_i: main
            clk_otp_i: io_div4
          }
          clock_group: infra
          reset_connections:
          {
            rst_ni: lc
            rst_otp_ni: lc_io_div4
          }
          base_addr: 0x41000000
          attr: templated
          clock_connections:
          {
            clk_i: clkmgr_aon_clocks.clk_main_infra
            clk_otp_i: clkmgr_aon_clocks.clk_io_div4_infra
          }
        }
        {
          name: rv_plic
          type: rv_plic
          clock_srcs:
          {
            clk_i: main
          }
          clock_group: secure
          reset_connections:
          {
            rst_ni: sys
          }
          base_addr: 0x41010000
          attr: templated
          clock_connections:
          {
            clk_i: clkmgr_aon_clocks.clk_main_secure
          }
        }
        {
          name: aes
          type: aes
          clock_srcs:
          {
            clk_i: main
            clk_edn_i: main
          }
          clock_group: trans
          reset_connections:
          {
            rst_ni: sys
            rst_edn_ni: sys
          }
          base_addr: 0x41100000
          clock_connections:
          {
            clk_i: clkmgr_aon_clocks.clk_main_aes
            clk_edn_i: clkmgr_aon_clocks.clk_main_aes
          }
        }
        {
          name: hmac
          type: hmac
          clock_srcs:
          {
            clk_i: main
          }
          clock_group: trans
          reset_connections:
          {
            rst_ni: sys
          }
          base_addr: 0x41110000
          clock_connections:
          {
            clk_i: clkmgr_aon_clocks.clk_main_hmac
          }
        }
        {
          name: kmac
          type: kmac
          clock_srcs:
          {
            clk_i: main
            clk_edn_i: main
          }
          clock_group: trans
          reset_connections:
          {
            rst_ni: sys
            rst_edn_ni: sys
          }
          base_addr: 0x41120000
          clock_connections:
          {
            clk_i: clkmgr_aon_clocks.clk_main_kmac
            clk_edn_i: clkmgr_aon_clocks.clk_main_kmac
          }
        }
        {
          name: keymgr
          type: keymgr
          clock_srcs:
          {
            clk_i: main
            clk_edn_i: main
          }
          clock_group: secure
          reset_connections:
          {
            rst_ni: sys
            rst_edn_ni: sys
          }
          base_addr: 0x41130000
          clock_connections:
          {
            clk_i: clkmgr_aon_clocks.clk_main_secure
            clk_edn_i: clkmgr_aon_clocks.clk_main_secure
          }
        }
        {
          name: csrng
          type: csrng
          clock_srcs:
          {
            clk_i: main
          }
          clock_group: secure
          reset_connections:
          {
            rst_ni: sys
          }
          base_addr: 0x41150000
          clock_connections:
          {
            clk_i: clkmgr_aon_clocks.clk_main_secure
          }
        }
        {
          name: entropy_src
          type: entropy_src
          clock_srcs:
          {
            clk_i: main
          }
          clock_group: secure
          reset_connections:
          {
            rst_ni: sys
          }
          clock_reset_export:
          [
            ast
          ]
          base_addr: 0x41160000
          clock_connections:
          {
            clk_i: clkmgr_aon_clocks.clk_main_secure
          }
        }
        {
          name: edn0
          type: edn
          clock_srcs:
          {
            clk_i: main
          }
          clock_group: secure
          reset_connections:
          {
            rst_ni: sys
          }
          clock_reset_export:
          [
            ast
          ]
          base_addr: 0x41170000
          clock_connections:
          {
            clk_i: clkmgr_aon_clocks.clk_main_secure
          }
        }
        {
          name: edn1
          type: edn
          clock_srcs:
          {
            clk_i: main
          }
          clock_group: secure
          reset_connections:
          {
            rst_ni: sys
          }
          base_addr: 0x41180000
          clock_connections:
          {
            clk_i: clkmgr_aon_clocks.clk_main_secure
          }
        }
        {
          name: sram_ctrl_main
          type: sram_ctrl
          clock_srcs:
          {
            clk_i: main
            clk_otp_i: io_div4
          }
          clock_group: secure
          reset_connections:
          {
            rst_ni: sys
            rst_otp_ni: lc_io_div4
          }
          base_addr: 0x411C0000
          clock_connections:
          {
            clk_i: clkmgr_aon_clocks.clk_main_secure
            clk_otp_i: clkmgr_aon_clocks.clk_io_div4_secure
          }
        }
        {
          name: otbn
          type: otbn
          clock_srcs:
          {
            clk_i: main
            clk_edn_i: main
          }
          clock_group: trans
          reset_connections:
          {
            rst_ni: sys
            rst_edn_ni: sys
          }
          base_addr: 0x411D0000
          clock_connections:
          {
            clk_i: clkmgr_aon_clocks.clk_main_otbn
            clk_edn_i: clkmgr_aon_clocks.clk_main_otbn
          }
        }
      ]
      memory:
      [
        {
          name: rom
          clock_srcs:
          {
            clk_i: main
          }
          clock_group: infra
          reset_connections:
          {
            rst_ni: sys
          }
          type: rom
          base_addr: 0x00008000
          swaccess: ro
          size: 0x4000
          integ_width: 8
          inter_signal_list:
          [
            {
              struct: tl
              package: tlul_pkg
              type: req_rsp
              act: rsp
              name: tl
            }
            {
              struct: rom_cfg
              package: prim_rom_pkg
              type: uni
              name: cfg
              act: rcv
            }
          ]
          clock_connections:
          {
            clk_i: clkmgr_aon_clocks.clk_main_infra
          }
        }
        {
          name: ram_main
          clock_srcs:
          {
            clk_i: main
          }
          clock_group: infra
          reset_connections:
          {
            rst_ni: sys
          }
          type: ram_1p_scr
          base_addr: 0x10000000
          size: 0x20000
          byte_write: "true"
          integ_width: 7
          exec: "1"
          inter_signal_list:
          [
            {
              struct: tl
              package: tlul_pkg
              type: req_rsp
              act: rsp
              name: tl
            }
            {
              struct: sram_scr
              package: sram_ctrl_pkg
              type: req_rsp
              name: sram_scr
              act: rsp
            }
            {
              struct: sram_scr_init
              package: sram_ctrl_pkg
              type: req_rsp
              name: sram_scr_init
              act: rsp
            }
            {
              struct: tl_instr_en
              package: tlul_pkg
              type: uni
              name: en_ifetch
              act: rcv
            }
            {
              struct: logic
              package: ""
              type: uni
              name: intg_error
              act: req
            }
            {
              struct: ram_1p_cfg
              package: prim_ram_1p_pkg
              type: uni
              name: cfg
              act: rcv
            }
          ]
          clock_connections:
          {
            clk_i: clkmgr_aon_clocks.clk_main_infra
          }
        }
        {
          name: ram_ret_aon
          clock_srcs:
          {
            clk_i: io_div4
          }
          clock_group: infra
          reset_connections:
          {
            rst_ni: sys_io_div4
          }
          domain: Aon
          type: ram_1p_scr
          base_addr: 0x40600000
          size: 0x1000
          byte_write: "true"
          integ_width: 7
          exec: "0"
          inter_signal_list:
          [
            {
              struct: tl
              package: tlul_pkg
              type: req_rsp
              act: rsp
              name: tl
            }
            {
              struct: sram_scr
              package: sram_ctrl_pkg
              type: req_rsp
              name: sram_scr
              act: rsp
            }
            {
              struct: sram_scr_init
              package: sram_ctrl_pkg
              type: req_rsp
              name: sram_scr_init
              act: rsp
            }
            {
              struct: tl_instr_en
              package: tlul_pkg
              type: uni
              name: en_ifetch
              act: rcv
            }
            {
              struct: logic
              package: ""
              type: uni
              name: intg_error
              act: req
            }
            {
              struct: ram_1p_cfg
              package: prim_ram_1p_pkg
              type: uni
              name: cfg
              act: rcv
            }
          ]
          clock_connections:
          {
            clk_i: clkmgr_aon_clocks.clk_io_div4_infra
          }
        }
        {
          name: eflash
          clock_srcs:
          {
            clk_i: main
          }
          clock_group: infra
          reset_connections:
          {
            rst_ni: lc
          }
          type: eflash
          base_addr: 0x20000000
          banks: 2
          pages_per_bank: 256
          program_resolution: 8
          swaccess: ro
          inter_signal_list:
          [
            {
              struct: flash
              type: req_rsp
              name: flash_ctrl
              act: rsp
            }
            {
              struct: tl
              package: tlul_pkg
              type: req_rsp
              act: rsp
              name: tl
            }
            {
              struct: lc_tx
              package: lc_ctrl_pkg
              type: uni
              act: rcv
              name: lc_nvm_debug_en
            }
            {
              struct: lc_tx
              package: lc_ctrl_pkg
              type: uni
              act: rcv
              name: flash_bist_enable
            }
            {
              struct: logic
              package: ""
              type: uni
              act: rcv
              name: flash_power_down_h
            }
            {
              struct: logic
              package: ""
              type: uni
              act: rcv
              name: flash_power_ready_h
            }
            {
              struct: logic
              package: ""
              width: "4"
              type: uni
              act: rcv
              name: flash_test_mode_a
            }
            {
              struct: logic
              package: ""
              type: uni
              act: rcv
              name: flash_test_voltage_h
            }
          ]
          clock_connections:
          {
            clk_i: clkmgr_aon_clocks.clk_main_infra
          }
        }
      ]
      port:
      [
        {
          name: ast
          inter_signal_list:
          [
            {
              struct: edn
              type: req_rsp
              name: edn
              act: rsp
              package: edn_pkg
            }
            {
              struct: lc_tx
              type: uni
              name: lc_dft_en
              act: req
              package: lc_ctrl_pkg
            }
            {
              struct: ram_1p_cfg
              package: prim_ram_1p_pkg
              type: uni
              name: ram_1p_cfg
              act: rcv
            }
            {
              struct: ram_2p_cfg
              package: prim_ram_2p_pkg
              type: uni
              name: ram_2p_cfg
              act: rcv
            }
            {
              struct: rom_cfg
              package: prim_rom_pkg
              type: uni
              name: rom_cfg
              act: rcv
            }
          ]
        }
      ]
      inter_module:
      {
        connect:
        {
          ast.ram_1p_cfg:
          [
            otbn.ram_cfg
            ram_main.cfg
            ram_ret_aon.cfg
            rv_core_ibex.ram_cfg
          ]
          ast.ram_2p_cfg:
          [
            spi_device.ram_cfg
            usbdev.ram_cfg
          ]
          ast.rom_cfg:
          [
            rom.cfg
          ]
          alert_handler.crashdump:
          [
            rstmgr_aon.alert_dump
          ]
          alert_handler.esc_rx:
          [
            rv_core_ibex.esc_nmi_rx
            lc_ctrl.esc_wipe_secrets_rx
            lc_ctrl.esc_scrap_state_rx
            pwrmgr_aon.esc_rst_rx
          ]
          alert_handler.esc_tx:
          [
            rv_core_ibex.esc_nmi_tx
            lc_ctrl.esc_wipe_secrets_tx
            lc_ctrl.esc_scrap_state_tx
            pwrmgr_aon.esc_rst_tx
          ]
          csrng.csrng_cmd:
          [
            edn0.csrng_cmd
            edn1.csrng_cmd
          ]
          csrng.entropy_src_hw_if:
          [
            entropy_src.entropy_src_hw_if
          ]
          flash_ctrl.flash:
          [
            eflash.flash_ctrl
          ]
          flash_ctrl.keymgr:
          [
            keymgr.flash
          ]
          flash_ctrl.otp:
          [
            otp_ctrl.flash_otp_key
          ]
          flash_ctrl.rma_req:
          [
            lc_ctrl.lc_flash_rma_req
          ]
          flash_ctrl.rma_ack:
          [
            lc_ctrl.lc_flash_rma_ack
          ]
          flash_ctrl.rma_seed:
          [
            lc_ctrl.lc_flash_rma_seed
          ]
          sram_ctrl_main.sram_scr:
          [
            ram_main.sram_scr
          ]
          sram_ctrl_main.sram_scr_init:
          [
            ram_main.sram_scr_init
          ]
          sram_ctrl_ret_aon.sram_scr:
          [
            ram_ret_aon.sram_scr
          ]
          sram_ctrl_ret_aon.sram_scr_init:
          [
            ram_ret_aon.sram_scr_init
          ]
          sram_ctrl_main.en_ifetch:
          [
            ram_main.en_ifetch
          ]
          sram_ctrl_ret_aon.en_ifetch:
          [
            ram_ret_aon.en_ifetch
          ]
          ram_main.intg_error:
          [
            sram_ctrl_main.intg_error
          ]
          ram_ret_aon.intg_error:
          [
            sram_ctrl_ret_aon.intg_error
          ]
          otp_ctrl.sram_otp_key:
          [
            sram_ctrl_main.sram_otp_key
            sram_ctrl_ret_aon.sram_otp_key
          ]
          pwrmgr_aon.pwr_flash:
          [
            flash_ctrl.pwrmgr
          ]
          pwrmgr_aon.pwr_rst:
          [
            rstmgr_aon.pwr
          ]
          pwrmgr_aon.pwr_clk:
          [
            clkmgr_aon.pwr
          ]
          pwrmgr_aon.pwr_otp:
          [
            otp_ctrl.pwr_otp
          ]
          pwrmgr_aon.pwr_lc:
          [
            lc_ctrl.pwr_lc
          ]
          pwrmgr_aon.strap:
          [
            pinmux_aon.strap_en
          ]
          pwrmgr_aon.low_power:
          [
            pinmux_aon.sleep_en
            aon_timer_aon.sleep_mode
          ]
          rv_core_ibex.crash_dump:
          [
            rstmgr_aon.cpu_dump
          ]
          usbdev.usb_out_of_rst:
          [
            pinmux_aon.usb_out_of_rst
          ]
          usbdev.usb_aon_wake_en:
          [
            pinmux_aon.usb_aon_wake_en
          ]
          usbdev.usb_aon_wake_ack:
          [
            pinmux_aon.usb_aon_wake_ack
          ]
          usbdev.usb_suspend:
          [
            pinmux_aon.usb_suspend
          ]
          pinmux_aon.usb_state_debug:
          [
            usbdev.usb_state_debug
          ]
          edn0.edn:
          [
            keymgr.edn
            otp_ctrl.edn
            ast.edn
            kmac.entropy
            alert_handler.edn
            aes.edn
            otbn.edn_urnd
          ]
          edn1.edn:
          [
            otbn.edn_rnd
          ]
          otp_ctrl.otp_keymgr_key:
          [
            keymgr.otp_key
          ]
          keymgr.kmac_key:
          [
            kmac.keymgr_key
          ]
          kmac.app:
          [
            keymgr.kmac_data
          ]
          clkmgr_aon.idle:
          [
            aes.idle
            hmac.idle
            kmac.idle
            otbn.idle
          ]
          pinmux_aon.lc_jtag:
          [
            lc_ctrl.jtag
          ]
          pinmux_aon.rv_jtag:
          [
            rv_dm.jtag
          ]
          otp_ctrl.otp_lc_data:
          [
            lc_ctrl.otp_lc_data
          ]
          lc_ctrl.lc_otp_program:
          [
            otp_ctrl.lc_otp_program
          ]
          lc_ctrl.lc_otp_token:
          [
            otp_ctrl.lc_otp_token
          ]
          otp_ctrl.otp_hw_cfg:
          [
            lc_ctrl.otp_hw_cfg
            keymgr.otp_hw_cfg
            sram_ctrl_main.otp_hw_cfg
            sram_ctrl_ret_aon.otp_hw_cfg
          ]
          lc_ctrl.lc_keymgr_div:
          [
            keymgr.lc_keymgr_div
          ]
          lc_ctrl.lc_dft_en:
          [
            otp_ctrl.lc_dft_en
            pinmux_aon.lc_dft_en
            ast.lc_dft_en
          ]
          lc_ctrl.lc_nvm_debug_en:
          [
            eflash.lc_nvm_debug_en
          ]
          lc_ctrl.lc_hw_debug_en:
          [
            sram_ctrl_main.lc_hw_debug_en
            sram_ctrl_ret_aon.lc_hw_debug_en
            pinmux_aon.lc_hw_debug_en
          ]
          lc_ctrl.lc_cpu_en:
          [
            rv_core_ibex.lc_cpu_en
            aon_timer_aon.lc_cpu_en
          ]
          lc_ctrl.lc_keymgr_en:
          [
            keymgr.lc_keymgr_en
          ]
          lc_ctrl.lc_escalate_en:
          [
            aes.lc_escalate_en
            otp_ctrl.lc_escalate_en
            sram_ctrl_main.lc_escalate_en
            sram_ctrl_ret_aon.lc_escalate_en
          ]
          lc_ctrl.lc_check_byp_en:
          [
            otp_ctrl.lc_check_byp_en
          ]
          lc_ctrl.lc_clk_byp_ack:
          [
            clkmgr_aon.lc_clk_bypass_ack
          ]
          lc_ctrl.lc_creator_seed_sw_rw_en:
          [
            otp_ctrl.lc_creator_seed_sw_rw_en
            flash_ctrl.lc_creator_seed_sw_rw_en
          ]
          lc_ctrl.lc_owner_seed_sw_rw_en:
          [
            flash_ctrl.lc_owner_seed_sw_rw_en
          ]
          lc_ctrl.lc_iso_part_sw_rd_en:
          [
            flash_ctrl.lc_iso_part_sw_rd_en
          ]
          lc_ctrl.lc_iso_part_sw_wr_en:
          [
            flash_ctrl.lc_iso_part_sw_wr_en
          ]
          lc_ctrl.lc_seed_hw_rd_en:
          [
            otp_ctrl.lc_seed_hw_rd_en
            flash_ctrl.lc_seed_hw_rd_en
          ]
        }
        top:
        [
          rstmgr_aon.resets
          rstmgr_aon.cpu
          pwrmgr_aon.pwr_cpu
          clkmgr_aon.clocks
          main.tl_corei
          main.tl_cored
          main.tl_dm_sba
          main.tl_debug_mem
        ]
        external:
        {
          adc_ctrl_aon.adc: adc
          ast.edn: ""
          ast.lc_dft_en: ""
          ast.ram_1p_cfg: ram_1p_cfg
          ast.ram_2p_cfg: ram_2p_cfg
          ast.rom_cfg: rom_cfg
          clkmgr_aon.clk_main: clk_main
          clkmgr_aon.clk_io: clk_io
          clkmgr_aon.clk_usb: clk_usb
          clkmgr_aon.clk_aon: clk_aon
          clkmgr_aon.jitter_en: clk_main_jitter_en
          clkmgr_aon.ast_clk_bypass_ack: lc_clk_byp_ack
          eflash.flash_bist_enable: flash_bist_enable
          eflash.flash_power_down_h: flash_power_down_h
          eflash.flash_power_ready_h: flash_power_ready_h
          entropy_src.entropy_src_rng: es_rng
          entropy_src.rng_fips: es_rng_fips
          lc_ctrl.lc_clk_byp_req: lc_clk_byp_req
          peri.tl_ast: ast_tl
          pinmux_aon.dft_strap_test: dft_strap_test
          pwrmgr_aon.pwr_ast: pwrmgr_ast
          otp_ctrl.otp_ast_pwr_seq: ""
          otp_ctrl.otp_ast_pwr_seq_h: ""
          sensor_ctrl_aon.ast_alert: sensor_ctrl_ast_alert
          sensor_ctrl_aon.ast_status: sensor_ctrl_ast_status
          sensor_ctrl_aon.pinmux2ast: pinmux2ast
          sensor_ctrl_aon.ast2pinmux: ast2pinmux
          usbdev.usb_ref_val: ""
          usbdev.usb_ref_pulse: ""
          clkmgr_aon.clocks_ast: clks_ast
        }
      }
      debug_mem_base_addr: 0x1A110000
      xbar:
      [
        {
          name: main
          clock_srcs:
          {
            clk_main_i: main
            clk_fixed_i: io_div4
          }
          clock_group: infra
          reset: sys
          reset_connections:
          {
            rst_main_ni: sys
            rst_fixed_ni: sys_io_div4
          }
          clock_connections:
          {
            clk_main_i: clkmgr_aon_clocks.clk_main_infra
            clk_fixed_i: clkmgr_aon_clocks.clk_io_div4_infra
          }
        }
        {
          name: peri
          clock_srcs:
          {
            clk_peri_i: io_div4
          }
          clock_group: infra
          reset: sys_io_div4
          reset_connections:
          {
            rst_peri_ni: sys_io_div4
          }
          clock_connections:
          {
            clk_peri_i: clkmgr_aon_clocks.clk_io_div4_infra
          }
        }
      ]
      pinmux:
      {
        num_mio: 44
        dio_modules:
        [
          {
            name: spi_device
            pad:
            [
              ChC[0..5]
            ]
          }
          {
            name: spi_host0
            pad:
            [
              ChB[0..5]
            ]
          }
          {
            name: usbdev
            pad:
            [
              ChA[0..8]
            ]
          }
        ]
        mio_modules:
        [
          gpio
          uart0
          uart1
          uart2
          uart3
          i2c0
          i2c1
          i2c2
          pattgen
          spi_host1
          flash_ctrl
          sensor_ctrl_aon
        ]
        nc_modules:
        [
          rv_timer
          hmac
        ]
        num_wkup_detect: 8
        wkup_cnt_width: 8
      }
      padctrl:
      {
        attr_default:
        [
          STRONG
        ]
        pads:
        [
          {
            name: ChA
            type: IO_33V
            count: 32
          }
          {
            name: ChB
            type: IO_33V
            count: 4
            attr:
            [
              KEEP
              WEAK
            ]
          }
          {
            name: ChC
            type: IO_33V
            count: 4
            attr:
            [
              KEEP
              STRONG
            ]
          }
        ]
      }
      exported_clks:
      {
        ast:
        {
          usbdev:
          [
            io_div4_peri
            aon_peri
            usb_peri
          ]
          adc_ctrl_aon:
          [
            io_div4_peri
            aon_peri
          ]
          ast:
          [
            io_div4_secure
          ]
          sensor_ctrl_aon:
          [
            io_div4_secure
          ]
          entropy_src:
          [
            main_secure
          ]
          edn0:
          [
            main_secure
          ]
        }
      }
    }
    div_srcs:
    [
      {
        name: io_div2
        aon: no
        div: 2
        src: io
        freq: "48000000"
      }
      {
        name: io_div4
        aon: no
        div: 4
        src: io
        freq: "24000000"
      }
    ]
    rg_srcs:
    [
      main
      io
      usb
      io_div2
      io_div4
    ]
    ft_clks:
    {
      clk_io_div4_powerup: io_div4
      clk_aon_powerup: aon
      clk_main_powerup: main
      clk_io_powerup: io
      clk_usb_powerup: usb
      clk_io_div2_powerup: io_div2
      clk_aon_peri: aon
      clk_aon_timers: aon
    }
    rg_clks:
    {
      clk_main_infra: main
      clk_io_div4_infra: io_div4
      clk_io_div4_secure: io_div4
      clk_main_secure: main
      clk_io_div4_timers: io_div4
      clk_main_timers: main
      clk_proc_main: main
    }
    sw_clks:
    {
      clk_io_div4_peri: io_div4
      clk_io_div2_peri: io_div2
      clk_usb_peri: usb
    }
    export_clks:
    {
      ast:
      {
        usbdev:
        [
          io_div4_peri
          aon_peri
          usb_peri
        ]
        adc_ctrl_aon:
        [
          io_div4_peri
          aon_peri
        ]
        ast:
        [
          io_div4_secure
        ]
        sensor_ctrl_aon:
        [
          io_div4_secure
        ]
        entropy_src:
        [
          main_secure
        ]
        edn0:
        [
          main_secure
        ]
      }
    }
    hint_clks:
    {
      clk_main_aes:
      {
        name: aes
        src: main
      }
      clk_main_hmac:
      {
        name: hmac
        src: main
      }
      clk_main_kmac:
      {
        name: kmac
        src: main
      }
      clk_main_otbn:
      {
        name: otbn
        src: main
      }
    }
  }
}
