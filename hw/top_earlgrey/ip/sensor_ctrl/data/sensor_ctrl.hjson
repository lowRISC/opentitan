// Copyright lowRISC contributors.
// Licensed under the Apache License, Version 2.0, see LICENSE for details.
// SPDX-License-Identifier: Apache-2.0
// TODO: This module is only a draft implementation that covers most of the ast_wrapper
// functionality but is incomplete


# SENSOR_CTRL register template
#
{
  name: "SENSOR_CTRL",
  clock_primary: "clk_i",
  bus_interfaces: [
    { protocol: "tlul", direction: "device" }
  ],
  available_input_list: [
    { name: "ast_debug_in",
      desc: "ast debug inputs from pinmux",
      width: "10"
    },
  ],
  available_output_list: [
    { name: "ast_debug_out",
      desc: "ast debug outputs to pinmux",
      width: "10"
    }
  ],
  regwidth: "32",
  param_list: [
    { name:    "NumAlerts",
      type:    "int",
      default: "7",
      desc:    "Number of alerts",
      local:   "true"
    },
    { name:    "NumIoRails",
      type:    "int",
      default: "2",
      desc:    "Number of IO rails",
      local:   "true"
    },
    { name:    "AsSel",
      type:    "int",
      default: "0",
      desc:    "Active shield alert bit position",
      local:   "true"
    }
    { name:    "CgSel",
      type:    "int",
      default: "1",
      desc:    "Clock glitch alert bit position",
      local:   "true"
    }
    { name:    "GdSel",
      type:    "int",
      default: "2",
      desc:    "Glitch detector alert bit position",
      local:   "true"
    }
    { name:    "TsHiSel",
      type:    "int",
      default: "3",
      desc:    "Temperature high alert bit position",
      local:   "true"
    }
    { name:    "TsLoSel",
      type:    "int",
      default: "4",
      desc:    "Temperature low alert bit position",
      local:   "true"
    }
    { name:    "LsSel",
      type:    "int",
      default: "5",
      desc:    "Laser alert bit position",
      local:   "true"
    }
    { name:    "OtSel",
      type:    "int",
      default: "6",
      desc:    "Other alert bit position",
      local:   "true"
    }
  ],

  alert_list: [
    { name: "recov_as",
      desc: "Triggered through AST",
    },
    { name: "recov_cg",
      desc: "Triggered through AST",
    },
    { name: "recov_gd",
      desc: "Triggered through AST",
    },
    { name: "recov_ts_hi",
      desc: "Triggered through AST",
    },
    { name: "recov_ts_lo",
      desc: "Triggered through AST",
    },
    { name: "recov_ls",
      desc: "Triggered through AST",
    },
    { name: "recov_ot",
      desc: "Triggered through AST",
    },
  ]


  // Define ast_struct package
  inter_signal_list: [
    { struct:  "ast_alert",
      type:    "req_rsp",
      name:    "ast_alert",
      act:     "rsp",
      package: "ast_pkg",
    },

    { struct:  "ast_status",
      type:    "uni",
      name:    "ast_status",
      act:     "rcv",
      package: "ast_pkg",
    },

    { struct:  "logic",
      type:    "uni",
      name:    "ast2pinmux",
      act:     "rcv",
      width:   10,
      package: ""
    },

    { struct:  "logic",
      type:    "uni",
      name:    "pinmux2ast",
      act:     "req",
      width:   10,
      package: ""
    },

  ],

registers: [
    { name: "CFG_REGWEN",
      swaccess: "rw0c",
      hwaccess: "none",
      desc: '''
      Controls the configurability of !!ACK_MODE register.
      ''',

      fields: [
        { bits: "0",
          name: "EN",
          desc: '''
            Configuration enable.
          ''',
          resval: "1",
        },
      ]
    },

    { multireg: {
        cname: "SENSOR_CTRL",
        name: "ACK_MODE",
        desc: "Alert acknowledge mode",
        count: "NumAlerts",
        swaccess: "rw",
        hwaccess: "hro",
        regwen: "CFG_REGWEN",
        fields: [
            { bits: "1:0",
              name: "VAL",
              desc: '''
                Acknowledge mode to alerts.
                0 is immediate acknowledge, the hardware immediately acks an incoming alert.
                1 is software acknowledge.  Software must program the appropriate bit in !!ALERT_STATE to acknowledge the alert.
                2 is no acknowledge.  When in this mode, any alert will effectively be considered fatal to the system.
                3 is not a valid selection, but behaves similarly to 2.
                ''',
              resval: "0"
            },
        ],
      },
    },

    { multireg: {
        cname: "SENSOR_CTRL",
        name: "ALERT_TRIG",
        desc: "Alert trigger test",
        count: "NumAlerts",
        swaccess: "rw",
        hwaccess: "hro",
        fields: [
            { bits: "0",
              name: "VAL",
              desc: '''
                Alert trigger for testing
                0 No alerts triggered
                1 Continuously trigger alert until disabled
                For bit mapping, please see !!ALERT_TEST
              ''',
              resval: "0"
            },
        ],
        tags: [// This register triggers alerts to fire and should be a directed test
               "excl:CsrNonInitTests:CsrExclWrite"]
      },
    },

    { multireg: {
        cname: "SENSOR_CTRL",
        name: "ALERT_STATE",
        desc: '''
          A bit is set whenever there is an incoming alert event.
          Software reads back the alert that was set and clears the appropriate bits to acknowledge the alert.

          This is only valid when !!ACK_MODE is set to software.
          For bit mapping, please see !!ALERT_TEST
        ''',
        count: "NumAlerts",
        swaccess: "rw1c",
        hwaccess: "hrw",
        hwqe: "true",
        fields: [
            { bits: "0",
              name: "VAL",
              desc: '''
                1 - An alert event has been set
                0 - No alert event has been set
              ''',
              resval: "0"
            },
        ],
      },
    },

    { name: "STATUS",
      swaccess: "ro",
      hwaccess: "hwo",
      desc: '''
        Status readback for ast
      ''',

      fields: [
        { bits: "NumIoRails-1:0",
          name: "io_pok",
          desc: '''
            IO power is ready
          ''',
          resval: "3",
        },
      ]
    },
  ]
}
