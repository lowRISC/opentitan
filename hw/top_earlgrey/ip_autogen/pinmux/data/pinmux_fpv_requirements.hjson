// Copyright lowRISC contributors (OpenTitan project).
// Licensed under the Apache License, Version 2.0, see LICENSE for details.
// SPDX-License-Identifier: Apache-2.0
{
  name: "pinmux_fpv"
  // The requirements of the pinmux FPV testplan (doc/fpv/README.md), one entry each:
  //   name, desc   the requirement ID and its statement
  //   source      where the rule comes from: !!REGISTER.FIELD names a register field
  //               (reggen's form), a Markdown link names a document section or a key
  //   kind        "spec": a specification states the rule; "RTL": none does, and the
  //               rule follows the design's present behaviour or leaves the outcome
  //               to a specification question; a "spec" entry whose source list
  //               ends with "No specification states <part>." takes that one part
  //               from the design's present behaviour
  //   testpoint   its testpoint in pinmux_env_fpv_testplan.hjson
  //   checks      what decides it: "<check name> (<planned assertion>)", the CSR
  //               checker, or a check that waits on a specification question
  //   why         why those checks prove it
  //   milestone   the verification stage of its testpoint: V1, V2 or V2S
  //   priority    the order of work within a stage: "1" before "2"
  //   security    true when a security property depends on it
  //   state       "open" until its checks are proven; with a reason where no check
  //               of this plan decides it
  // The file holds, besides the entries:
  //   written_for   the top the plan was written for and read against
  //   rendered_for  the top of this copy
  //   terms         the words the requirements use, each with its meaning
  //   parameters    the values the top's configuration sets, which the
  //                 requirements name by parameter, with the key that sets each
  //   pad_roles     the roles of the pads the top description assigns, which the
  //                 requirements name by role
  //   groups        the requirements by feature; a group's conditions say when
  //                 its requirements hold and define its own words
  written_for: "earlgrey"
  rendered_for: "earlgrey"
  terms: [
    {
      name: '''`n`'''
      desc: '''MIO peripheral input, from 0 to `NMioPeriphIn` - 1'''
    }
    {
      name: '''`k`'''
      desc: '''MIO peripheral output, from 0 to `NMioPeriphOut` - 1'''
    }
    {
      name: '''`p`'''
      desc: '''MIO pad, from 0 to `NMioPads` - 1'''
    }
    {
      name: '''`d`'''
      desc: '''DIO pad, from 0 to `NDioPads` - 1'''
    }
    {
      name: '''Watched signal'''
      desc: '''The pad input that `MIODIO` and `PADSEL` pick'''
    }
    {
      name: '''Forwarded value'''
      desc: '''The watched signal sampled each `clk_aon_i` cycle, through the filter when `FILTER` is 1'''
    }
    {
      name: '''Asleep, awake'''
      desc: '''A pad is asleep while its sleep status bit is 1, awake while it is 0'''
    }
    {
      name: '''AON'''
      desc: '''The always-on domain: the logic on `clk_aon_i` and `rst_aon_ni`'''
    }
    {
      name: '''Lands'''
      desc: '''A written or sampled value lands in the cycle the register or flop it is meant for takes it'''
    }
    {
      name: '''Hardware write'''
      desc: '''A write to a register field made by the pinmux logic, not by software over the bus'''
    }
    {
      name: '''Full reset'''
      desc: '''A reset that asserts `rst_sys_ni`, which the top connects to the system reset tree ([top_earlgrey.hjson `module.pinmux`](hw/top_earlgrey/data/top_earlgrey.hjson))'''
    }
    {
      name: '''NDM reset'''
      desc: '''A reset that asserts `rst_ni` and `rst_aon_ni`, and not `rst_sys_ni`. The top connects `rst_ni` and `rst_aon_ni` to the life cycle reset tree ([top_earlgrey.hjson `module.pinmux`](hw/top_earlgrey/data/top_earlgrey.hjson)). A non-debug module reset request asserts that tree outside PROD and PROD_END ([Summary](hw/top_earlgrey/ip_autogen/rstmgr/doc/theory_of_operation.md#summary)). A flop on `rst_sys_ni` keeps its value through this reset ([Non-debug Module Reset](hw/top_earlgrey/ip_autogen/pinmux/doc/theory_of_operation.md#non-debug-module-reset))'''
    }
    {
      name: '''Steadily On'''
      desc: '''An input is steadily On in a cycle when the input was On, and the design was out of full reset, in each of the two cycles before that cycle'''
    }
    {
      name: '''On, Off'''
      desc: '''On is 4'b0101 and Off 4'b1010, the life cycle controller's values ([Control Signal Propagation](hw/ip/lc_ctrl/doc/interfaces.md#control-signal-propagation))'''
    }
    {
      name: '''The latch'''
      desc: '''The latched debug enable, seen on `pinmux_hw_debug_en_o` and through the RISC-V TAP'''
    }
    {
      name: '''A clear'''
      desc: '''`lc_hw_debug_clr_i`, `lc_check_byp_en_i` or `lc_escalate_en_i` at any value other than Off ([Non-debug Module Reset](hw/top_earlgrey/ip_autogen/pinmux/doc/theory_of_operation.md#non-debug-module-reset); [Control Signal Propagation](hw/ip/lc_ctrl/doc/interfaces.md#control-signal-propagation) for the debug clear and the escalation input); it turns the latch Off'''
    }
    {
      name: '''Connected'''
      desc: '''A TAP is connected while the TAP straps name it and its gate is open: the life cycle TAP at straps 01; the RISC-V TAP at straps 10 while the latch is On; the DFT TAP at straps 11 while `lc_dft_en_i` is On; on a top with the RRAM TAP (`enable_rram_tap`), the RRAM TAP at straps 00 while `RRAM_JTAG_SEL` is `kMultiBitBool4True` and `lc_nvm_debug_en_i` is On; at straps 00, no TAP otherwise ([Strap Sampling and TAP Isolation](hw/top_earlgrey/ip_autogen/pinmux/doc/theory_of_operation.md#strap-sampling-and-tap-isolation), [Non-debug Module Reset](hw/top_earlgrey/ip_autogen/pinmux/doc/theory_of_operation.md#non-debug-module-reset))'''
    }
    {
      name: '''Owns'''
      desc: '''A TAP owns the JTAG pads while it is connected: the pads then carry the TAP's signals, not what the pad muxes select'''
    }
    {
      name: '''Cut'''
      desc: '''A TAP is cut while its gate is shut, or while the TAP straps name another TAP or none'''
    }
    {
      name: '''Allowed pad'''
      desc: '''A pad is allowed for a signal when the signal's pad list names the pad, or when the list is empty. The pad list is the signal's `pads` entry in the top's configuration ([top_earlgrey.hjson `pinmux`](hw/top_earlgrey/data/top_earlgrey.hjson); [top_earlgrey_pinmux.ipconfig.hjson](hw/top_earlgrey/ip_autogen/pinmux/data/top_earlgrey_pinmux.ipconfig.hjson) `mio_periph_ins`; [top_earlgrey_pinmux.ipconfig.hjson](hw/top_earlgrey/ip_autogen/pinmux/data/top_earlgrey_pinmux.ipconfig.hjson) `mio_periph_outs`).'''
    }
  ]
  parameters: [
    {
      name: "NMioPeriphIn"
      desc: '''Number of muxed peripheral inputs'''
      value: 94
    }
    {
      name: "NMioPeriphOut"
      desc: '''Number of muxed peripheral outputs'''
      value: 104
    }
    {
      name: "NMioPads"
      desc: '''Number of muxed pads'''
      value: 47
    }
    {
      name: "NDioPads"
      desc: '''Number of dedicated pads'''
      value: 16
    }
    {
      name: "NWkupDetect"
      desc: '''Number of wakeup detectors'''
      value: 8
    }
    {
      name: "WkupCntWidth"
      desc: '''Width of a wakeup detector's counter, in bits'''
      value: 8
    }
  ]
  pad_roles: [
    {
      name: '''the TAP strap 0 pad'''
      pad: "IOC8 (MIO 30)"
    }
    {
      name: '''the TAP strap 1 pad'''
      pad: "IOC5 (MIO 27)"
    }
    {
      name: '''the DFT strap 0 pad'''
      pad: "IOR5 (MIO 40)"
    }
    {
      name: '''the DFT strap 1 pad'''
      pad: "IOR7 (MIO 42)"
    }
    {
      name: '''the TCK pad'''
      pad: "IOR3 (MIO 38)"
    }
    {
      name: '''the TMS pad'''
      pad: "IOR0 (MIO 35)"
    }
    {
      name: '''the TDI pad'''
      pad: "IOR2 (MIO 37)"
    }
    {
      name: '''the TRST_N pad'''
      pad: "IOR4 (MIO 39)"
    }
    {
      name: '''the TDO pad'''
      pad: "IOR1 (MIO 36)"
    }
    {
      name: '''the USB D+ pad'''
      pad: "USB_P (DIO 0)"
    }
    {
      name: '''the USB D- pad'''
      pad: "USB_N (DIO 1)"
    }
    {
      name: '''a scan clock pad'''
      pad: "SPI_DEV_CLK (DIO 12)"
    }
  ]
  groups: [
    {
      name: '''Input selection'''
      conditions: [
        '''Every row holds in every cycle, except for a JTAG pad while a TAP owns it.'''
        '''An input's pad list limits only the select values that name a pad. The constant selects 0 and 1 act the same on every input, with or without a pad list.'''
      ]
      requirements: [
        {
          name: REQ_IN_01
          desc: '''MIO peripheral input `n` shall read 0 while `MIO_PERIPH_INSEL_n` is 0.'''
          source: [
            '''!!MIO_PERIPH_INSEL.IN'''
          ]
          kind: "spec"
          testpoint: "pad_listen"
          checks: ["reads tie 0 (assert_PadListen_ReadsTie0)"]
          why: '''In every cycle the check compares each MIO peripheral input whose select is 0 with 0.'''
          milestone: "V1"
          priority: "1"
          security: false
          state: "open"
        }
        {
          name: REQ_IN_02
          desc: '''MIO peripheral input `n` shall read 1 while `MIO_PERIPH_INSEL_n` is 1.'''
          source: [
            '''!!MIO_PERIPH_INSEL.IN'''
          ]
          kind: "spec"
          testpoint: "pad_listen"
          checks: ["reads tie 1 (assert_PadListen_ReadsTie1)"]
          why: '''In every cycle the check compares each MIO peripheral input whose select is 1 with 1.'''
          milestone: "V1"
          priority: "1"
          security: false
          state: "open"
        }
        {
          name: REQ_IN_03
          desc: '''MIO peripheral input `n` shall read the input of MIO pad `p`, in the same cycle, while `MIO_PERIPH_INSEL_n` is 2 + `p` and pad `p` is allowed for input `n`. Here `p` runs from 0 to `NMioPads` - 1.'''
          source: [
            '''!!MIO_PERIPH_INSEL.IN'''
            '''[Muxing Matrix](hw/top_earlgrey/ip_autogen/pinmux/doc/theory_of_operation.md#muxing-matrix)'''
            '''[top_earlgrey_pinmux.ipconfig.hjson `n_mio_pads`](hw/top_earlgrey/ip_autogen/pinmux/data/top_earlgrey_pinmux.ipconfig.hjson)'''
            '''[top_earlgrey_pinmux.ipconfig.hjson `mio_periph_ins`](hw/top_earlgrey/ip_autogen/pinmux/data/top_earlgrey_pinmux.ipconfig.hjson)'''
          ]
          kind: "spec"
          testpoint: "pad_listen"
          checks: ["reads selected pad (assert_PadListen_ReadsSelectedPad)"]
          why: '''The check compares each MIO peripheral input with `mio_in_i[p]` in the same cycle while its select is 2 + `p`, for every `p` from 0 to `NMioPads` - 1. For an input with a pad list, the check runs only over the pads that the list allows.'''
          milestone: "V1"
          priority: "1"
          security: false
          state: "open"
        }
        {
          name: REQ_IN_04
          desc: '''MIO peripheral input `n` shall read 0 while `MIO_PERIPH_INSEL_n` is greater than `NMioPads` + 1. These select values name no pad.'''
          source: [
            '''!!MIO_PERIPH_INSEL'''
            '''[top_earlgrey_pinmux.ipconfig.hjson `n_mio_pads`](hw/top_earlgrey/ip_autogen/pinmux/data/top_earlgrey_pinmux.ipconfig.hjson)'''
          ]
          kind: "RTL"
          testpoint: "pad_listen"
          checks: ["select without a pad reads 0 (assert_PadListen_SelectWithoutAPadReads0)"]
          why: '''While the select of a MIO peripheral input is greater than `NMioPads` + 1, the check compares the input with 0. These select values name no pad.'''
          milestone: "V1"
          priority: "1"
          security: false
          state: "open"
        }
        {
          name: REQ_IN_05
          desc: '''DIO peripheral input `d` shall read the input of DIO pad `d`, in the same cycle, at every value of the pinmux registers.'''
          source: [
            '''[MIO and DIO Signal Categories](hw/top_earlgrey/ip_autogen/pinmux/doc/theory_of_operation.md#mio-and-dio-signal-categories)'''
          ]
          kind: "spec"
          testpoint: "pad_listen"
          checks: ["DIO reads its pad (assert_PadListen_DioReadsItsPad)"]
          why: '''The check compares each DIO peripheral input with its own pad's bit of `dio_in_i` in the same cycle, at every value of the registers.'''
          milestone: "V1"
          priority: "1"
          security: false
          state: "open"
        }
        {
          name: REQ_IN_06
          desc: '''After reset and until software writes its select, MIO peripheral input `n` shall read the pad input or the constant 0 or 1 that the top defines as its reset selection. An input with no reset selection defined shall read 0.'''
          source: [
            '''[Pinmux Configuration](hw/top_earlgrey/ip_autogen/pinmux/doc/programmers_guide.md#pinmux-configuration)'''
            '''[MIO and DIO Signal Categories](hw/top_earlgrey/ip_autogen/pinmux/doc/theory_of_operation.md#mio-and-dio-signal-categories)'''
            '''!!MIO_PERIPH_INSEL.IN'''
            '''[top_earlgrey.hjson `pinmux`](hw/top_earlgrey/data/top_earlgrey.hjson)'''
            '''[top_earlgrey_pinmux.ipconfig.hjson `mio_periph_ins`](hw/top_earlgrey/ip_autogen/pinmux/data/top_earlgrey_pinmux.ipconfig.hjson)'''
          ]
          kind: "spec"
          testpoint: "reset_state"
          checks: ["input starts at default (assert_ResetState_InputStartsAtDefault)"]
          why: '''From reset until the input's select is written, the check compares the input with the input's default value in every cycle. For an input with no default, the check compares the input with 0.'''
          milestone: "V2"
          priority: "2"
          security: false
          state: "open"
        }
        {
          name: REQ_IN_07
          desc: '''MIO peripheral input `n` shall read 0 while `MIO_PERIPH_INSEL_n` is 2 + `p` and pad `p` is not allowed for input `n`.'''
          source: [
            '''[Muxing Matrix](hw/top_earlgrey/ip_autogen/pinmux/doc/theory_of_operation.md#muxing-matrix)'''
            '''[Pinmux Configuration](hw/top_earlgrey/ip_autogen/pinmux/doc/programmers_guide.md#pinmux-configuration)'''
            '''!!MIO_PERIPH_INSEL.IN'''
            '''[top_earlgrey_pinmux.ipconfig.hjson `mio_periph_ins`](hw/top_earlgrey/ip_autogen/pinmux/data/top_earlgrey_pinmux.ipconfig.hjson)'''
          ]
          kind: "spec"
          testpoint: "sparse_insel"
          checks: ["unlisted pad reads zero (assert_SparseInsel_UnlistedPadReadsZero)"]
          why: '''While the input select names a pad that the input's pad list does not allow, the check compares the input with 0 in the same cycle.'''
          milestone: "V2"
          priority: "2"
          security: false
          state: "open"
        }
      ]
    }
    {
      name: '''Output selection'''
      conditions: [
        '''Every row holds while the pad is awake and no TAP owns the pad.'''
        '''A pad list limits only the select values that name a peripheral output, so the constant select values 0, 1 and 2 behave the same on every pad.'''
      ]
      requirements: [
        {
          name: REQ_OUT_01a
          desc: '''The output of MIO pad `p` shall be 0 while `MIO_OUTSEL_p` is 0.'''
          source: [
            '''!!MIO_OUTSEL.OUT'''
          ]
          kind: "spec"
          testpoint: "pad_output"
          checks: ["tie 0 drives 0 (assert_PadOutput_Tie0Drives0)"]
          why: '''While an awake pad's select is 0, the check compares the pad's output with 0 in every cycle.'''
          milestone: "V1"
          priority: "1"
          security: false
          state: "open"
        }
        {
          name: REQ_OUT_01b
          desc: '''The output enable of MIO pad `p` shall be 1 while `MIO_OUTSEL_p` is 0, so the pad drives 0.'''
          source: [
            '''!!MIO_OUTSEL.OUT'''
          ]
          kind: "spec"
          testpoint: "pad_output"
          checks: ["tie 0 drives 0 (assert_PadOutput_Tie0Drives0)"]
          why: '''While an awake pad's select is 0, the check compares the pad's output enable with 1 in every cycle.'''
          milestone: "V1"
          priority: "1"
          security: false
          state: "open"
        }
        {
          name: REQ_OUT_02a
          desc: '''The output of MIO pad `p` shall be 1 while `MIO_OUTSEL_p` is 1.'''
          source: [
            '''!!MIO_OUTSEL.OUT'''
          ]
          kind: "spec"
          testpoint: "pad_output"
          checks: ["tie 1 drives 1 (assert_PadOutput_Tie1Drives1)"]
          why: '''While an awake pad's select is 1, the check compares the pad's output with 1 in every cycle.'''
          milestone: "V1"
          priority: "1"
          security: false
          state: "open"
        }
        {
          name: REQ_OUT_02b
          desc: '''The output enable of MIO pad `p` shall be 1 while `MIO_OUTSEL_p` is 1, so the pad drives 1.'''
          source: [
            '''!!MIO_OUTSEL.OUT'''
          ]
          kind: "spec"
          testpoint: "pad_output"
          checks: ["tie 1 drives 1 (assert_PadOutput_Tie1Drives1)"]
          why: '''While an awake pad's select is 1, the check compares the pad's output enable with 1 in every cycle.'''
          milestone: "V1"
          priority: "1"
          security: false
          state: "open"
        }
        {
          name: REQ_OUT_03a
          desc: '''The output enable of MIO pad `p` shall be 0 while `MIO_OUTSEL_p` is 2, so the pad is high-Z.'''
          source: [
            '''!!MIO_OUTSEL.OUT'''
          ]
          kind: "spec"
          testpoint: "pad_output"
          checks: ["select 2 is high-Z (assert_PadOutput_Select2IsHighZ)"]
          why: '''While an awake pad's select is 2, the check compares the pad's output enable with 0 in every cycle.'''
          milestone: "V1"
          priority: "1"
          security: false
          state: "open"
        }
        {
          name: REQ_OUT_03b
          desc: '''The output of MIO pad `p` shall be 0 while `MIO_OUTSEL_p` is 2.'''
          source: [
            '''!!MIO_OUTSEL.OUT'''
          ]
          kind: "spec"
          testpoint: "pad_output"
          checks: ["select 2 is high-Z (assert_PadOutput_Select2IsHighZ)"]
          why: '''While an awake pad's select is 2, the check compares the pad's output with 0 in every cycle.'''
          milestone: "V1"
          priority: "1"
          security: false
          state: "open"
        }
        {
          name: REQ_OUT_04a
          desc: '''MIO pad `p` shall carry peripheral output `k`, in the same cycle, while `MIO_OUTSEL_p` is 3 + `k` and pad `p` is allowed for output `k`. Here `k` runs from 0 to `NMioPeriphOut` - 1.'''
          source: [
            '''!!MIO_OUTSEL.OUT'''
            '''[Muxing Matrix](hw/top_earlgrey/ip_autogen/pinmux/doc/theory_of_operation.md#muxing-matrix)'''
            '''[top_earlgrey_pinmux.ipconfig.hjson `n_mio_periph_out`](hw/top_earlgrey/ip_autogen/pinmux/data/top_earlgrey_pinmux.ipconfig.hjson)'''
            '''[top_earlgrey_pinmux.ipconfig.hjson `mio_periph_outs`](hw/top_earlgrey/ip_autogen/pinmux/data/top_earlgrey_pinmux.ipconfig.hjson)'''
          ]
          kind: "spec"
          testpoint: "pad_output"
          checks: ["drives selected output (assert_PadOutput_DrivesSelectedOutput)"]
          why: '''While an awake pad's select is 3 + `k`, the check compares its output with `periph_to_mio_i[k]` in the same cycle, for `k` from 0 to `NMioPeriphOut` - 1. On a top with pad lists, the check skips outputs not allowed for the pad.'''
          milestone: "V1"
          priority: "1"
          security: false
          state: "open"
        }
        {
          name: REQ_OUT_04b
          desc: '''MIO pad `p` shall carry output enable `k`, in the same cycle, while `MIO_OUTSEL_p` is 3 + `k` and pad `p` is allowed for output `k`. Here `k` runs from 0 to `NMioPeriphOut` - 1.'''
          source: [
            '''!!MIO_OUTSEL.OUT'''
            '''[Muxing Matrix](hw/top_earlgrey/ip_autogen/pinmux/doc/theory_of_operation.md#muxing-matrix)'''
            '''[top_earlgrey_pinmux.ipconfig.hjson `n_mio_periph_out`](hw/top_earlgrey/ip_autogen/pinmux/data/top_earlgrey_pinmux.ipconfig.hjson)'''
            '''[top_earlgrey_pinmux.ipconfig.hjson `mio_periph_outs`](hw/top_earlgrey/ip_autogen/pinmux/data/top_earlgrey_pinmux.ipconfig.hjson)'''
          ]
          kind: "spec"
          testpoint: "pad_output"
          checks: ["drives selected output (assert_PadOutput_DrivesSelectedOutput)"]
          why: '''While an awake pad's select is 3 + `k`, the check compares its output enable with `periph_to_mio_oe_i[k]` in the same cycle, for `k` from 0 to `NMioPeriphOut` - 1. On a top with pad lists, the check skips outputs not allowed for the pad.'''
          milestone: "V1"
          priority: "1"
          security: false
          state: "open"
        }
        {
          name: REQ_OUT_05a
          desc: '''The output enable of MIO pad `p` shall be 0 while `MIO_OUTSEL_p` is greater than `NMioPeriphOut` + 2, so the pad is high-Z. These select values name no peripheral output.'''
          source: [
            '''!!MIO_OUTSEL'''
            '''[top_earlgrey_pinmux.ipconfig.hjson `n_mio_periph_out`](hw/top_earlgrey/ip_autogen/pinmux/data/top_earlgrey_pinmux.ipconfig.hjson)'''
          ]
          kind: "RTL"
          testpoint: "pad_output"
          checks: ["select without an output is high-Z (assert_PadOutput_SelectWithoutAnOutputIsHighZ)"]
          why: '''While an awake pad's select is greater than `NMioPeriphOut` + 2, the check compares the pad's output enable with 0. These select values name no peripheral output.'''
          milestone: "V1"
          priority: "1"
          security: false
          state: "open"
        }
        {
          name: REQ_OUT_05b
          desc: '''The output of MIO pad `p` shall be 0 while `MIO_OUTSEL_p` is greater than `NMioPeriphOut` + 2. These select values name no peripheral output.'''
          source: [
            '''!!MIO_OUTSEL'''
            '''[top_earlgrey_pinmux.ipconfig.hjson `n_mio_periph_out`](hw/top_earlgrey/ip_autogen/pinmux/data/top_earlgrey_pinmux.ipconfig.hjson)'''
          ]
          kind: "RTL"
          testpoint: "pad_output"
          checks: ["select without an output is high-Z (assert_PadOutput_SelectWithoutAnOutputIsHighZ)"]
          why: '''While an awake pad's select is greater than `NMioPeriphOut` + 2, the check compares the pad's output with 0. These select values name no peripheral output.'''
          milestone: "V1"
          priority: "1"
          security: false
          state: "open"
        }
        {
          name: REQ_OUT_06a
          desc: '''DIO pad `d` shall carry its peripheral's output, in the same cycle.'''
          source: [
            '''[MIO and DIO Signal Categories](hw/top_earlgrey/ip_autogen/pinmux/doc/theory_of_operation.md#mio-and-dio-signal-categories)'''
          ]
          kind: "spec"
          testpoint: "pad_output"
          checks: ["DIO drives its peripheral (assert_PadOutput_DioDrivesItsPeripheral)"]
          why: '''The check compares each awake DIO pad's output with `periph_to_dio_i[d]` in the same cycle, for any values that the registers hold.'''
          milestone: "V1"
          priority: "1"
          security: false
          state: "open"
        }
        {
          name: REQ_OUT_06b
          desc: '''DIO pad `d` shall carry its peripheral's output enable, in the same cycle.'''
          source: [
            '''[MIO and DIO Signal Categories](hw/top_earlgrey/ip_autogen/pinmux/doc/theory_of_operation.md#mio-and-dio-signal-categories)'''
          ]
          kind: "spec"
          testpoint: "pad_output"
          checks: ["DIO drives its peripheral (assert_PadOutput_DioDrivesItsPeripheral)"]
          why: '''The check compares each awake DIO pad's output enable with `periph_to_dio_oe_i[d]` in the same cycle, for any values that the registers hold.'''
          milestone: "V1"
          priority: "1"
          security: false
          state: "open"
        }
        {
          name: REQ_OUT_07
          desc: '''After reset and until software writes its select, MIO pad `p` shall carry the peripheral output that the top defines as the pad's reset selection. A pad with no reset selection defined shall be high-Z.'''
          source: [
            '''[MIO and DIO Signal Categories](hw/top_earlgrey/ip_autogen/pinmux/doc/theory_of_operation.md#mio-and-dio-signal-categories)'''
            '''[Pinmux Configuration](hw/top_earlgrey/ip_autogen/pinmux/doc/programmers_guide.md#pinmux-configuration)'''
            '''!!MIO_OUTSEL.OUT'''
            '''[top_earlgrey.hjson `pinmux`](hw/top_earlgrey/data/top_earlgrey.hjson)'''
            '''[top_earlgrey_pinmux.ipconfig.hjson `mio_periph_outs`](hw/top_earlgrey/ip_autogen/pinmux/data/top_earlgrey_pinmux.ipconfig.hjson)'''
          ]
          kind: "spec"
          testpoint: "reset_state"
          checks: ["pad starts at default (assert_ResetState_PadStartsAtDefault)"]
          why: '''From reset until the pad's select is written, the check compares an awake pad with the pad's default drive in every cycle. For a pad that no default names, the check requires output enable 0.'''
          milestone: "V2"
          priority: "2"
          security: false
          state: "open"
        }
        {
          name: REQ_OUT_08
          desc: '''MIO pad `p` shall be high-Z, with output enable 0 and output 0, while `MIO_OUTSEL_p` is 3 + `k` and pad `p` is not allowed for output `k`.'''
          source: [
            '''[Muxing Matrix](hw/top_earlgrey/ip_autogen/pinmux/doc/theory_of_operation.md#muxing-matrix)'''
            '''[Pinmux Configuration](hw/top_earlgrey/ip_autogen/pinmux/doc/programmers_guide.md#pinmux-configuration)'''
            '''!!MIO_OUTSEL.OUT'''
            '''[top_earlgrey_pinmux.ipconfig.hjson `mio_periph_outs`](hw/top_earlgrey/ip_autogen/pinmux/data/top_earlgrey_pinmux.ipconfig.hjson)'''
          ]
          kind: "spec"
          testpoint: "sparse_outsel"
          checks: ["unlisted output disables pad (assert_SparseOutsel_UnlistedOutputDisablesPad)", "disabled pad drives zero (assert_SparseOutsel_DisabledPadDrivesZero)"]
          why: '''While the pad's output select names an output whose pad list does not allow the pad, the checks compare the pad's `oe` and `out` with 0 in the same cycle.'''
          milestone: "V2"
          priority: "2"
          security: false
          state: "open"
        }
      ]
    }
    {
      name: '''Pad attributes'''
      conditions: [
        '''Every row holds in every cycle, whether the pad is asleep or awake.'''
        '''The rows do not hold on a JTAG pad while a TAP owns that pad.'''
        '''"Written" means a write that the register block accepts while the register's lock is open. The group Register locks gives the rules of a lock.'''
        '''"Reads back" means the value that a read of the register returns.'''
        '''A pad type "keeps" an attribute bit when the pads of that type implement the bit ([Pad Attributes](hw/top_earlgrey/ip_autogen/pinmux/doc/programmers_guide.md#pad-attributes)).'''
        '''A pad type keeps the same bits on every pad of the type, and the bits that it keeps never change. No document lists the bits that each pad type keeps, so the rows fix only that the pads of one type agree.'''
        '''A one-bit field is kept when its bit is kept, and each bit of `slew_rate` and of `drive_strength` is kept or not kept on its own ([Pad Attributes](hw/top_earlgrey/ip_autogen/pinmux/doc/programmers_guide.md#pad-attributes)).'''
      ]
      requirements: [
        {
          name: REQ_ATTR_01a
          desc: '''The `invert` field of the attribute output of MIO pad `p` shall equal the value that the `invert` field of `MIO_PAD_ATTR_p` reads back.'''
          source: [
            '''!!MIO_PAD_ATTR.invert'''
            '''[Type RW HWExt](util/reggen/README.md#type-rw-hwext)'''
            '''[Generic Pad Wrapper](hw/top_earlgrey/ip_autogen/pinmux/doc/theory_of_operation.md#generic-pad-wrapper)'''
          ]
          kind: "spec"
          testpoint: "pad_attr"
          checks: ["pad gets read-back (assert_PadAttr_PadGetsReadBack)"]
          why: '''In every cycle the check compares field `invert` of the pad's `mio_attr_o` with the read-back of `MIO_PAD_ATTR_p`.'''
          milestone: "V2"
          priority: "2"
          security: false
          state: "open"
        }
        {
          name: REQ_ATTR_01b
          desc: '''The `virtual_od_en` field of the attribute output of MIO pad `p` shall equal the value that the `virtual_od_en` field of `MIO_PAD_ATTR_p` reads back.'''
          source: [
            '''!!MIO_PAD_ATTR.virtual_od_en'''
            '''[Type RW HWExt](util/reggen/README.md#type-rw-hwext)'''
            '''[Generic Pad Wrapper](hw/top_earlgrey/ip_autogen/pinmux/doc/theory_of_operation.md#generic-pad-wrapper)'''
          ]
          kind: "spec"
          testpoint: "pad_attr"
          checks: ["pad gets read-back (assert_PadAttr_PadGetsReadBack)"]
          why: '''In every cycle the check compares field `virtual_od_en` of the pad's `mio_attr_o` with the read-back of `MIO_PAD_ATTR_p`.'''
          milestone: "V2"
          priority: "2"
          security: false
          state: "open"
        }
        {
          name: REQ_ATTR_01c
          desc: '''The `pull_en` field of the attribute output of MIO pad `p` shall equal the value that the `pull_en` field of `MIO_PAD_ATTR_p` reads back.'''
          source: [
            '''!!MIO_PAD_ATTR.pull_en'''
            '''[Type RW HWExt](util/reggen/README.md#type-rw-hwext)'''
            '''[Generic Pad Wrapper](hw/top_earlgrey/ip_autogen/pinmux/doc/theory_of_operation.md#generic-pad-wrapper)'''
          ]
          kind: "spec"
          testpoint: "pad_attr"
          checks: ["pad gets read-back (assert_PadAttr_PadGetsReadBack)"]
          why: '''In every cycle the check compares field `pull_en` of the pad's `mio_attr_o` with the read-back of `MIO_PAD_ATTR_p`.'''
          milestone: "V2"
          priority: "2"
          security: false
          state: "open"
        }
        {
          name: REQ_ATTR_01d
          desc: '''The `pull_select` field of the attribute output of MIO pad `p` shall equal the value that the `pull_select` field of `MIO_PAD_ATTR_p` reads back.'''
          source: [
            '''!!MIO_PAD_ATTR.pull_select'''
            '''[Type RW HWExt](util/reggen/README.md#type-rw-hwext)'''
            '''[Generic Pad Wrapper](hw/top_earlgrey/ip_autogen/pinmux/doc/theory_of_operation.md#generic-pad-wrapper)'''
          ]
          kind: "spec"
          testpoint: "pad_attr"
          checks: ["pad gets read-back (assert_PadAttr_PadGetsReadBack)"]
          why: '''In every cycle the check compares field `pull_select` of the pad's `mio_attr_o` with the read-back of `MIO_PAD_ATTR_p`.'''
          milestone: "V2"
          priority: "2"
          security: false
          state: "open"
        }
        {
          name: REQ_ATTR_01e
          desc: '''The `keeper_en` field of the attribute output of MIO pad `p` shall equal the value that the `keeper_en` field of `MIO_PAD_ATTR_p` reads back.'''
          source: [
            '''!!MIO_PAD_ATTR.keeper_en'''
            '''[Type RW HWExt](util/reggen/README.md#type-rw-hwext)'''
            '''[Generic Pad Wrapper](hw/top_earlgrey/ip_autogen/pinmux/doc/theory_of_operation.md#generic-pad-wrapper)'''
          ]
          kind: "spec"
          testpoint: "pad_attr"
          checks: ["pad gets read-back (assert_PadAttr_PadGetsReadBack)"]
          why: '''In every cycle the check compares field `keeper_en` of the pad's `mio_attr_o` with the read-back of `MIO_PAD_ATTR_p`.'''
          milestone: "V2"
          priority: "2"
          security: false
          state: "open"
        }
        {
          name: REQ_ATTR_01f
          desc: '''The `schmitt_en` field of the attribute output of MIO pad `p` shall equal the value that the `schmitt_en` field of `MIO_PAD_ATTR_p` reads back.'''
          source: [
            '''!!MIO_PAD_ATTR.schmitt_en'''
            '''[Type RW HWExt](util/reggen/README.md#type-rw-hwext)'''
            '''[Generic Pad Wrapper](hw/top_earlgrey/ip_autogen/pinmux/doc/theory_of_operation.md#generic-pad-wrapper)'''
          ]
          kind: "spec"
          testpoint: "pad_attr"
          checks: ["pad gets read-back (assert_PadAttr_PadGetsReadBack)"]
          why: '''In every cycle the check compares field `schmitt_en` of the pad's `mio_attr_o` with the read-back of `MIO_PAD_ATTR_p`.'''
          milestone: "V2"
          priority: "2"
          security: false
          state: "open"
        }
        {
          name: REQ_ATTR_01g
          desc: '''The `od_en` field of the attribute output of MIO pad `p` shall equal the value that the `od_en` field of `MIO_PAD_ATTR_p` reads back.'''
          source: [
            '''!!MIO_PAD_ATTR.od_en'''
            '''[Type RW HWExt](util/reggen/README.md#type-rw-hwext)'''
            '''[Generic Pad Wrapper](hw/top_earlgrey/ip_autogen/pinmux/doc/theory_of_operation.md#generic-pad-wrapper)'''
          ]
          kind: "spec"
          testpoint: "pad_attr"
          checks: ["pad gets read-back (assert_PadAttr_PadGetsReadBack)"]
          why: '''In every cycle the check compares field `od_en` of the pad's `mio_attr_o` with the read-back of `MIO_PAD_ATTR_p`.'''
          milestone: "V2"
          priority: "2"
          security: false
          state: "open"
        }
        {
          name: REQ_ATTR_01h
          desc: '''The `input_disable` field of the attribute output of MIO pad `p` shall equal the value that the `input_disable` field of `MIO_PAD_ATTR_p` reads back.'''
          source: [
            '''!!MIO_PAD_ATTR.input_disable'''
            '''[Type RW HWExt](util/reggen/README.md#type-rw-hwext)'''
            '''[Generic Pad Wrapper](hw/top_earlgrey/ip_autogen/pinmux/doc/theory_of_operation.md#generic-pad-wrapper)'''
          ]
          kind: "spec"
          testpoint: "pad_attr"
          checks: ["pad gets read-back (assert_PadAttr_PadGetsReadBack)"]
          why: '''In every cycle the check compares field `input_disable` of the pad's `mio_attr_o` with the read-back of `MIO_PAD_ATTR_p`.'''
          milestone: "V2"
          priority: "2"
          security: false
          state: "open"
        }
        {
          name: REQ_ATTR_01i
          desc: '''The `slew_rate` field of the attribute output of MIO pad `p` shall equal the value that the `slew_rate` field of `MIO_PAD_ATTR_p` reads back.'''
          source: [
            '''!!MIO_PAD_ATTR.slew_rate'''
            '''[Type RW HWExt](util/reggen/README.md#type-rw-hwext)'''
            '''[Generic Pad Wrapper](hw/top_earlgrey/ip_autogen/pinmux/doc/theory_of_operation.md#generic-pad-wrapper)'''
          ]
          kind: "spec"
          testpoint: "pad_attr"
          checks: ["pad gets read-back (assert_PadAttr_PadGetsReadBack)"]
          why: '''In every cycle the check compares both bits of field `slew_rate` of the pad's `mio_attr_o` with the read-back of `MIO_PAD_ATTR_p`.'''
          milestone: "V2"
          priority: "2"
          security: false
          state: "open"
        }
        {
          name: REQ_ATTR_01j
          desc: '''The `drive_strength` field of the attribute output of MIO pad `p` shall equal the value that the `drive_strength` field of `MIO_PAD_ATTR_p` reads back.'''
          source: [
            '''!!MIO_PAD_ATTR.drive_strength'''
            '''[Type RW HWExt](util/reggen/README.md#type-rw-hwext)'''
            '''[Generic Pad Wrapper](hw/top_earlgrey/ip_autogen/pinmux/doc/theory_of_operation.md#generic-pad-wrapper)'''
          ]
          kind: "spec"
          testpoint: "pad_attr"
          checks: ["pad gets read-back (assert_PadAttr_PadGetsReadBack)"]
          why: '''In every cycle the check compares the four bits of field `drive_strength` of the pad's `mio_attr_o` with the read-back of `MIO_PAD_ATTR_p`.'''
          milestone: "V2"
          priority: "2"
          security: false
          state: "open"
        }
        {
          name: REQ_ATTR_02a
          desc: '''The `invert` field of the attribute output of DIO pad `d` shall equal the value that the `invert` field of `DIO_PAD_ATTR_d` reads back.'''
          source: [
            '''!!DIO_PAD_ATTR.invert'''
            '''[Type RW HWExt](util/reggen/README.md#type-rw-hwext)'''
            '''[Generic Pad Wrapper](hw/top_earlgrey/ip_autogen/pinmux/doc/theory_of_operation.md#generic-pad-wrapper)'''
          ]
          kind: "spec"
          testpoint: "pad_attr"
          checks: ["pad gets read-back (assert_PadAttr_PadGetsReadBack)"]
          why: '''In every cycle the check compares field `invert` of the pad's `dio_attr_o` with the read-back of `DIO_PAD_ATTR_d`.'''
          milestone: "V2"
          priority: "2"
          security: false
          state: "open"
        }
        {
          name: REQ_ATTR_02b
          desc: '''The `virtual_od_en` field of the attribute output of DIO pad `d` shall equal the value that the `virtual_od_en` field of `DIO_PAD_ATTR_d` reads back.'''
          source: [
            '''!!DIO_PAD_ATTR.virtual_od_en'''
            '''[Type RW HWExt](util/reggen/README.md#type-rw-hwext)'''
            '''[Generic Pad Wrapper](hw/top_earlgrey/ip_autogen/pinmux/doc/theory_of_operation.md#generic-pad-wrapper)'''
          ]
          kind: "spec"
          testpoint: "pad_attr"
          checks: ["pad gets read-back (assert_PadAttr_PadGetsReadBack)"]
          why: '''In every cycle the check compares field `virtual_od_en` of the pad's `dio_attr_o` with the read-back of `DIO_PAD_ATTR_d`.'''
          milestone: "V2"
          priority: "2"
          security: false
          state: "open"
        }
        {
          name: REQ_ATTR_02c
          desc: '''The `pull_en` field of the attribute output of DIO pad `d` shall equal the value that the `pull_en` field of `DIO_PAD_ATTR_d` reads back.'''
          source: [
            '''!!DIO_PAD_ATTR.pull_en'''
            '''[Type RW HWExt](util/reggen/README.md#type-rw-hwext)'''
            '''[Generic Pad Wrapper](hw/top_earlgrey/ip_autogen/pinmux/doc/theory_of_operation.md#generic-pad-wrapper)'''
          ]
          kind: "spec"
          testpoint: "pad_attr"
          checks: ["pad gets read-back (assert_PadAttr_PadGetsReadBack)"]
          why: '''In every cycle the check compares field `pull_en` of the pad's `dio_attr_o` with the read-back of `DIO_PAD_ATTR_d`.'''
          milestone: "V2"
          priority: "2"
          security: false
          state: "open"
        }
        {
          name: REQ_ATTR_02d
          desc: '''The `pull_select` field of the attribute output of DIO pad `d` shall equal the value that the `pull_select` field of `DIO_PAD_ATTR_d` reads back.'''
          source: [
            '''!!DIO_PAD_ATTR.pull_select'''
            '''[Type RW HWExt](util/reggen/README.md#type-rw-hwext)'''
            '''[Generic Pad Wrapper](hw/top_earlgrey/ip_autogen/pinmux/doc/theory_of_operation.md#generic-pad-wrapper)'''
          ]
          kind: "spec"
          testpoint: "pad_attr"
          checks: ["pad gets read-back (assert_PadAttr_PadGetsReadBack)"]
          why: '''In every cycle the check compares field `pull_select` of the pad's `dio_attr_o` with the read-back of `DIO_PAD_ATTR_d`.'''
          milestone: "V2"
          priority: "2"
          security: false
          state: "open"
        }
        {
          name: REQ_ATTR_02e
          desc: '''The `keeper_en` field of the attribute output of DIO pad `d` shall equal the value that the `keeper_en` field of `DIO_PAD_ATTR_d` reads back.'''
          source: [
            '''!!DIO_PAD_ATTR.keeper_en'''
            '''[Type RW HWExt](util/reggen/README.md#type-rw-hwext)'''
            '''[Generic Pad Wrapper](hw/top_earlgrey/ip_autogen/pinmux/doc/theory_of_operation.md#generic-pad-wrapper)'''
          ]
          kind: "spec"
          testpoint: "pad_attr"
          checks: ["pad gets read-back (assert_PadAttr_PadGetsReadBack)"]
          why: '''In every cycle the check compares field `keeper_en` of the pad's `dio_attr_o` with the read-back of `DIO_PAD_ATTR_d`.'''
          milestone: "V2"
          priority: "2"
          security: false
          state: "open"
        }
        {
          name: REQ_ATTR_02f
          desc: '''The `schmitt_en` field of the attribute output of DIO pad `d` shall equal the value that the `schmitt_en` field of `DIO_PAD_ATTR_d` reads back.'''
          source: [
            '''!!DIO_PAD_ATTR.schmitt_en'''
            '''[Type RW HWExt](util/reggen/README.md#type-rw-hwext)'''
            '''[Generic Pad Wrapper](hw/top_earlgrey/ip_autogen/pinmux/doc/theory_of_operation.md#generic-pad-wrapper)'''
          ]
          kind: "spec"
          testpoint: "pad_attr"
          checks: ["pad gets read-back (assert_PadAttr_PadGetsReadBack)"]
          why: '''In every cycle the check compares field `schmitt_en` of the pad's `dio_attr_o` with the read-back of `DIO_PAD_ATTR_d`.'''
          milestone: "V2"
          priority: "2"
          security: false
          state: "open"
        }
        {
          name: REQ_ATTR_02g
          desc: '''The `od_en` field of the attribute output of DIO pad `d` shall equal the value that the `od_en` field of `DIO_PAD_ATTR_d` reads back.'''
          source: [
            '''!!DIO_PAD_ATTR.od_en'''
            '''[Type RW HWExt](util/reggen/README.md#type-rw-hwext)'''
            '''[Generic Pad Wrapper](hw/top_earlgrey/ip_autogen/pinmux/doc/theory_of_operation.md#generic-pad-wrapper)'''
          ]
          kind: "spec"
          testpoint: "pad_attr"
          checks: ["pad gets read-back (assert_PadAttr_PadGetsReadBack)"]
          why: '''In every cycle the check compares field `od_en` of the pad's `dio_attr_o` with the read-back of `DIO_PAD_ATTR_d`.'''
          milestone: "V2"
          priority: "2"
          security: false
          state: "open"
        }
        {
          name: REQ_ATTR_02h
          desc: '''The `input_disable` field of the attribute output of DIO pad `d` shall equal the value that the `input_disable` field of `DIO_PAD_ATTR_d` reads back.'''
          source: [
            '''!!DIO_PAD_ATTR.input_disable'''
            '''[Type RW HWExt](util/reggen/README.md#type-rw-hwext)'''
            '''[Generic Pad Wrapper](hw/top_earlgrey/ip_autogen/pinmux/doc/theory_of_operation.md#generic-pad-wrapper)'''
          ]
          kind: "spec"
          testpoint: "pad_attr"
          checks: ["pad gets read-back (assert_PadAttr_PadGetsReadBack)"]
          why: '''In every cycle the check compares field `input_disable` of the pad's `dio_attr_o` with the read-back of `DIO_PAD_ATTR_d`.'''
          milestone: "V2"
          priority: "2"
          security: false
          state: "open"
        }
        {
          name: REQ_ATTR_02i
          desc: '''The `slew_rate` field of the attribute output of DIO pad `d` shall equal the value that the `slew_rate` field of `DIO_PAD_ATTR_d` reads back.'''
          source: [
            '''!!DIO_PAD_ATTR.slew_rate'''
            '''[Type RW HWExt](util/reggen/README.md#type-rw-hwext)'''
            '''[Generic Pad Wrapper](hw/top_earlgrey/ip_autogen/pinmux/doc/theory_of_operation.md#generic-pad-wrapper)'''
          ]
          kind: "spec"
          testpoint: "pad_attr"
          checks: ["pad gets read-back (assert_PadAttr_PadGetsReadBack)"]
          why: '''In every cycle the check compares both bits of field `slew_rate` of the pad's `dio_attr_o` with the read-back of `DIO_PAD_ATTR_d`.'''
          milestone: "V2"
          priority: "2"
          security: false
          state: "open"
        }
        {
          name: REQ_ATTR_02j
          desc: '''The `drive_strength` field of the attribute output of DIO pad `d` shall equal the value that the `drive_strength` field of `DIO_PAD_ATTR_d` reads back.'''
          source: [
            '''!!DIO_PAD_ATTR.drive_strength'''
            '''[Type RW HWExt](util/reggen/README.md#type-rw-hwext)'''
            '''[Generic Pad Wrapper](hw/top_earlgrey/ip_autogen/pinmux/doc/theory_of_operation.md#generic-pad-wrapper)'''
          ]
          kind: "spec"
          testpoint: "pad_attr"
          checks: ["pad gets read-back (assert_PadAttr_PadGetsReadBack)"]
          why: '''In every cycle the check compares the four bits of field `drive_strength` of the pad's `dio_attr_o` with the read-back of `DIO_PAD_ATTR_d`.'''
          milestone: "V2"
          priority: "2"
          security: false
          state: "open"
        }
        {
          name: REQ_ATTR_03
          desc: '''The `invert` field of every pad shall read back as written.'''
          source: [
            '''[Generic Pad Wrapper](hw/top_earlgrey/ip_autogen/pinmux/doc/theory_of_operation.md#generic-pad-wrapper)'''
          ]
          kind: "spec"
          testpoint: "pad_attr"
          checks: ["invert reads back (assert_PadAttr_InvertReadsBack)"]
          why: '''On every pad type, the check compares the `invert` bit of the read-back with the `invert` bit of the pad's last attribute write. The check applies in every cycle after the pad's first attribute write.'''
          milestone: "V2"
          priority: "2"
          security: false
          state: "open"
        }
        {
          name: REQ_ATTR_05
          desc: '''The `virtual_od_en` field of a BidirStd pad or a BidirStr pad shall read back as written.'''
          source: [
            '''[Virtual open drain](hw/top_earlgrey/doc/design/README.md#virtual-open-drain)'''
            '''[top_earlgrey.hjson `pinout.pads`](hw/top_earlgrey/data/top_earlgrey.hjson)'''
          ]
          kind: "spec"
          testpoint: "pad_attr"
          checks: ["virtual open drain reads back (assert_PadAttr_VirtualOpenDrainReadsBack)"]
          why: '''On every BidirStd pad and every BidirStr pad, the check compares the `virtual_od_en` bit of the read-back with the `virtual_od_en` bit of the pad's last attribute write. The check applies in every cycle after the pad's first attribute write.'''
          milestone: "V2"
          priority: "2"
          security: false
          state: "open"
        }
        {
          name: REQ_ATTR_06
          desc: '''The `od_en` field of every pad shall read back 0.'''
          source: [
            '''[Virtual open drain](hw/top_earlgrey/doc/design/README.md#virtual-open-drain)'''
            '''[Pad Attributes](hw/top_earlgrey/ip_autogen/pinmux/doc/programmers_guide.md#pad-attributes)'''
            '''[top_earlgrey.hjson `pinout.pads`](hw/top_earlgrey/data/top_earlgrey.hjson)'''
          ]
          kind: "spec"
          testpoint: "pad_attr"
          checks: ["no open drain (assert_PadAttr_NoOpenDrain)"]
          why: '''On every pad, the check requires the `od_en` bit of the read-back to be 0 in every cycle, for any value that software wrote.'''
          milestone: "V2"
          priority: "2"
          security: false
          state: "open"
        }
        {
          name: REQ_ATTR_07
          desc: '''The `virtual_od_en` field of every pad whose type is neither BidirStd nor BidirStr shall read back 0.'''
          source: [
            '''[Virtual open drain](hw/top_earlgrey/doc/design/README.md#virtual-open-drain)'''
            '''[Pad Attributes](hw/top_earlgrey/ip_autogen/pinmux/doc/programmers_guide.md#pad-attributes)'''
            '''[top_earlgrey.hjson `pinout.pads`](hw/top_earlgrey/data/top_earlgrey.hjson)'''
          ]
          kind: "spec"
          testpoint: "pad_attr"
          checks: ["no virtual open drain elsewhere (assert_PadAttr_NoVirtualOpenDrainElsewhere)"]
          why: '''On every pad whose type is neither BidirStd nor BidirStr, the check requires the `virtual_od_en` bit of the read-back to be 0 in every cycle, for any value that software wrote.'''
          milestone: "V2"
          priority: "2"
          security: false
          state: "open"
        }
        {
          name: REQ_ATTR_08c
          desc: '''The `pull_en` field of every pad shall read back as written in each bit that the pad's type keeps.'''
          source: [
            '''!!MIO_PAD_ATTR'''
            '''[Pad Attributes](hw/top_earlgrey/ip_autogen/pinmux/doc/programmers_guide.md#pad-attributes)'''
            '''[top_earlgrey.hjson `pinout.pads`](hw/top_earlgrey/data/top_earlgrey.hjson)'''
          ]
          kind: "spec"
          testpoint: "pad_attr"
          checks: ["supported bits read back (assert_PadAttr_SupportedBitsReadBack)"]
          why: '''The check requires `pull_en` to read back a written 0 as 0. Once a written 1 in `pull_en` reads back as 1 on one pad, the check requires a written 1 to read back as 1 on every pad of the same type from that cycle on.'''
          milestone: "V2"
          priority: "2"
          security: false
          state: "open"
        }
        {
          name: REQ_ATTR_08d
          desc: '''The `pull_select` field of every pad shall read back as written in each bit that the pad's type keeps.'''
          source: [
            '''!!MIO_PAD_ATTR'''
            '''[Pad Attributes](hw/top_earlgrey/ip_autogen/pinmux/doc/programmers_guide.md#pad-attributes)'''
            '''[top_earlgrey.hjson `pinout.pads`](hw/top_earlgrey/data/top_earlgrey.hjson)'''
          ]
          kind: "spec"
          testpoint: "pad_attr"
          checks: ["supported bits read back (assert_PadAttr_SupportedBitsReadBack)"]
          why: '''The check requires `pull_select` to read back a written 0 as 0. Once a written 1 in `pull_select` reads back as 1 on one pad, the check requires a written 1 to read back as 1 on every pad of the same type from that cycle on.'''
          milestone: "V2"
          priority: "2"
          security: false
          state: "open"
        }
        {
          name: REQ_ATTR_08e
          desc: '''The `keeper_en` field of every pad shall read back as written in each bit that the pad's type keeps.'''
          source: [
            '''!!MIO_PAD_ATTR'''
            '''[Pad Attributes](hw/top_earlgrey/ip_autogen/pinmux/doc/programmers_guide.md#pad-attributes)'''
            '''[top_earlgrey.hjson `pinout.pads`](hw/top_earlgrey/data/top_earlgrey.hjson)'''
          ]
          kind: "spec"
          testpoint: "pad_attr"
          checks: ["supported bits read back (assert_PadAttr_SupportedBitsReadBack)"]
          why: '''The check requires `keeper_en` to read back a written 0 as 0. Once a written 1 in `keeper_en` reads back as 1 on one pad, the check requires a written 1 to read back as 1 on every pad of the same type from that cycle on.'''
          milestone: "V2"
          priority: "2"
          security: false
          state: "open"
        }
        {
          name: REQ_ATTR_08f
          desc: '''The `schmitt_en` field of every pad shall read back as written in each bit that the pad's type keeps.'''
          source: [
            '''!!MIO_PAD_ATTR'''
            '''[Pad Attributes](hw/top_earlgrey/ip_autogen/pinmux/doc/programmers_guide.md#pad-attributes)'''
            '''[top_earlgrey.hjson `pinout.pads`](hw/top_earlgrey/data/top_earlgrey.hjson)'''
          ]
          kind: "spec"
          testpoint: "pad_attr"
          checks: ["supported bits read back (assert_PadAttr_SupportedBitsReadBack)"]
          why: '''The check requires `schmitt_en` to read back a written 0 as 0. Once a written 1 in `schmitt_en` reads back as 1 on one pad, the check requires a written 1 to read back as 1 on every pad of the same type from that cycle on.'''
          milestone: "V2"
          priority: "2"
          security: false
          state: "open"
        }
        {
          name: REQ_ATTR_08g
          desc: '''The `input_disable` field of every pad shall read back as written in each bit that the pad's type keeps.'''
          source: [
            '''!!MIO_PAD_ATTR'''
            '''[Pad Attributes](hw/top_earlgrey/ip_autogen/pinmux/doc/programmers_guide.md#pad-attributes)'''
            '''[top_earlgrey.hjson `pinout.pads`](hw/top_earlgrey/data/top_earlgrey.hjson)'''
          ]
          kind: "spec"
          testpoint: "pad_attr"
          checks: ["supported bits read back (assert_PadAttr_SupportedBitsReadBack)"]
          why: '''The check requires `input_disable` to read back a written 0 as 0. Once a written 1 in `input_disable` reads back as 1 on one pad, the check requires a written 1 to read back as 1 on every pad of the same type from that cycle on.'''
          milestone: "V2"
          priority: "2"
          security: false
          state: "open"
        }
        {
          name: REQ_ATTR_08h
          desc: '''The `slew_rate` field of every pad shall read back as written in each bit that the pad's type keeps.'''
          source: [
            '''!!MIO_PAD_ATTR'''
            '''[Pad Attributes](hw/top_earlgrey/ip_autogen/pinmux/doc/programmers_guide.md#pad-attributes)'''
            '''[top_earlgrey.hjson `pinout.pads`](hw/top_earlgrey/data/top_earlgrey.hjson)'''
          ]
          kind: "spec"
          testpoint: "pad_attr"
          checks: ["supported bits read back (assert_PadAttr_SupportedBitsReadBack)"]
          why: '''The check requires each bit of `slew_rate` to read back a written 0 as 0. Once a written 1 in a bit reads back as 1 on one pad, the check requires the same for that bit on every pad of the same type from that cycle on.'''
          milestone: "V2"
          priority: "2"
          security: false
          state: "open"
        }
        {
          name: REQ_ATTR_08i
          desc: '''The `drive_strength` field of every pad shall read back as written in each bit that the pad's type keeps.'''
          source: [
            '''!!MIO_PAD_ATTR'''
            '''[Pad Attributes](hw/top_earlgrey/ip_autogen/pinmux/doc/programmers_guide.md#pad-attributes)'''
            '''[top_earlgrey.hjson `pinout.pads`](hw/top_earlgrey/data/top_earlgrey.hjson)'''
          ]
          kind: "spec"
          testpoint: "pad_attr"
          checks: ["supported bits read back (assert_PadAttr_SupportedBitsReadBack)"]
          why: '''The check requires each bit of `drive_strength` to read back a written 0 as 0. Once a written 1 in a bit reads back as 1 on one pad, the check requires the same for that bit on every pad of the same type from that cycle on.'''
          milestone: "V2"
          priority: "2"
          security: false
          state: "open"
        }
        {
          name: REQ_ATTR_09c
          desc: '''The `pull_en` field of every pad shall read back 0 in each bit that the pad's type does not keep.'''
          source: [
            '''[Pad Attributes](hw/top_earlgrey/ip_autogen/pinmux/doc/programmers_guide.md#pad-attributes)'''
            '''[top_earlgrey.hjson `pinout.pads`](hw/top_earlgrey/data/top_earlgrey.hjson)'''
          ]
          kind: "spec"
          testpoint: "pad_attr"
          checks: ["unsupported bits read 0 (assert_PadAttr_UnsupportedBitsRead0)"]
          why: '''The check requires `pull_en` to read back a written 0 as 0. Once a written 1 in `pull_en` reads back as 0 on one pad, the check requires `pull_en` to read 0 on every pad of the same type from that cycle on.'''
          milestone: "V2"
          priority: "2"
          security: false
          state: "open"
        }
        {
          name: REQ_ATTR_09d
          desc: '''The `pull_select` field of every pad shall read back 0 in each bit that the pad's type does not keep.'''
          source: [
            '''[Pad Attributes](hw/top_earlgrey/ip_autogen/pinmux/doc/programmers_guide.md#pad-attributes)'''
            '''[top_earlgrey.hjson `pinout.pads`](hw/top_earlgrey/data/top_earlgrey.hjson)'''
          ]
          kind: "spec"
          testpoint: "pad_attr"
          checks: ["unsupported bits read 0 (assert_PadAttr_UnsupportedBitsRead0)"]
          why: '''The check requires `pull_select` to read back a written 0 as 0. Once a written 1 in `pull_select` reads back as 0 on one pad, the check requires `pull_select` to read 0 on every pad of the same type from that cycle on.'''
          milestone: "V2"
          priority: "2"
          security: false
          state: "open"
        }
        {
          name: REQ_ATTR_09e
          desc: '''The `keeper_en` field of every pad shall read back 0 in each bit that the pad's type does not keep.'''
          source: [
            '''[Pad Attributes](hw/top_earlgrey/ip_autogen/pinmux/doc/programmers_guide.md#pad-attributes)'''
            '''[top_earlgrey.hjson `pinout.pads`](hw/top_earlgrey/data/top_earlgrey.hjson)'''
          ]
          kind: "spec"
          testpoint: "pad_attr"
          checks: ["unsupported bits read 0 (assert_PadAttr_UnsupportedBitsRead0)"]
          why: '''The check requires `keeper_en` to read back a written 0 as 0. Once a written 1 in `keeper_en` reads back as 0 on one pad, the check requires `keeper_en` to read 0 on every pad of the same type from that cycle on.'''
          milestone: "V2"
          priority: "2"
          security: false
          state: "open"
        }
        {
          name: REQ_ATTR_09f
          desc: '''The `schmitt_en` field of every pad shall read back 0 in each bit that the pad's type does not keep.'''
          source: [
            '''[Pad Attributes](hw/top_earlgrey/ip_autogen/pinmux/doc/programmers_guide.md#pad-attributes)'''
            '''[top_earlgrey.hjson `pinout.pads`](hw/top_earlgrey/data/top_earlgrey.hjson)'''
          ]
          kind: "spec"
          testpoint: "pad_attr"
          checks: ["unsupported bits read 0 (assert_PadAttr_UnsupportedBitsRead0)"]
          why: '''The check requires `schmitt_en` to read back a written 0 as 0. Once a written 1 in `schmitt_en` reads back as 0 on one pad, the check requires `schmitt_en` to read 0 on every pad of the same type from that cycle on.'''
          milestone: "V2"
          priority: "2"
          security: false
          state: "open"
        }
        {
          name: REQ_ATTR_09g
          desc: '''The `input_disable` field of every pad shall read back 0 in each bit that the pad's type does not keep.'''
          source: [
            '''[Pad Attributes](hw/top_earlgrey/ip_autogen/pinmux/doc/programmers_guide.md#pad-attributes)'''
            '''[top_earlgrey.hjson `pinout.pads`](hw/top_earlgrey/data/top_earlgrey.hjson)'''
          ]
          kind: "spec"
          testpoint: "pad_attr"
          checks: ["unsupported bits read 0 (assert_PadAttr_UnsupportedBitsRead0)"]
          why: '''The check requires `input_disable` to read back a written 0 as 0. Once a written 1 in `input_disable` reads back as 0 on one pad, the check requires `input_disable` to read 0 on every pad of the same type from that cycle on.'''
          milestone: "V2"
          priority: "2"
          security: false
          state: "open"
        }
        {
          name: REQ_ATTR_09h
          desc: '''The `slew_rate` field of every pad shall read back 0 in each bit that the pad's type does not keep.'''
          source: [
            '''[Pad Attributes](hw/top_earlgrey/ip_autogen/pinmux/doc/programmers_guide.md#pad-attributes)'''
            '''[top_earlgrey.hjson `pinout.pads`](hw/top_earlgrey/data/top_earlgrey.hjson)'''
          ]
          kind: "spec"
          testpoint: "pad_attr"
          checks: ["unsupported bits read 0 (assert_PadAttr_UnsupportedBitsRead0)"]
          why: '''The check requires each bit of `slew_rate` to read back a written 0 as 0. Once a written 1 in a bit reads back as 0 on one pad, the check requires that bit to read 0 on every pad of the same type from that cycle on.'''
          milestone: "V2"
          priority: "2"
          security: false
          state: "open"
        }
        {
          name: REQ_ATTR_09i
          desc: '''The `drive_strength` field of every pad shall read back 0 in each bit that the pad's type does not keep.'''
          source: [
            '''[Pad Attributes](hw/top_earlgrey/ip_autogen/pinmux/doc/programmers_guide.md#pad-attributes)'''
            '''[top_earlgrey.hjson `pinout.pads`](hw/top_earlgrey/data/top_earlgrey.hjson)'''
          ]
          kind: "spec"
          testpoint: "pad_attr"
          checks: ["unsupported bits read 0 (assert_PadAttr_UnsupportedBitsRead0)"]
          why: '''The check requires each bit of `drive_strength` to read back a written 0 as 0. Once a written 1 in a bit reads back as 0 on one pad, the check requires that bit to read 0 on every pad of the same type from that cycle on.'''
          milestone: "V2"
          priority: "2"
          security: false
          state: "open"
        }
        {
          name: REQ_ATTR_10
          desc: '''After reset, each pad's attribute output shall be the reset value of the pad's entry in the top's configuration, and all 0 for a pad whose entry sets no attribute. Fields that the pad's type does not keep shall be 0.'''
          source: [
            '''!!MIO_PAD_ATTR'''
            '''!!DIO_PAD_ATTR'''
            '''[top_earlgrey.hjson `pinout`](hw/top_earlgrey/data/top_earlgrey.hjson)'''
            '''[top_earlgrey_pinmux.ipconfig.hjson `mio_pad_attr_resvals`](hw/top_earlgrey/ip_autogen/pinmux/data/top_earlgrey_pinmux.ipconfig.hjson)'''
            '''[top_earlgrey_pinmux.ipconfig.hjson `dio_pad_attr_resvals`](hw/top_earlgrey/ip_autogen/pinmux/data/top_earlgrey_pinmux.ipconfig.hjson)'''
          ]
          kind: "spec"
          testpoint: "pad_attr"
          checks: ["reset attributes (assert_PadAttr_ResetAttributes)"]
          why: '''Until the pad's first attribute write after reset, the check compares the pad's attribute output with the attribute reset value that the top's configuration gives the pad. The fields that the pad's type does not keep are 0.'''
          milestone: "V2"
          priority: "2"
          security: false
          state: "open"
        }
      ]
    }
    {
      name: '''Sleep retention'''
      conditions: [
        '''In these rows, a pad is any MIO pad `p` or any DIO pad `d`.'''
        '''A pad's status bit is the pad's bit in `MIO_PAD_SLEEP_STATUS` or in `DIO_PAD_SLEEP_STATUS`.'''
        '''Sleep entry is a rise of `sleep_en_i` from 0 to 1.'''
        '''The rows for sleep modes 0 to 3 hold while no TAP owns the pad and the pad's sleep mode has not changed since sleep entry.'''
      ]
      requirements: [
        {
          name: REQ_SLP_01
          desc: '''At sleep entry, the status bit of every pad whose sleep enable is 1 shall become 1. `REQ_SLP_09` states the one exception, in which a software clear of that bit lands in the same cycle.'''
          source: [
            '''!!MIO_PAD_SLEEP_EN.EN'''
            '''[Sleep Features](hw/top_earlgrey/ip_autogen/pinmux/doc/programmers_guide.md#sleep-features)'''
          ]
          kind: "spec"
          testpoint: "pad_sleep"
          checks: ["bit set at entry (assert_PadSleep_BitSetAtEntry)"]
          why: '''At every sleep entry in which the pad's sleep enable is 1 and software does not clear the status bit in that cycle, the check requires the bit to be 1 in the next cycle.'''
          milestone: "V2"
          priority: "2"
          security: false
          state: "open"
        }
        {
          name: REQ_SLP_02
          desc: '''A status bit shall become 1 only at sleep entry, and only if the pad's sleep enable is 1.'''
          source: [
            '''!!MIO_PAD_SLEEP_STATUS.EN'''
            '''[Sleep Features](hw/top_earlgrey/ip_autogen/pinmux/doc/programmers_guide.md#sleep-features)'''
          ]
          kind: "spec"
          testpoint: "pad_sleep"
          checks: ["bit set only at entry (assert_PadSleep_BitSetOnlyAtEntry)"]
          why: '''Whenever a status bit rises from 0 to 1, the check requires the cycle before to be a sleep entry in which the pad's sleep enable is 1.'''
          milestone: "V2"
          priority: "2"
          security: false
          state: "open"
        }
        {
          name: REQ_SLP_03a
          desc: '''While a pad is asleep and its sleep mode is 0, the pad's output shall be 0.'''
          source: [
            '''!!MIO_PAD_SLEEP_MODE.OUT'''
            '''[Sleep Features](hw/top_earlgrey/ip_autogen/pinmux/doc/programmers_guide.md#sleep-features)'''
          ]
          kind: "spec"
          testpoint: "pad_sleep"
          checks: ["tie low in sleep (assert_PadSleep_TieLowInSleep)"]
          why: '''While a pad's status bit is 1 and its sleep mode was 0 at the sleep entry, the check compares the pad's output with 0 in the same cycle. The check skips every cycle in which a TAP owns the pad.'''
          milestone: "V2"
          priority: "2"
          security: false
          state: "open"
        }
        {
          name: REQ_SLP_03b
          desc: '''While a pad is asleep and its sleep mode is 0, the pad's output enable shall be 1, so the pad drives 0.'''
          source: [
            '''!!MIO_PAD_SLEEP_MODE.OUT'''
            '''[Sleep Features](hw/top_earlgrey/ip_autogen/pinmux/doc/programmers_guide.md#sleep-features)'''
          ]
          kind: "spec"
          testpoint: "pad_sleep"
          checks: ["tie low in sleep (assert_PadSleep_TieLowInSleep)"]
          why: '''While a pad's status bit is 1 and its sleep mode was 0 at the sleep entry, the check compares the pad's output enable with 1. The check skips every cycle in which a TAP owns the pad.'''
          milestone: "V2"
          priority: "2"
          security: false
          state: "open"
        }
        {
          name: REQ_SLP_04a
          desc: '''While a pad is asleep and its sleep mode is 1, the pad's output shall be 1.'''
          source: [
            '''!!MIO_PAD_SLEEP_MODE.OUT'''
          ]
          kind: "spec"
          testpoint: "pad_sleep"
          checks: ["tie high in sleep (assert_PadSleep_TieHighInSleep)"]
          why: '''While a pad's status bit is 1 and its sleep mode was 1 at the sleep entry, the check compares the pad's output with 1 in the same cycle. The check skips every cycle in which a TAP owns the pad.'''
          milestone: "V2"
          priority: "2"
          security: false
          state: "open"
        }
        {
          name: REQ_SLP_04b
          desc: '''While a pad is asleep and its sleep mode is 1, the pad's output enable shall be 1, so the pad drives 1.'''
          source: [
            '''!!MIO_PAD_SLEEP_MODE.OUT'''
          ]
          kind: "spec"
          testpoint: "pad_sleep"
          checks: ["tie high in sleep (assert_PadSleep_TieHighInSleep)"]
          why: '''While a pad's status bit is 1 and its sleep mode was 1 at the sleep entry, the check compares the pad's output enable with 1. The check skips every cycle in which a TAP owns the pad.'''
          milestone: "V2"
          priority: "2"
          security: false
          state: "open"
        }
        {
          name: REQ_SLP_05a
          desc: '''While a pad is asleep and its sleep mode is 2, the pad's output enable shall be 0, so the pad is high-Z.'''
          source: [
            '''!!MIO_PAD_SLEEP_MODE.OUT'''
          ]
          kind: "spec"
          testpoint: "pad_sleep"
          checks: ["high-Z in sleep (assert_PadSleep_HighZInSleep)"]
          why: '''While a pad's status bit is 1 and its sleep mode was 2 at the sleep entry, the check compares the pad's output enable with 0 in the same cycle. The check skips every cycle in which a TAP owns the pad.'''
          milestone: "V2"
          priority: "2"
          security: false
          state: "open"
        }
        {
          name: REQ_SLP_05b
          desc: '''While a pad is asleep and its sleep mode is 2, the pad's output shall be 0.'''
          source: [
            '''!!MIO_PAD_SLEEP_MODE.OUT'''
          ]
          kind: "spec"
          testpoint: "pad_sleep"
          checks: ["high-Z in sleep (assert_PadSleep_HighZInSleep)"]
          why: '''While a pad's status bit is 1 and its sleep mode was 2 at the sleep entry, the check compares the pad's output with 0. The check skips every cycle in which a TAP owns the pad.'''
          milestone: "V2"
          priority: "2"
          security: false
          state: "open"
        }
        {
          name: REQ_SLP_06a
          desc: '''While a pad is asleep and its sleep mode is 3, the pad shall keep the output that it drove in the last cycle before its status bit became 1.'''
          source: [
            '''!!MIO_PAD_SLEEP_MODE.OUT'''
            '''[Retention Logic](hw/top_earlgrey/ip_autogen/pinmux/doc/theory_of_operation.md#retention-logic)'''
          ]
          kind: "spec"
          testpoint: "pad_sleep"
          checks: ["keep holds (assert_PadSleep_KeepHolds)"]
          why: '''While a pad's status bit is 1 and its sleep mode was 3 at the sleep entry that set the bit, the check compares the pad's output with its output in that entry cycle. The check applies only if no TAP owned the pad then and no TAP owns it now.'''
          milestone: "V2"
          priority: "2"
          security: false
          state: "open"
        }
        {
          name: REQ_SLP_06b
          desc: '''While a pad is asleep and its sleep mode is 3, the pad shall keep the output enable that it drove in the last cycle before its status bit became 1.'''
          source: [
            '''!!MIO_PAD_SLEEP_MODE.OUT'''
            '''[Retention Logic](hw/top_earlgrey/ip_autogen/pinmux/doc/theory_of_operation.md#retention-logic)'''
          ]
          kind: "spec"
          testpoint: "pad_sleep"
          checks: ["keep holds (assert_PadSleep_KeepHolds)"]
          why: '''While a pad's status bit is 1 and its sleep mode was 3 at the sleep entry that set the bit, the check compares the pad's output enable with its enable in that entry cycle. The check applies only if no TAP owned the pad then and no TAP owns it now.'''
          milestone: "V2"
          priority: "2"
          security: false
          state: "open"
        }
        {
          name: REQ_SLP_07
          desc: '''Once a status bit is 1, the bit shall stay 1 until software writes 0 to it. The rule holds at every value of `sleep_en_i` and of the pad's sleep enable, and for every value that the peripheral drives.'''
          source: [
            '''!!MIO_PAD_SLEEP_STATUS.EN'''
            '''[Retention Logic](hw/top_earlgrey/ip_autogen/pinmux/doc/theory_of_operation.md#retention-logic)'''
          ]
          kind: "spec"
          testpoint: "pad_sleep"
          checks: ["bit holds until cleared (assert_PadSleep_BitHoldsUntilCleared)", "clear releases (assert_PadSleep_ClearReleases)"]
          why: '''If software does not clear a status bit at 1 in a cycle, the check _bit holds until cleared_ requires the bit to be 1 in the next cycle. The check _clear releases_ requires the bit to be 0 in the cycle after a clear.'''
          milestone: "V2"
          priority: "2"
          security: false
          state: "open"
        }
        {
          name: REQ_SLP_08
          desc: '''While an MIO pad is awake, the pad shall drive what its output select names. While a DIO pad is awake, the pad shall drive the output and output enable of its own peripheral.'''
          source: [
            '''[Retention Logic](hw/top_earlgrey/ip_autogen/pinmux/doc/theory_of_operation.md#retention-logic)'''
            '''[Sleep Features](hw/top_earlgrey/ip_autogen/pinmux/doc/programmers_guide.md#sleep-features)'''
          ]
          kind: "spec"
          testpoint: "sleep_release"
          checks: ["tie 0 drives 0 (assert_PadOutput_Tie0Drives0)", "tie 1 drives 1 (assert_PadOutput_Tie1Drives1)", "select 2 is high-Z (assert_PadOutput_Select2IsHighZ)", "drives selected output (assert_PadOutput_DrivesSelectedOutput)", "select without an output is high-Z (assert_PadOutput_SelectWithoutAnOutputIsHighZ)", "DIO drives its peripheral (assert_PadOutput_DioDrivesItsPeripheral)"]
          why: '''Each of these checks compares the pad's drive with its selected drive in every cycle in which the pad's status bit is 0.'''
          milestone: "V2"
          priority: "2"
          security: false
          state: "open"
        }
        {
          name: REQ_SLP_09
          desc: '''When sleep entry sets a status bit in the cycle that software writes 0 to that bit, the bit shall end at 0. The software clear has precedence over sleep entry.'''
          source: [
            '''!!MIO_PAD_SLEEP_STATUS'''
            '''[Type RW](util/reggen/README.md#type-rw)'''
            '''[Simultaneous SW and HW access](util/reggen/README.md#simultaneous-sw-and-hw-access)'''
          ]
          kind: "spec"
          testpoint: "pad_sleep"
          checks: ["clear wins (assert_PadSleep_ClearWins)"]
          why: '''When a sleep entry with the pad's sleep enable at 1 falls in the same cycle as a software clear of the status bit, the check requires the bit to be 0 in the next cycle.'''
          milestone: "V2"
          priority: "2"
          security: false
          state: "open"
        }
        {
          name: REQ_SLP_10a
          desc: '''A write to a pad's sleep mode while the pad is asleep shall leave the pad as it is.'''
          source: [
            '''[Retention Logic](hw/top_earlgrey/ip_autogen/pinmux/doc/theory_of_operation.md#retention-logic)'''
            '''[Sleep Features](hw/top_earlgrey/ip_autogen/pinmux/doc/programmers_guide.md#sleep-features)'''
          ]
          kind: "spec"
          testpoint: "pad_sleep"
          checks: ["mode write while held (assert_PadSleep_ModeWriteWhileHeld)"]
          why: '''After software writes the pad's sleep mode while the status bit is 1, the check requires the pad to keep the sleep value of the mode taken at the sleep entry.'''
          milestone: "V2"
          priority: "2"
          security: false
          state: "open"
        }
        {
          name: REQ_SLP_10b
          desc: '''After a write to a pad's sleep mode while the pad is asleep, the new mode shall take effect at the next sleep entry.'''
          source: [
            '''[Retention Logic](hw/top_earlgrey/ip_autogen/pinmux/doc/theory_of_operation.md#retention-logic)'''
            '''[Sleep Features](hw/top_earlgrey/ip_autogen/pinmux/doc/programmers_guide.md#sleep-features)'''
          ]
          kind: "spec"
          testpoint: "pad_sleep"
          checks: ["tie low in sleep (assert_PadSleep_TieLowInSleep)", "tie high in sleep (assert_PadSleep_TieHighInSleep)", "high-Z in sleep (assert_PadSleep_HighZInSleep)", "keep holds (assert_PadSleep_KeepHolds)", "the CSR checker"]
          why: '''Each of the four sleep mode checks uses the sleep mode that the pad had at the sleep entry. The CSR checker checks that the register keeps the written mode.'''
          milestone: "V2"
          priority: "2"
          security: false
          state: "open"
        }
      ]
    }
    {
      name: '''Register locks'''
      conditions: [
        '''A "lock" is one bit of a `*_REGWEN` register. Each lock locks the registers that have the same index. A lock is open while it is 1 and closed while it is 0.'''
        '''The rule that a locked pad's attribute output does not change (`REQ_LOCK_03a`) holds on every pad, except on a JTAG pad while a TAP owns that pad. The rule for the value that software reads (`REQ_LOCK_03b`) holds on every pad.'''
      ]
      requirements: [
        {
          name: REQ_LOCK_01a
          desc: '''Every lock shall read 1 after reset.'''
          source: [
            '''the register description: the `EN` field of each `*_REGWEN`, for example !!MIO_PAD_ATTR_REGWEN.EN `resval: "1"`, on `clk_i` with `rst_ni` ([pinmux.hjson `clocking`](hw/top_earlgrey/ip_autogen/pinmux/data/pinmux.hjson))'''
            '''[Configuration and Register Definition File Format](util/reggen/README.md#configuration-and-register-definition-file-format)'''
          ]
          kind: "spec"
          testpoint: "register_block"
          checks: ["the CSR checker"]
          why: '''After reset, the CSR checker expects every lock to be 1, and compares the lock's value and each read of it with 1. Bit 31 of `ALERT_TEST` locks the alert test in the same way, and the CSR checker expects it to be 1 after reset too.'''
          milestone: "V2"
          priority: "2"
          security: true
          state: "open"
        }
        {
          name: REQ_LOCK_01b
          desc: '''Once software writes 0 to a lock, the lock shall stay 0 until reset.'''
          source: [
            '''[Configuration and Register Definition File Format](util/reggen/README.md#configuration-and-register-definition-file-format)'''
            '''[Pad Attributes](hw/top_earlgrey/ip_autogen/pinmux/doc/programmers_guide.md#pad-attributes)'''
          ]
          kind: "spec"
          testpoint: "register_block"
          checks: ["the CSR checker"]
          why: '''The CSR checker predicts each lock as an `rw0c` field. In that prediction, an accepted write of 0 clears the lock and nothing sets it. A lock that returns to 1 before a reset fails the comparison.'''
          milestone: "V2"
          priority: "2"
          security: true
          state: "open"
        }
        {
          name: REQ_LOCK_01c
          desc: '''A write of 1 to a lock that is 0 shall not reopen it.'''
          source: [
            '''the register description: each lock `rw0c`'''
            '''[Configuration and Register Definition File Format](util/reggen/README.md#configuration-and-register-definition-file-format)'''
            '''[Pinmux Configuration](hw/top_earlgrey/ip_autogen/pinmux/doc/programmers_guide.md#pinmux-configuration)'''
          ]
          kind: "spec"
          testpoint: "register_block"
          checks: ["the CSR checker"]
          why: '''The CSR checker predicts each lock as an `rw0c` field, so a closed lock stays 0 on a write of 1. A lock that such a write reopens fails the comparison.'''
          milestone: "V2"
          priority: "2"
          security: true
          state: "open"
        }
        {
          name: REQ_LOCK_02
          desc: '''While a lock is 0, a write to a register it locks shall leave that register unchanged.'''
          source: [
            '''!!MIO_PERIPH_INSEL_REGWEN.EN'''
            '''[Configuration and Register Definition File Format](util/reggen/README.md#configuration-and-register-definition-file-format)'''
          ]
          kind: "spec"
          testpoint: "register_block"
          checks: ["locked read-back holds (assert_Regwen_LockedReadBackHolds)", "the CSR checker"]
          why: '''The CSR checker predicts that a register whose lock reads 0 keeps its value over every write. For the attribute registers, the check _locked read-back holds_ requires the read-back to stay unchanged while the lock reads 0.'''
          milestone: "V2"
          priority: "2"
          security: true
          state: "open"
        }
        {
          name: REQ_LOCK_03a
          desc: '''While a pad's attribute lock is 0, the pad's attribute output shall not change.'''
          source: [
            '''!!MIO_PAD_ATTR_REGWEN.EN'''
            '''[Pad Attributes](hw/top_earlgrey/ip_autogen/pinmux/doc/programmers_guide.md#pad-attributes)'''
          ]
          kind: "spec"
          testpoint: "regwen"
          checks: ["locked attribute holds (assert_Regwen_LockedAttributeHolds)"]
          why: '''While the attribute lock of a pad is closed, the check requires the pad's attribute output to keep its value from each cycle to the next. The check covers every pad that no TAP owns.'''
          milestone: "V2"
          priority: "2"
          security: true
          state: "open"
        }
        {
          name: REQ_LOCK_03b
          desc: '''While a pad's attribute lock is 0, the value that software reads from the pad's attribute register shall not change.'''
          source: [
            '''!!MIO_PAD_ATTR_REGWEN.EN'''
            '''[Pad Attributes](hw/top_earlgrey/ip_autogen/pinmux/doc/programmers_guide.md#pad-attributes)'''
          ]
          kind: "spec"
          testpoint: "regwen"
          checks: ["locked read-back holds (assert_Regwen_LockedReadBackHolds)"]
          why: '''While the attribute lock of a pad is closed, the check requires the pad's read-back to keep its value from each cycle to the next. The check covers every pad, including a JTAG pad that a TAP owns.'''
          milestone: "V2"
          priority: "2"
          security: true
          state: "open"
        }
      ]
    }
    {
      name: '''Register block and bus'''
      conditions: [
        '''A "failed request" is a request whose command integrity code does not match, or whose data integrity code does not match ([Usage of User Bits](hw/ip/tlul/README.md#usage-of-user-bits)). No document says whether the data integrity code of a read is checked, because that code covers the write data ([Usage of User Bits](hw/ip/tlul/README.md#usage-of-user-bits)). These rows follow the design, which checks the data integrity code of every request.'''
        '''The pinmux's alert sender answers a ping of the alert handler with an alert event, which is a full handshake on the alert and acknowledge pairs. The alert handler takes that handshake as the answer to its ping ([Ping Testing](hw/top_earlgrey/ip_autogen/alert_handler/doc/theory_of_operation.md#ping-testing)).'''
        '''The "in-band reset" is the alert handler's re-initialization. During the in-band reset, the alert handler puts a signal integrity error on its ping and acknowledge pairs on purpose ([Employed Solution](hw/top_earlgrey/ip_autogen/alert_handler/doc/theory_of_operation.md#employed-solution)).'''
        '''A request has an "illegal combination of address, size and mask" when its address is not aligned to its size, when its size is greater than 2, or when its mask has a bit set outside the access. A `PutFullData` request also has an illegal combination when the mask bit of a lane inside the access is 0.'''
      ]
      requirements: [
        {
          name: REQ_REG_01a
          desc: '''Every register field shall behave as its access type requires on each software read or write that is answered without an error. This row covers a write only while the field's lock reads 1, or when the field has no lock.'''
          source: [
            '''the register description: each field's `swaccess`, for example !!MIO_PAD_SLEEP_STATUS `swaccess: "rw0c"`'''
            '''[Configuration and Register Definition File Format](util/reggen/README.md#configuration-and-register-definition-file-format)'''
          ]
          kind: "spec"
          testpoint: "register_block"
          checks: ["read-back changes only on a write (assert_PadAttr_ReadBackChangesOnlyOnAWrite)", "the CSR checker"]
          why: '''For the attribute registers, the check _read-back changes only on a write_ allows a read-back to change only in the cycle after an attribute write. The CSR checker predicts each field from its access type.'''
          milestone: "V2"
          priority: "2"
          security: true
          state: "open"
        }
        {
          name: REQ_REG_01b
          desc: '''After reset, every register field shall read the reset value that the register description gives the field.'''
          source: [
            '''the register description: each field's `resval`, for example !!MIO_PAD_SLEEP_STATUS.EN `resval: "0"`'''
            '''[Configuration and Register Definition File Format](util/reggen/README.md#configuration-and-register-definition-file-format)'''
          ]
          kind: "spec"
          testpoint: "register_block"
          checks: ["the CSR checker"]
          why: '''After reset, the CSR checker requires each field to hold its reset value. The check _reset attributes_ covers the reset values of the attribute registers.'''
          milestone: "V2"
          priority: "2"
          security: true
          state: "open"
        }
        {
          name: REQ_BUS_01a
          desc: '''The pinmux shall answer every request with one response, and only one.'''
          source: [
            '''TileLink 1.9.3 p. 39: "Receipt of request messages must result in the eventual receipt of a response message by the requestor."; p. 30: "it is illegal to receive a response without receiving the request."; p. 46: "In TL-UL, every message fits within a single beat"'''
            '''No specification states the limit of one response per request.'''
          ]
          kind: "spec"
          testpoint: "bus"
          checks: ["device rules (assert_Bus_DeviceRules)"]
          why: '''The check uses the device rules of the TL-UL ABVIP on the pinmux's port. These rules match each response to one open request.'''
          milestone: "V2"
          priority: "2"
          security: true
          state: "open"
        }
        {
          name: REQ_BUS_01b
          desc: '''The pinmux shall answer every request with a response that follows the TL-UL rules and carries the source ID of the request.'''
          source: [
            '''[Source ID requirements for device elements](hw/ip/tlul/README.md#source-id-requirements-for-device-elements)'''
          ]
          kind: "spec"
          testpoint: "bus"
          checks: ["device rules (assert_Bus_DeviceRules)"]
          why: '''The check uses the device rules of the TL-UL ABVIP on the pinmux's port. These rules compare the `d_source` of each response with the `a_source` of its request.'''
          milestone: "V2"
          priority: "2"
          security: true
          state: "open"
        }
        {
          name: REQ_BUS_01c
          desc: '''A request shall receive an error response only if it is a failed request, a request that one of `REQ_BUS_10a` to `REQ_BUS_10d` describes, or a request to an address that no register maps.'''
          source: [
            '''[Explicit Error Cases](hw/ip/tlul/README.md#explicit-error-cases)'''
            '''[Error responses](util/reggen/README.md#error-responses)'''
            '''No specification states the error on a read whose only mismatch is in its data integrity code, and the error on an address that is not aligned to the request's size.'''
          ]
          kind: "spec"
          testpoint: "bus"
          checks: ["errors as the register checker predicts", "the CSR checker"]
          why: '''For every request that is not a failed request, the error checks of the CSR checker require `d_error` to be 1 exactly when the request has one of the listed causes.'''
          milestone: "V2"
          priority: "2"
          security: true
          state: "open"
        }
        {
          name: REQ_BUS_02a
          desc: '''Every response shall carry the response integrity code, which is computed over the op code, the size and the error of that response.'''
          source: [
            '''[Usage of User Bits](hw/ip/tlul/README.md#usage-of-user-bits)'''
            '''[pinmux.hjson `countermeasures` BUS.INTEGRITY](hw/top_earlgrey/ip_autogen/pinmux/data/pinmux.hjson)'''
            '''No specification states the encoding of the response integrity code.'''
          ]
          kind: "spec"
          testpoint: "bus"
          checks: ["response codes correct (assert_Bus_ResponseCodesCorrect)"]
          why: '''For each response, the check recomputes the response code from the response's opcode, size and error with the integrity functions of `tlul_pkg`. The check then compares the result with the response code that the pinmux sends.'''
          milestone: "V2"
          priority: "2"
          security: true
          state: "open"
        }
        {
          name: REQ_BUS_02b
          desc: '''Every response shall carry the data integrity code, which is computed over the data of that response.'''
          source: [
            '''[Usage of User Bits](hw/ip/tlul/README.md#usage-of-user-bits)'''
            '''[pinmux.hjson `countermeasures` BUS.INTEGRITY](hw/top_earlgrey/ip_autogen/pinmux/data/pinmux.hjson)'''
            '''No specification states the encoding of the data integrity code.'''
          ]
          kind: "spec"
          testpoint: "bus"
          checks: ["response codes correct (assert_Bus_ResponseCodesCorrect)"]
          why: '''For each response, the check recomputes the data code over the response data with the integrity functions of `tlul_pkg`. The check then compares the result with the data code that the pinmux sends.'''
          milestone: "V2"
          priority: "2"
          security: true
          state: "open"
        }
        {
          name: REQ_BUS_03
          desc: '''A failed request shall receive an error response.'''
          source: [
            '''[Usage of User Bits](hw/ip/tlul/README.md#usage-of-user-bits)'''
            '''[cip_base_vseq](hw/dv/sv/cip_lib/README.md#cip_base_vseq)'''
          ]
          kind: "RTL"
          testpoint: "bus"
          checks: ["failed request errors (assert_Bus_FailedRequestErrors)"]
          why: '''The check requires `d_error` to be 1 on the response to every failed request.'''
          milestone: "V2"
          priority: "2"
          security: true
          state: "open"
        }
        {
          name: REQ_BUS_04
          desc: '''A write that is a failed request shall change no register.'''
          source: [
            '''[Usage of User Bits](hw/ip/tlul/README.md#usage-of-user-bits)'''
          ]
          kind: "RTL"
          testpoint: "bus"
          checks: ["failed write changes nothing (assert_Bus_FailedWriteChangesNothing)"]
          why: '''The check requires every register to keep its value over a failed write. The one exception is an AON field that is still taking an earlier write, which has not landed yet.'''
          milestone: "V2"
          priority: "2"
          security: true
          state: "open"
        }
        {
          name: REQ_BUS_05
          desc: '''Outside the alert handler's in-band reset, a failed request shall raise the fatal alert `fatal_fault`.'''
          source: [
            '''[pinmux.hjson `alert_list` fatal_fault](hw/top_earlgrey/ip_autogen/pinmux/data/pinmux.hjson)'''
            '''[Employed Solution](hw/top_earlgrey/ip_autogen/alert_handler/doc/theory_of_operation.md#employed-solution)'''
            '''No specification states the alert for a read whose only mismatch is in its data integrity code.'''
          ]
          kind: "spec"
          testpoint: "alert"
          checks: ["failed request alerts (assert_Alert_FailedRequestAlerts)"]
          why: '''The check requires an alert event on `alert_tx_o` within 40 cycles of every failed request.'''
          milestone: "V2S"
          priority: "2"
          security: true
          state: "open"
        }
        {
          name: REQ_BUS_06
          desc: '''Outside the alert handler's in-band reset, the pinmux shall send the fatal alert repeatedly from the time it is raised until reset.'''
          source: [
            '''[Alerts per Module](doc/contributing/hw/comportability/README.md#alerts-per-module)'''
            '''[Employed Solution](hw/top_earlgrey/ip_autogen/alert_handler/doc/theory_of_operation.md#employed-solution)'''
          ]
          kind: "spec"
          testpoint: "alert"
          checks: ["fatal alert repeats (assert_Alert_FatalAlertRepeats)"]
          why: '''After a failed request and until reset, the check requires every cycle to be followed by an alert event within 40 cycles.'''
          milestone: "V2S"
          priority: "2"
          security: true
          state: "open"
        }
        {
          name: REQ_BUS_07
          desc: '''While bit 31 of `ALERT_TEST` is 1, a write of 1 to bit 0 of `ALERT_TEST` that is answered without an error shall send one alert event. The rule applies only outside the alert handler's in-band reset.'''
          source: [
            '''The register page says of bit 0: "Write 1 to trigger one alert event of this kind." (!!ALERT_TEST)'''
            '''[Test Alert Register Creation](doc/contributing/hw/comportability/README.md#test-alert-register-creation)'''
            '''[Employed Solution](hw/top_earlgrey/ip_autogen/alert_handler/doc/theory_of_operation.md#employed-solution)'''
          ]
          kind: "spec"
          testpoint: "alert"
          checks: ["test sends an event (assert_Alert_TestSendsAnEvent)", "no alert without a cause (assert_Alert_NoAlertWithoutACause)"]
          why: '''The check _test sends an event_ requires an alert event within 40 cycles of each alert test. In the check _no alert without a cause_, each alert test allows one alert event, so one test gives one event.'''
          milestone: "V2S"
          priority: "2"
          security: true
          state: "open"
        }
        {
          name: REQ_BUS_08
          desc: '''While bit 31 of `ALERT_TEST` is 0, a write to bit 0 of `ALERT_TEST` that is not a failed request shall send no alert. The rule applies only outside the alert handler's in-band reset.'''
          source: [
            '''The register page says of bit 31: "Write 0 to disable alert testing until the next reset." (!!ALERT_TEST)'''
            '''[Employed Solution](hw/top_earlgrey/ip_autogen/alert_handler/doc/theory_of_operation.md#employed-solution)'''
          ]
          kind: "spec"
          testpoint: "alert"
          checks: ["no alert without a cause (assert_Alert_NoAlertWithoutACause)"]
          why: '''The check allows no alert event for a write of bit 0 while bit 31 of `ALERT_TEST` is 0. An alert event that has no other cause then fails the check.'''
          milestone: "V2S"
          priority: "2"
          security: true
          state: "open"
        }
        {
          name: REQ_BUS_09
          desc: '''Outside the alert handler's in-band reset, the pinmux shall send the fatal alert only after a failed request or an alert test. This rule does not cover the pinmux's answers to the alert handler's pings.'''
          source: [
            '''[pinmux.hjson `alert_list` fatal_fault](hw/top_earlgrey/ip_autogen/pinmux/data/pinmux.hjson)'''
            '''[Employed Solution](hw/top_earlgrey/ip_autogen/alert_handler/doc/theory_of_operation.md#employed-solution)'''
          ]
          kind: "spec"
          testpoint: "alert"
          checks: ["no alert without a cause (assert_Alert_NoAlertWithoutACause)"]
          why: '''The check allows an alert event only after a failed request, after a ping or after an alert test. Each ping and each alert test allows one event.'''
          milestone: "V2S"
          priority: "2"
          security: true
          state: "open"
        }
        {
          name: REQ_BUS_10a
          desc: '''A request with an undefined opcode shall receive an error response.'''
          source: [
            '''[Usage of Opcode, Size and Mask](hw/ip/tlul/README.md#usage-of-opcode-size-and-mask)'''
            '''[Error responses](util/reggen/README.md#error-responses)'''
          ]
          kind: "spec"
          testpoint: "bus"
          checks: ["errors as the register checker predicts", "the CSR checker"]
          why: '''The error checks of the CSR checker require `d_error` to be 1 on a request with an undefined opcode. The proof lets the opcode take any value.'''
          milestone: "V2"
          priority: "2"
          security: true
          state: "open"
        }
        {
          name: REQ_BUS_10b
          desc: '''A request with an illegal combination of address, size and mask shall receive an error response. These combinations are defined in the Conditions above.'''
          source: [
            '''[Explicit Error Cases](hw/ip/tlul/README.md#explicit-error-cases)'''
            '''TileLink 1.9.3 p. 51: "a_address must be aligned to a_size."'''
            '''No specification states the error on an address that is not aligned to the request's size.'''
          ]
          kind: "spec"
          testpoint: "bus"
          checks: ["errors as the register checker predicts", "the CSR checker"]
          why: '''The error checks of the CSR checker require `d_error` to be 1 on a request with an illegal combination of address, size and mask. The proof keeps every mask contiguous.'''
          milestone: "V2"
          priority: "2"
          security: true
          state: "open"
        }
        {
          name: REQ_BUS_10c
          desc: '''A write of 8 or 16 bits to an address not aligned to a word shall receive an error response.'''
          source: [
            '''[Error responses](util/reggen/README.md#error-responses)'''
            '''[Explicit Error Cases](hw/ip/tlul/README.md#explicit-error-cases)'''
          ]
          kind: "spec"
          testpoint: "bus"
          checks: ["errors as the register checker predicts", "the CSR checker"]
          why: '''The error checks of the CSR checker require `d_error` to be 1 on an 8-bit or 16-bit write that is not aligned to a word.'''
          milestone: "V2"
          priority: "2"
          security: true
          state: "open"
        }
        {
          name: REQ_BUS_10d
          desc: '''A write narrower than its register shall receive an error response. The width of a register is set by the location of its fields.'''
          source: [
            '''[Error responses](util/reggen/README.md#error-responses)'''
          ]
          kind: "spec"
          testpoint: "bus"
          checks: ["errors as the register checker predicts", "the CSR checker"]
          why: '''The error checks of the CSR checker require `d_error` to be 1 on a write that is narrower than its register.'''
          milestone: "V2"
          priority: "2"
          security: true
          state: "open"
        }
        {
          name: REQ_BUS_10e
          desc: '''A request to an address that no register maps shall receive an error response, when that address is within the address bits that the register block decodes.'''
          source: [
            '''[Explicit Error Cases](hw/ip/tlul/README.md#explicit-error-cases)'''
            '''[Error responses](util/reggen/README.md#error-responses)'''
          ]
          kind: "spec"
          testpoint: "bus"
          checks: ["errors as the register checker predicts", "the CSR checker"]
          why: '''The error checks of the CSR checker require `d_error` to be 1 on a request to an address that maps to no register.'''
          milestone: "V2"
          priority: "2"
          security: true
          state: "open"
        }
        {
          name: REQ_BUS_11
          desc: '''A write that is answered with an error for any reason other than a failed integrity check shall change no register.'''
          source: [
            '''[cip_base_vseq](hw/dv/sv/cip_lib/README.md#cip_base_vseq)'''
            '''[Error responses](util/reggen/README.md#error-responses)'''
          ]
          kind: "spec"
          testpoint: "bus"
          checks: ["error write changes nothing", "the CSR checker"]
          why: '''A write answered with an error is not an accepted write. The CSR checker and the no-write checks of the attribute registers and the AON fields therefore require every register to keep its value over that write.'''
          milestone: "V2"
          priority: "2"
          security: true
          state: "open"
        }
        {
          name: REQ_BUS_12
          desc: '''Outside the alert handler's in-band reset, the pinmux shall answer each ping of the alert handler with one alert event within a bounded time.'''
          source: [
            '''[Ping Testing](hw/top_earlgrey/ip_autogen/alert_handler/doc/theory_of_operation.md#ping-testing)'''
          ]
          kind: "spec"
          testpoint: "alert"
          checks: ["ping answered (assert_Alert_PingAnswered)", "no alert without a cause (assert_Alert_NoAlertWithoutACause)"]
          why: '''The check _ping answered_ requires an alert event within 40 cycles of each ping. In the check _no alert without a cause_, each ping allows one alert event, so one ping gives one event.'''
          milestone: "V2S"
          priority: "2"
          security: true
          state: "open"
        }
      ]
    }
    {
      name: '''Wakeup detectors'''
      conditions: [
        '''The detector index `w` runs from 0 to `NWkupDetect` - 1, and a cycle in these rows is a cycle of `clk_aon_i`. The watched signal and the forwarded value are defined in the Terms.'''
        '''The register values in these rows are those that the AON logic holds once a write has crossed into the AON domain.'''
        '''The rows hold while an enabled detector keeps its mode. The other fields of the detector may change while it is enabled, although no specification states what such a change does.'''
        '''The rows hold at every value of `sleep_en_i` and of the scan mode, and also while `clk_i` is stopped.'''
        '''One exception: the rows do not hold while scan mode is on and the detector watches a scan clock pad.'''
        '''The rows are checked from the filter's fourth sample after the AON reset `rst_aon_ni`.'''
        '''The timed rows (`REQ_WKUP_09a` to `REQ_WKUP_10b`) hold while `CNT_TH` is 1 or greater.'''
      ]
      requirements: [
        {
          name: REQ_WKUP_01
          desc: '''While a detector's `MIODIO` is 0, its watched signal shall be the input of MIO pad `PADSEL` - 2 for `PADSEL` from 2 to `NMioPads` + 1, the constant 0 for `PADSEL` 0 and the constant 1 for `PADSEL` 1.'''
          source: [
            '''!!MIO_PERIPH_INSEL.IN'''
            '''!!WKUP_DETECTOR.MIODIO'''
            '''!!WKUP_DETECTOR_PADSEL.SEL'''
            '''[Retention and Wakeup Features](hw/top_earlgrey/ip_autogen/pinmux/doc/theory_of_operation.md#retention-and-wakeup-features)'''
            '''[Wakeup Detectors](hw/top_earlgrey/ip_autogen/pinmux/doc/theory_of_operation.md#wakeup-detectors)'''
            '''[top_earlgrey_pinmux.ipconfig.hjson `n_mio_pads`](hw/top_earlgrey/ip_autogen/pinmux/data/top_earlgrey_pinmux.ipconfig.hjson)'''
          ]
          kind: "spec"
          testpoint: "wakeup"
          checks: ["edge sets cause (assert_Wakeup_EdgeSetsCause)", "timed high sets cause (assert_Wakeup_TimedHighSetsCause)", "timed low sets cause (assert_Wakeup_TimedLowSetsCause)", "no false cause (assert_Wakeup_NoFalseCause)"]
          why: '''The checks watch the MIO pad or the constant that the select names.'''
          milestone: "V2"
          priority: "1"
          security: false
          state: "open"
        }
        {
          name: REQ_WKUP_02
          desc: '''While a detector's `MIODIO` is 1, its watched signal shall be the input of DIO pad `PADSEL` for `PADSEL` from 0 to `NDioPads` - 1.'''
          source: [
            '''!!WKUP_DETECTOR.MIODIO'''
            '''!!WKUP_DETECTOR_PADSEL.SEL'''
            '''[MIO and DIO Signal Categories](hw/top_earlgrey/ip_autogen/pinmux/doc/theory_of_operation.md#mio-and-dio-signal-categories)'''
            '''[top_earlgrey_pinmux.ipconfig.hjson `n_dio_pads`](hw/top_earlgrey/ip_autogen/pinmux/data/top_earlgrey_pinmux.ipconfig.hjson)'''
          ]
          kind: "spec"
          testpoint: "wakeup"
          checks: ["edge sets cause (assert_Wakeup_EdgeSetsCause)", "no false cause (assert_Wakeup_NoFalseCause)"]
          why: '''The checks watch the forwarded value of the DIO pad that the select names.'''
          milestone: "V2"
          priority: "1"
          security: false
          state: "open"
        }
        {
          name: REQ_WKUP_03
          desc: '''A detector's watched signal shall be 0 while its `PADSEL` names no pad. `PADSEL` names no pad when it is greater than `NMioPads` + 1 and `MIODIO` is 0, or when it is `NDioPads` or greater and `MIODIO` is 1.'''
          source: [
            '''!!WKUP_DETECTOR_PADSEL.SEL'''
            '''[top_earlgrey_pinmux.ipconfig.hjson `n_mio_pads`, `n_dio_pads`](hw/top_earlgrey/ip_autogen/pinmux/data/top_earlgrey_pinmux.ipconfig.hjson)'''
          ]
          kind: "spec"
          testpoint: "wakeup"
          checks: ["timed low sets cause (assert_Wakeup_TimedLowSetsCause)", "no false cause (assert_Wakeup_NoFalseCause)"]
          why: '''On a select that names no pad, the checks watch the value 0. The checks therefore require a detector in mode 4 to detect, and allow no edge to set the cause bit.'''
          milestone: "V2"
          priority: "1"
          security: false
          state: "open"
        }
        {
          name: REQ_WKUP_04
          desc: '''While a detector's `FILTER` is 0, its forwarded value shall be the watched signal as sampled at each `clk_aon_i` edge.'''
          source: [
            '''[Wakeup Detectors](hw/top_earlgrey/ip_autogen/pinmux/doc/theory_of_operation.md#wakeup-detectors)'''
          ]
          kind: "spec"
          testpoint: "wakeup"
          checks: ["edge sets cause (assert_Wakeup_EdgeSetsCause)", "no false cause (assert_Wakeup_NoFalseCause)"]
          why: '''With `FILTER` 0, the forwarded value that the checks watch is the sampled pad. The checks allow the pad to be seen up to 4 cycles late.'''
          milestone: "V2"
          priority: "1"
          security: false
          state: "open"
        }
        {
          name: REQ_WKUP_05
          desc: '''While a detector's `FILTER` is 1, its forwarded value shall take a new value only once 4 consecutive samples of the watched signal have had that value.'''
          source: [
            '''!!WKUP_DETECTOR.FILTER'''
          ]
          kind: "spec"
          testpoint: "wakeup"
          checks: ["edge sets cause (assert_Wakeup_EdgeSetsCause)", "no false cause (assert_Wakeup_NoFalseCause)"]
          why: '''The checks count a level that holds for 4 consecutive samples as an edge of the forwarded value. A glitch of 3 samples gives no edge.'''
          milestone: "V2"
          priority: "1"
          security: false
          state: "open"
        }
        {
          name: REQ_WKUP_06a
          desc: '''An enabled detector in mode 0 (Posedge) shall detect every rise of the forwarded value.'''
          source: [
            '''!!WKUP_DETECTOR.MODE'''
            '''[Wakeup Detectors](hw/top_earlgrey/ip_autogen/pinmux/doc/theory_of_operation.md#wakeup-detectors)'''
          ]
          kind: "spec"
          testpoint: "wakeup"
          checks: ["posedge sets cause (assert_Wakeup_PosedgeSetsCause)"]
          why: '''The check requires a hardware write of 1 to the cause bit within 8 cycles of each rise of the forwarded value, if `EN` is 1 at the rise and in each of the 4 cycles after it. A pulse of one sample counts as a rise.'''
          milestone: "V2"
          priority: "1"
          security: false
          state: "open"
        }
        {
          name: REQ_WKUP_06b
          desc: '''An enabled detector in mode 0 (Posedge) shall detect only at a rise of the forwarded value.'''
          source: [
            '''!!WKUP_DETECTOR.MODE'''
            '''[Wakeup Detectors](hw/top_earlgrey/ip_autogen/pinmux/doc/theory_of_operation.md#wakeup-detectors)'''
          ]
          kind: "spec"
          testpoint: "wakeup"
          checks: ["no false cause (assert_Wakeup_NoFalseCause)"]
          why: '''In mode 0, the check allows a hardware write of 1 to a cause bit at 0 only when the write answers a rise of the forwarded value with `EN` 1. The check allows the rise to be seen up to 4 cycles late.'''
          milestone: "V2"
          priority: "1"
          security: false
          state: "open"
        }
        {
          name: REQ_WKUP_07a
          desc: '''An enabled detector in mode 1 (Negedge) shall detect every fall of the forwarded value.'''
          source: [
            '''!!WKUP_DETECTOR.MODE'''
          ]
          kind: "spec"
          testpoint: "wakeup"
          checks: ["negedge sets cause (assert_Wakeup_NegedgeSetsCause)"]
          why: '''The check requires a hardware write of 1 to bit `w` within 8 cycles of each fall of the forwarded value, if `EN` is 1 at the fall and in each of the 4 cycles after it.'''
          milestone: "V2"
          priority: "1"
          security: false
          state: "open"
        }
        {
          name: REQ_WKUP_07b
          desc: '''An enabled detector in mode 1 (Negedge) shall detect only at a fall of the forwarded value.'''
          source: [
            '''!!WKUP_DETECTOR.MODE'''
          ]
          kind: "spec"
          testpoint: "wakeup"
          checks: ["no false cause (assert_Wakeup_NoFalseCause)"]
          why: '''In mode 1, the check allows a hardware write of 1 to a cause bit at 0 only when the write answers a fall of the forwarded value. A detector that detects on a rise therefore fails the check.'''
          milestone: "V2"
          priority: "1"
          security: false
          state: "open"
        }
        {
          name: REQ_WKUP_08a
          desc: '''An enabled detector in mode 2 (Edge) shall detect every change of the forwarded value.'''
          source: [
            '''!!WKUP_DETECTOR.MODE'''
          ]
          kind: "spec"
          testpoint: "wakeup"
          checks: ["edge sets cause (assert_Wakeup_EdgeSetsCause)"]
          why: '''The check requires a hardware write of 1 to bit `w` within 8 cycles of each rise and each fall of the forwarded value, if `EN` is 1 at the edge and in each of the 4 cycles after it.'''
          milestone: "V2"
          priority: "1"
          security: false
          state: "open"
        }
        {
          name: REQ_WKUP_08b
          desc: '''An enabled detector in mode 2 (Edge) shall detect only at a change of the forwarded value.'''
          source: [
            '''!!WKUP_DETECTOR.MODE'''
          ]
          kind: "spec"
          testpoint: "wakeup"
          checks: ["no false cause (assert_Wakeup_NoFalseCause)"]
          why: '''In mode 2, the check allows a hardware write of 1 to a cause bit at 0 only when the write answers a rise or a fall of the forwarded value.'''
          milestone: "V2"
          priority: "1"
          security: false
          state: "open"
        }
        {
          name: REQ_WKUP_09a
          desc: '''An enabled detector in mode 3 (TimedHigh) shall detect when the forwarded value has been 1 for `CNT_TH` consecutive cycles.'''
          source: [
            '''!!WKUP_DETECTOR.MODE'''
            '''!!WKUP_DETECTOR_CNT_TH.TH'''
            '''[Wakeup Detectors](hw/top_earlgrey/ip_autogen/pinmux/doc/theory_of_operation.md#wakeup-detectors)'''
            '''[top_earlgrey_pinmux.ipconfig.hjson `wkup_cnt_width`](hw/top_earlgrey/ip_autogen/pinmux/data/top_earlgrey_pinmux.ipconfig.hjson)'''
          ]
          kind: "spec"
          testpoint: "wakeup"
          checks: ["timed high sets cause (assert_Wakeup_TimedHighSetsCause)"]
          why: '''The check requires the cause bit to be set within 8 cycles of the cycle in which the forwarded value has been 1 for `CNT_TH` + 1 consecutive cycles with `EN` 1. The sources of this count differ by one cycle, so a detection after `CNT_TH` + 1 cycles also passes.'''
          milestone: "V2"
          priority: "1"
          security: false
          state: "open"
        }
        {
          name: REQ_WKUP_09b
          desc: '''An enabled detector in mode 3 (TimedHigh) shall never detect while the forwarded value has been 1 for fewer than `CNT_TH` consecutive cycles.'''
          source: [
            '''!!WKUP_DETECTOR.MODE'''
            '''[top_earlgrey_pinmux.ipconfig.hjson `wkup_cnt_width`](hw/top_earlgrey/ip_autogen/pinmux/data/top_earlgrey_pinmux.ipconfig.hjson)'''
          ]
          kind: "spec"
          testpoint: "wakeup"
          checks: ["no false cause (assert_Wakeup_NoFalseCause)"]
          why: '''In mode 3, the check refuses a set of the cause bit while the forwarded value has been 1 for fewer than `CNT_TH` consecutive cycles with `EN` 1.'''
          milestone: "V2"
          priority: "1"
          security: false
          state: "open"
        }
        {
          name: REQ_WKUP_10a
          desc: '''An enabled detector in mode 4 (TimedLow) shall detect when the forwarded value has been 0 for `CNT_TH` consecutive cycles.'''
          source: [
            '''!!WKUP_DETECTOR.MODE'''
            '''!!WKUP_DETECTOR_CNT_TH.TH'''
            '''[Wakeup Detectors](hw/top_earlgrey/ip_autogen/pinmux/doc/theory_of_operation.md#wakeup-detectors)'''
            '''[top_earlgrey_pinmux.ipconfig.hjson `wkup_cnt_width`](hw/top_earlgrey/ip_autogen/pinmux/data/top_earlgrey_pinmux.ipconfig.hjson)'''
          ]
          kind: "spec"
          testpoint: "wakeup"
          checks: ["timed low sets cause (assert_Wakeup_TimedLowSetsCause)"]
          why: '''The check requires the cause bit to be set within 8 cycles of the cycle in which the forwarded value has been 0 for `CNT_TH` + 1 consecutive cycles with `EN` 1. The sources of this count differ by one cycle, so a detection after `CNT_TH` + 1 cycles also passes.'''
          milestone: "V2"
          priority: "1"
          security: false
          state: "open"
        }
        {
          name: REQ_WKUP_10b
          desc: '''An enabled detector in mode 4 (TimedLow) shall never detect while the forwarded value has been 0 for fewer than `CNT_TH` consecutive cycles.'''
          source: [
            '''!!WKUP_DETECTOR.MODE'''
            '''[top_earlgrey_pinmux.ipconfig.hjson `wkup_cnt_width`](hw/top_earlgrey/ip_autogen/pinmux/data/top_earlgrey_pinmux.ipconfig.hjson)'''
          ]
          kind: "spec"
          testpoint: "wakeup"
          checks: ["no false cause (assert_Wakeup_NoFalseCause)"]
          why: '''In mode 4, the check refuses a set of the cause bit while the forwarded value has been 0 for fewer than `CNT_TH` consecutive cycles with `EN` 1.'''
          milestone: "V2"
          priority: "1"
          security: false
          state: "open"
        }
        {
          name: REQ_WKUP_11
          desc: '''An enabled detector in mode 5, 6 or 7 shall detect exactly the rises of the forwarded value, as in mode 0 (Posedge).'''
          source: [
            '''!!WKUP_DETECTOR.MODE'''
          ]
          kind: "spec"
          testpoint: "wakeup"
          checks: ["posedge sets cause (assert_Wakeup_PosedgeSetsCause)", "no false cause (assert_Wakeup_NoFalseCause)"]
          why: '''Both checks read `MODE` 5, 6 and 7 as mode 0.'''
          milestone: "V2"
          priority: "1"
          security: false
          state: "open"
        }
        {
          name: REQ_WKUP_12
          desc: '''A detector whose enable is 0 shall detect nothing.'''
          source: [
            '''!!WKUP_DETECTOR_EN.EN'''
          ]
          kind: "spec"
          testpoint: "wakeup"
          checks: ["no false cause (assert_Wakeup_NoFalseCause)"]
          why: '''The check allows a hardware write of 1 to a cause bit at 0 only when the write answers a pattern with `EN` 1. An edge within 4 cycles of a change of `EN` may set the cause bit or not.'''
          milestone: "V2"
          priority: "1"
          security: false
          state: "open"
        }
        {
          name: REQ_WKUP_13a
          desc: '''The sampling of a detector's watched signal shall run while the detector is disabled, so that enabling the detector does not restart the sampling.'''
          source: [
            '''None: the theory of operation and the register description are silent'''
          ]
          kind: "RTL"
          testpoint: "wakeup"
          checks: ["no false cause (assert_Wakeup_NoFalseCause)", "posedge sets cause (assert_Wakeup_PosedgeSetsCause)"]
          why: '''The checks sample the pad at every value of `EN`. A pad that is already 1 before the enable therefore gives no rise, and a rise immediately after the enable counts as a rise.'''
          milestone: "V2"
          priority: "1"
          security: false
          state: "open"
        }
        {
          name: REQ_WKUP_13b
          desc: '''A detector's filter shall run while the detector is disabled, so that enabling the detector does not restart the filter.'''
          source: [
            '''None: the theory of operation and the register description are silent'''
          ]
          kind: "RTL"
          testpoint: "wakeup"
          checks: ["no false cause (assert_Wakeup_NoFalseCause)", "posedge sets cause (assert_Wakeup_PosedgeSetsCause)"]
          why: '''The filter of the checks runs at every value of `EN`. A rise whose 4 samples span the enable counts as a rise, and a pad that is already 1 before the enable does not.'''
          milestone: "V2"
          priority: "1"
          security: false
          state: "open"
        }
        {
          name: REQ_WKUP_14
          desc: '''When detector `w` is enabled and detects, bit `w` of `WKUP_CAUSE` shall become 1.'''
          source: [
            '''[Wakeup Detectors](hw/top_earlgrey/ip_autogen/pinmux/doc/theory_of_operation.md#wakeup-detectors)'''
            '''!!WKUP_CAUSE.CAUSE'''
            '''[Wakeup Features](hw/top_earlgrey/ip_autogen/pinmux/doc/programmers_guide.md#wakeup-features)'''
            '''[top_earlgrey_pinmux.ipconfig.hjson `n_wkup_detect`](hw/top_earlgrey/ip_autogen/pinmux/data/top_earlgrey_pinmux.ipconfig.hjson)'''
          ]
          kind: "spec"
          testpoint: "wakeup"
          checks: ["posedge sets cause (assert_Wakeup_PosedgeSetsCause)", "negedge sets cause (assert_Wakeup_NegedgeSetsCause)", "edge sets cause (assert_Wakeup_EdgeSetsCause)", "timed high sets cause (assert_Wakeup_TimedHighSetsCause)", "timed low sets cause (assert_Wakeup_TimedLowSetsCause)", "set lands (assert_Wakeup_SetLands)"]
          why: '''The checks require a cause set within 8 cycles of each detection, and the cause bit to be 1 in the cycle after the set.'''
          milestone: "V2"
          priority: "1"
          security: false
          state: "open"
        }
        {
          name: REQ_WKUP_15
          desc: '''Bit `w` of `WKUP_CAUSE` shall become 1 only when detector `w` detects.'''
          source: [
            '''!!WKUP_CAUSE.CAUSE'''
            '''[top_earlgrey_pinmux.ipconfig.hjson `n_wkup_detect`](hw/top_earlgrey/ip_autogen/pinmux/data/top_earlgrey_pinmux.ipconfig.hjson)'''
          ]
          kind: "spec"
          testpoint: "wakeup"
          checks: ["no false cause (assert_Wakeup_NoFalseCause)", "cause rises only on a set (assert_Wakeup_CauseRisesOnlyOnASet)"]
          why: '''The checks allow a cause set of bit `w` only on a pattern of detector `w`, and allow bit `w` to rise only in the cycle after a cause set of that bit.'''
          milestone: "V2"
          priority: "1"
          security: false
          state: "open"
        }
        {
          name: REQ_WKUP_16
          desc: '''Once a cause bit (a bit of `WKUP_CAUSE`) is 1, it shall stay 1 until software's clear of that bit lands. This holds for any behaviour of the bit's detector, of the detector's enable and of the pad that the detector watches.'''
          source: [
            '''!!WKUP_CAUSE'''
            '''!!WKUP_CAUSE.CAUSE'''
            '''[Wakeup Features](hw/top_earlgrey/ip_autogen/pinmux/doc/programmers_guide.md#wakeup-features)'''
            '''[Wakeup Recording](hw/top_earlgrey/ip_autogen/pwrmgr/doc/theory_of_operation.md#wakeup-recording)'''
          ]
          kind: "spec"
          testpoint: "wakeup_cause"
          checks: ["cause holds until cleared (assert_WakeupCause_CauseHoldsUntilCleared)", "hardware only sets cause (assert_WakeupCause_HardwareOnlySetsCause)"]
          why: '''The checks allow the cause bit to fall only in the cycle after a landed clear, or at `rst_aon_ni`. The checks allow a hardware write of 0 to the bit only in a cycle in which a clear lands.'''
          milestone: "V2"
          priority: "2"
          security: false
          state: "open"
        }
        {
          name: REQ_WKUP_17
          desc: '''When a detection sets a cause bit in the cycle in which software's clear of that bit lands, the bit shall end at 0. Software's clear has precedence over the detection.'''
          source: [
            '''!!WKUP_CAUSE'''
            '''[Type RW](util/reggen/README.md#type-rw)'''
            '''[Simultaneous SW and HW access](util/reggen/README.md#simultaneous-sw-and-hw-access)'''
          ]
          kind: "spec"
          testpoint: "wakeup_cause"
          checks: ["set and clear together (assert_WakeupCause_SetAndClearTogether)"]
          why: '''When a hardware write of 1 to a cause bit comes in the cycle in which a clear of that bit lands, the check requires the bit to be 0 in the next cycle.'''
          milestone: "V2"
          priority: "2"
          security: false
          state: "open"
        }
        {
          name: REQ_WKUP_18a
          desc: '''`pin_wkup_req_o` shall be 1 while at least one cause bit is 1.'''
          source: [
            '''[Inter-Module Signals](hw/top_earlgrey/ip_autogen/pinmux/doc/interfaces.md#inter-module-signals)'''
            '''[Wakeup Detectors](hw/top_earlgrey/ip_autogen/pinmux/doc/theory_of_operation.md#wakeup-detectors)'''
            '''[Wakeup Recording](hw/top_earlgrey/ip_autogen/pwrmgr/doc/theory_of_operation.md#wakeup-recording)'''
            '''[top_earlgrey_pinmux.ipconfig.hjson `n_wkup_detect`](hw/top_earlgrey/ip_autogen/pinmux/data/top_earlgrey_pinmux.ipconfig.hjson)'''
          ]
          kind: "spec"
          testpoint: "wakeup_cause"
          checks: ["request follows cause (assert_WakeupCause_RequestFollowsCause)"]
          why: '''The check requires `pin_wkup_req_o` to be 1 within 2 cycles of any cause bit rising. The check also requires the request to be 1 while any cause bit has been 1 for 3 consecutive cycles.'''
          milestone: "V2"
          priority: "2"
          security: false
          state: "open"
        }
        {
          name: REQ_WKUP_18b
          desc: '''`pin_wkup_req_o` shall be 0 while every cause bit is 0.'''
          source: [
            '''[Inter-Module Signals](hw/top_earlgrey/ip_autogen/pinmux/doc/interfaces.md#inter-module-signals)'''
            '''[Wakeup Detectors](hw/top_earlgrey/ip_autogen/pinmux/doc/theory_of_operation.md#wakeup-detectors)'''
            '''[Wakeup Recording](hw/top_earlgrey/ip_autogen/pwrmgr/doc/theory_of_operation.md#wakeup-recording)'''
            '''[top_earlgrey_pinmux.ipconfig.hjson `n_wkup_detect`](hw/top_earlgrey/ip_autogen/pinmux/data/top_earlgrey_pinmux.ipconfig.hjson)'''
          ]
          kind: "spec"
          testpoint: "wakeup_cause"
          checks: ["no request without cause (assert_WakeupCause_NoRequestWithoutCause)"]
          why: '''The check requires `pin_wkup_req_o` to be 0 once every cause bit has been 0 for 3 consecutive cycles.'''
          milestone: "V2"
          priority: "2"
          security: false
          state: "open"
        }
        {
          name: REQ_WKUP_19a
          desc: '''A write to a detector's enable shall reach the AON logic within a bounded time.'''
          source: [
            '''!!WKUP_DETECTOR_EN'''
            '''[Wakeup Features](hw/top_earlgrey/ip_autogen/pinmux/doc/programmers_guide.md#wakeup-features)'''
          ]
          kind: "spec"
          testpoint: "wakeup_sync"
          checks: ["write lands (assert_WakeupSync_WriteLands)", "no change without a write (assert_WakeupSync_NoChangeWithoutAWrite)"]
          why: '''For `EN`, the checks require each accepted write to land within 4 cycles, and allow only a write that has not yet landed to change the field.'''
          milestone: "V2"
          priority: "2"
          security: false
          state: "open"
        }
        {
          name: REQ_WKUP_19b
          desc: '''A write to a detector's configuration shall reach the AON logic within a bounded time.'''
          source: [
            '''!!WKUP_DETECTOR'''
            '''[Wakeup Features](hw/top_earlgrey/ip_autogen/pinmux/doc/programmers_guide.md#wakeup-features)'''
          ]
          kind: "spec"
          testpoint: "wakeup_sync"
          checks: ["write lands (assert_WakeupSync_WriteLands)", "no change without a write (assert_WakeupSync_NoChangeWithoutAWrite)"]
          why: '''For `MODE`, `FILTER` and `MIODIO`, the checks require each accepted write to land within 4 cycles, and allow only a write that has not yet landed to change one of these fields.'''
          milestone: "V2"
          priority: "2"
          security: false
          state: "open"
        }
        {
          name: REQ_WKUP_19c
          desc: '''A write to a detector's threshold shall reach the AON logic within a bounded time.'''
          source: [
            '''!!WKUP_DETECTOR_CNT_TH'''
            '''[Wakeup Features](hw/top_earlgrey/ip_autogen/pinmux/doc/programmers_guide.md#wakeup-features)'''
          ]
          kind: "spec"
          testpoint: "wakeup_sync"
          checks: ["write lands (assert_WakeupSync_WriteLands)", "no change without a write (assert_WakeupSync_NoChangeWithoutAWrite)"]
          why: '''For `CNT_TH`, the checks require each accepted write to land within 4 cycles, and allow only a write that has not yet landed to change the field.'''
          milestone: "V2"
          priority: "2"
          security: false
          state: "open"
        }
        {
          name: REQ_WKUP_19d
          desc: '''A clear of `WKUP_CAUSE` shall reach the AON logic within a bounded time.'''
          source: [
            '''!!WKUP_CAUSE'''
            '''[Wakeup Features](hw/top_earlgrey/ip_autogen/pinmux/doc/programmers_guide.md#wakeup-features)'''
          ]
          kind: "spec"
          testpoint: "wakeup_sync"
          checks: ["clear lands (assert_WakeupSync_ClearLands)", "landed clear clears cause (assert_WakeupSync_LandedClearClearsCause)", "no clear without a write (assert_WakeupSync_NoClearWithoutAWrite)"]
          why: '''The checks require each software clear of the cause bit to land within 10 cycles, and the bit to be 0 one cycle later. The checks allow no clear to land without a software clear.'''
          milestone: "V2"
          priority: "2"
          security: false
          state: "open"
        }
        {
          name: REQ_WKUP_20a
          desc: '''A write to a detector's configuration that is accepted before a write to its enable shall hold in the AON logic no later than that enable write does.'''
          source: [
            '''!!WKUP_DETECTOR_EN'''
          ]
          kind: "spec"
          testpoint: "wakeup_sync"
          checks: ["writes land in order (assert_WakeupSync_WritesLandInOrder)"]
          why: '''The check compares the AON cycles in which a configuration write and a later enable write land. The check fails when the enable write lands first.'''
          milestone: "V2"
          priority: "2"
          security: false
          state: "open"
        }
        {
          name: REQ_WKUP_20b
          desc: '''A write to a detector's threshold that is accepted before a write to its enable shall hold in the AON logic no later than that enable write does.'''
          source: [
            '''!!WKUP_DETECTOR_EN'''
          ]
          kind: "spec"
          testpoint: "wakeup_sync"
          checks: ["writes land in order (assert_WakeupSync_WritesLandInOrder)"]
          why: '''The check compares the AON cycles in which a threshold write and a later enable write land. An enable that holds before the threshold fails the check.'''
          milestone: "V2"
          priority: "2"
          security: false
          state: "open"
        }
      ]
    }
    {
      name: '''USB wakeup'''
      conditions: [
        '''the module is usbdev's AON/Wake module ([USB Wakeup Detection Module](hw/top_earlgrey/ip_autogen/pinmux/doc/theory_of_operation.md#usb-wakeup-detection-module)), and each pinmux port in the table below has the role that usbdev's documents give to the port it connects to:'''
        '''`usbdev_dppullup_en`: D+ pull-up enable, routed to the module's input `usbdev_dppullup_en_i` ([AON/Wake Interface Pins](hw/ip/usbdev/doc/theory_of_operation.md#aonwake-interface-pins))'''
        '''`usbdev_dnpullup_en`: D- pull-up enable, routed to the module's input `usbdev_dnpullup_en_i` ([AON/Wake Interface Pins](hw/ip/usbdev/doc/theory_of_operation.md#aonwake-interface-pins))'''
        '''`usbdev_suspend_req`: "Request to activate the AON/Wake module" ([Inter-Module Signals](hw/ip/usbdev/doc/interfaces.md#inter-module-signals))'''
        '''`usbdev_wake_ack`: "Acknowledge a wake signal from the AON/Wake" ([Inter-Module Signals](hw/ip/usbdev/doc/interfaces.md#inter-module-signals))'''
        '''`usb_dppullup_en`: D+ pull-up enable from the module's output `usb_dppullup_en_o` ([AON/Wake Interface Pins](hw/ip/usbdev/doc/theory_of_operation.md#aonwake-interface-pins))'''
        '''`usb_dnpullup_en`: D- pull-up enable from the module's output `usb_dnpullup_en_o` ([AON/Wake Interface Pins](hw/ip/usbdev/doc/theory_of_operation.md#aonwake-interface-pins))'''
        '''`usbdev_bus_not_idle`: The event "the USB is in a non-idle state" ([Inter-Module Signals](hw/ip/usbdev/doc/interfaces.md#inter-module-signals))'''
        '''`usbdev_bus_reset`: The event "a USB Bus Reset occurred" ([Inter-Module Signals](hw/ip/usbdev/doc/interfaces.md#inter-module-signals))'''
        '''`usbdev_sense_lost`: The event "the VBUS/SENSE signal became deasserted" ([Inter-Module Signals](hw/ip/usbdev/doc/interfaces.md#inter-module-signals))'''
        '''`usbdev_wake_detect_active`: The active state, "the external AON/Wake module is active" ([Inter-Module Signals](hw/ip/usbdev/doc/interfaces.md#inter-module-signals)), from the module's output `wake_detect_active_aon_o` ([AON/Wake Interface Pins](hw/ip/usbdev/doc/theory_of_operation.md#aonwake-interface-pins))'''
        '''A suspend request is a `clk_aon_i` cycle in which `usbdev_suspend_req` is 1, and a wake acknowledge is a `clk_aon_i` cycle in which `usbdev_wake_ack` is 1.'''
        '''The USB lines are the module's D+, D- and VBUS inputs, and they may take any value at any time. The module is active while `usbdev_wake_detect_active` is 1.'''
        '''The bus is idle while each line equals its own pad pull-up enable: D+ equals `usb_dppullup_en`, and D- equals `usb_dnpullup_en`. With no enable at 1, both lines low is idle, so a bus reset then sets the bus reset event but not the bus-not-idle event.'''
        '''The two pull-up rows `REQ_USB_06d` and `REQ_USB_06e` hold when usbdev keeps its pull-up enables unchanged in the 4 always-on clock cycles before a suspend request.'''
        '''The wiring rows follow usbdev's documents; the pinmux theory of operation names only `usb_wkup_req` ([USB Wakeup Detection Module](hw/top_earlgrey/ip_autogen/pinmux/doc/theory_of_operation.md#usb-wakeup-detection-module)).'''
        '''The rows name each signal as these documents do, and the port of the pinmux has the same name with the suffix `_i` or `_o`.'''
      ]
      requirements: [
        {
          name: REQ_USB_01a
          desc: '''`usbdev_dppullup_en` shall reach the module's input that has the same role, unchanged and in the same cycle.'''
          source: [
            '''[Inter-Module Signals](hw/top_earlgrey/ip_autogen/pinmux/doc/interfaces.md#inter-module-signals)'''
            '''[top_earlgrey.hjson `inter_module.connect usbdev.usb_dp_pullup`](hw/top_earlgrey/data/top_earlgrey.hjson)'''
            '''[top_earlgrey_pinmux.ipconfig.hjson `enable_usb_wakeup`](hw/top_earlgrey/ip_autogen/pinmux/data/top_earlgrey_pinmux.ipconfig.hjson)'''
          ]
          kind: "spec"
          testpoint: "usb_conn"
          checks: ["D+ pull-up enable in (assert_UsbConn_DpPullUpEnableIn)"]
          why: '''The check compares the module's `usbdev_dppullup_en_i` port with `usbdev_dppullup_en` in every cycle.'''
          milestone: "V2"
          priority: "2"
          security: false
          state: "open"
        }
        {
          name: REQ_USB_01b
          desc: '''`usbdev_dnpullup_en` shall reach the module's input that has the same role, unchanged and in the same cycle.'''
          source: [
            '''[Inter-Module Signals](hw/top_earlgrey/ip_autogen/pinmux/doc/interfaces.md#inter-module-signals)'''
            '''[top_earlgrey.hjson `inter_module.connect usbdev.usb_dn_pullup`](hw/top_earlgrey/data/top_earlgrey.hjson)'''
            '''[top_earlgrey_pinmux.ipconfig.hjson `enable_usb_wakeup`](hw/top_earlgrey/ip_autogen/pinmux/data/top_earlgrey_pinmux.ipconfig.hjson)'''
          ]
          kind: "spec"
          testpoint: "usb_conn"
          checks: ["D- pull-up enable in (assert_UsbConn_DnPullUpEnableIn)"]
          why: '''The check compares the module's `usbdev_dnpullup_en_i` port with `usbdev_dnpullup_en` in every cycle.'''
          milestone: "V2"
          priority: "2"
          security: false
          state: "open"
        }
        {
          name: REQ_USB_01c
          desc: '''`usbdev_suspend_req` shall reach the module's input that has the same role, unchanged and in the same cycle.'''
          source: [
            '''[Inter-Module Signals](hw/top_earlgrey/ip_autogen/pinmux/doc/interfaces.md#inter-module-signals)'''
            '''[top_earlgrey.hjson `inter_module.connect usbdev.usb_aon_suspend_req`](hw/top_earlgrey/data/top_earlgrey.hjson)'''
            '''[top_earlgrey_pinmux.ipconfig.hjson `enable_usb_wakeup`](hw/top_earlgrey/ip_autogen/pinmux/data/top_earlgrey_pinmux.ipconfig.hjson)'''
          ]
          kind: "spec"
          testpoint: "usb_conn"
          checks: ["suspend request in (assert_UsbConn_SuspendRequestIn)"]
          why: '''The check compares the module's suspend request port with `usbdev_suspend_req` in every cycle. The comparison also covers a one-cycle pulse.'''
          milestone: "V2"
          priority: "2"
          security: false
          state: "open"
        }
        {
          name: REQ_USB_01d
          desc: '''`usbdev_wake_ack` shall reach the module's input that has the same role, unchanged and in the same cycle.'''
          source: [
            '''[Inter-Module Signals](hw/top_earlgrey/ip_autogen/pinmux/doc/interfaces.md#inter-module-signals)'''
            '''[top_earlgrey.hjson `inter_module.connect usbdev.usb_aon_wake_ack`](hw/top_earlgrey/data/top_earlgrey.hjson)'''
            '''[top_earlgrey_pinmux.ipconfig.hjson `enable_usb_wakeup`](hw/top_earlgrey/ip_autogen/pinmux/data/top_earlgrey_pinmux.ipconfig.hjson)'''
          ]
          kind: "spec"
          testpoint: "usb_conn"
          checks: ["wake acknowledge in (assert_UsbConn_WakeAcknowledgeIn)"]
          why: '''The check compares the module's wake acknowledge port with `usbdev_wake_ack` in every cycle.'''
          milestone: "V2"
          priority: "2"
          security: false
          state: "open"
        }
        {
          name: REQ_USB_02a
          desc: '''`usb_dppullup_en` shall carry the module's pull-up enable that has the same role, unchanged and in the same cycle.'''
          source: [
            '''[Inter-Module Signals](hw/top_earlgrey/ip_autogen/pinmux/doc/interfaces.md#inter-module-signals)'''
            '''[top_earlgrey.hjson `inter_module.external pinmux.usb_dppullup_en`](hw/top_earlgrey/data/top_earlgrey.hjson)'''
            '''[top_earlgrey_pinmux.ipconfig.hjson `enable_usb_wakeup`](hw/top_earlgrey/ip_autogen/pinmux/data/top_earlgrey_pinmux.ipconfig.hjson)'''
          ]
          kind: "spec"
          testpoint: "usb_conn"
          checks: ["D+ pull-up enable out (assert_UsbConn_DpPullUpEnableOut)"]
          why: '''The check compares `usb_dppullup_en` with the module's `usb_dppullup_en_o` port in every cycle.'''
          milestone: "V2"
          priority: "2"
          security: false
          state: "open"
        }
        {
          name: REQ_USB_02b
          desc: '''`usb_dnpullup_en` shall carry the module's pull-up enable that has the same role, unchanged and in the same cycle.'''
          source: [
            '''[Inter-Module Signals](hw/top_earlgrey/ip_autogen/pinmux/doc/interfaces.md#inter-module-signals)'''
            '''[top_earlgrey.hjson `inter_module.external pinmux.usb_dnpullup_en`](hw/top_earlgrey/data/top_earlgrey.hjson)'''
            '''[top_earlgrey_pinmux.ipconfig.hjson `enable_usb_wakeup`](hw/top_earlgrey/ip_autogen/pinmux/data/top_earlgrey_pinmux.ipconfig.hjson)'''
          ]
          kind: "spec"
          testpoint: "usb_conn"
          checks: ["D- pull-up enable out (assert_UsbConn_DnPullUpEnableOut)"]
          why: '''The check compares `usb_dnpullup_en` with the module's `usb_dnpullup_en_o` port in every cycle.'''
          milestone: "V2"
          priority: "2"
          security: false
          state: "open"
        }
        {
          name: REQ_USB_02c
          desc: '''`usbdev_bus_not_idle` shall carry the one of the module's three events that has the same role, unchanged and in the same cycle.'''
          source: [
            '''[Inter-Module Signals](hw/top_earlgrey/ip_autogen/pinmux/doc/interfaces.md#inter-module-signals)'''
            '''[top_earlgrey.hjson `inter_module.connect usbdev.usb_aon_bus_not_idle`](hw/top_earlgrey/data/top_earlgrey.hjson)'''
            '''[top_earlgrey_pinmux.ipconfig.hjson `enable_usb_wakeup`](hw/top_earlgrey/ip_autogen/pinmux/data/top_earlgrey_pinmux.ipconfig.hjson)'''
          ]
          kind: "spec"
          testpoint: "usb_conn"
          checks: ["bus not idle out (assert_UsbConn_BusNotIdleOut)"]
          why: '''The check compares `usbdev_bus_not_idle` with the module's resume event port in every cycle.'''
          milestone: "V2"
          priority: "2"
          security: false
          state: "open"
        }
        {
          name: REQ_USB_02d
          desc: '''`usbdev_bus_reset` shall carry the one of the module's three events that has the same role, unchanged and in the same cycle.'''
          source: [
            '''[Inter-Module Signals](hw/top_earlgrey/ip_autogen/pinmux/doc/interfaces.md#inter-module-signals)'''
            '''[top_earlgrey.hjson `inter_module.connect usbdev.usb_aon_bus_reset`](hw/top_earlgrey/data/top_earlgrey.hjson)'''
            '''[top_earlgrey_pinmux.ipconfig.hjson `enable_usb_wakeup`](hw/top_earlgrey/ip_autogen/pinmux/data/top_earlgrey_pinmux.ipconfig.hjson)'''
          ]
          kind: "spec"
          testpoint: "usb_conn"
          checks: ["bus reset out (assert_UsbConn_BusResetOut)"]
          why: '''The check compares `usbdev_bus_reset` with the module's bus reset event port in every cycle.'''
          milestone: "V2"
          priority: "2"
          security: false
          state: "open"
        }
        {
          name: REQ_USB_02e
          desc: '''`usbdev_sense_lost` shall carry the one of the module's three events that has the same role, unchanged and in the same cycle.'''
          source: [
            '''[Inter-Module Signals](hw/top_earlgrey/ip_autogen/pinmux/doc/interfaces.md#inter-module-signals)'''
            '''[top_earlgrey.hjson `inter_module.connect usbdev.usb_aon_sense_lost`](hw/top_earlgrey/data/top_earlgrey.hjson)'''
            '''[top_earlgrey_pinmux.ipconfig.hjson `enable_usb_wakeup`](hw/top_earlgrey/ip_autogen/pinmux/data/top_earlgrey_pinmux.ipconfig.hjson)'''
          ]
          kind: "spec"
          testpoint: "usb_conn"
          checks: ["sense lost out (assert_UsbConn_SenseLostOut)"]
          why: '''The check compares `usbdev_sense_lost` with the module's VBUS lost event port in every cycle.'''
          milestone: "V2"
          priority: "2"
          security: false
          state: "open"
        }
        {
          name: REQ_USB_02f
          desc: '''`usbdev_wake_detect_active` shall carry the module's active state, unchanged and in the same cycle.'''
          source: [
            '''[Inter-Module Signals](hw/top_earlgrey/ip_autogen/pinmux/doc/interfaces.md#inter-module-signals)'''
            '''[top_earlgrey.hjson `inter_module.connect pinmux.usbdev_wake_detect_active`](hw/top_earlgrey/data/top_earlgrey.hjson)'''
            '''[top_earlgrey_pinmux.ipconfig.hjson `enable_usb_wakeup`](hw/top_earlgrey/ip_autogen/pinmux/data/top_earlgrey_pinmux.ipconfig.hjson)'''
          ]
          kind: "spec"
          testpoint: "usb_conn"
          checks: ["active out (assert_UsbConn_ActiveOut)"]
          why: '''The check compares `usbdev_wake_detect_active` with the module's `wake_detect_active_aon_o` port in every cycle. A value taken from another port, or a delayed value, fails the check.'''
          milestone: "V2"
          priority: "2"
          security: false
          state: "open"
        }
        {
          name: REQ_USB_03
          desc: '''`usb_wkup_req` shall carry the module's wake request, unchanged and in the same cycle.'''
          source: [
            '''[Inter-Module Signals](hw/top_earlgrey/ip_autogen/pinmux/doc/interfaces.md#inter-module-signals)'''
            '''[top_earlgrey_pinmux.ipconfig.hjson `enable_usb_wakeup`](hw/top_earlgrey/ip_autogen/pinmux/data/top_earlgrey_pinmux.ipconfig.hjson)'''
          ]
          kind: "spec"
          testpoint: "usb_conn"
          checks: ["wake request out (assert_UsbConn_WakeRequestOut)"]
          why: '''The check compares `usb_wkup_req` with the module's `wake_req_aon_o` port in every cycle. The comparison also covers a one-cycle pulse.'''
          milestone: "V2"
          priority: "2"
          security: false
          state: "open"
        }
        {
          name: REQ_USB_04a
          desc: '''The module shall run on `clk_aon_i`.'''
          source: [
            '''[Inter-Module Signals](hw/top_earlgrey/ip_autogen/pinmux/doc/interfaces.md#inter-module-signals)'''
            '''[USB Wakeup Detection Module](hw/top_earlgrey/ip_autogen/pinmux/doc/theory_of_operation.md#usb-wakeup-detection-module)'''
            '''[AON/Wake Clocking](hw/ip/usbdev/doc/theory_of_operation.md#aonwake-clocking)'''
            '''[top_earlgrey_pinmux.ipconfig.hjson `enable_usb_wakeup`](hw/top_earlgrey/ip_autogen/pinmux/data/top_earlgrey_pinmux.ipconfig.hjson)'''
          ]
          kind: "spec"
          testpoint: "usb_conn"
          checks: ["module on AON clock (assert_UsbConn_ModuleOnAonClock)"]
          why: '''The check compares the module's clock with `clk_aon_i` in every cycle. The proofs clock `clk_aon_i` slower than `clk_i`, so a module on `clk_i` fails the check.'''
          milestone: "V2"
          priority: "2"
          security: false
          state: "open"
        }
        {
          name: REQ_USB_04b
          desc: '''The module shall be reset by `rst_aon_ni`.'''
          source: [
            '''[pinmux.hjson `clocking`](hw/top_earlgrey/ip_autogen/pinmux/data/pinmux.hjson)'''
            '''[top_earlgrey_pinmux.ipconfig.hjson `enable_usb_wakeup`](hw/top_earlgrey/ip_autogen/pinmux/data/top_earlgrey_pinmux.ipconfig.hjson)'''
            '''[AON/Wake Clocking](hw/ip/usbdev/doc/theory_of_operation.md#aonwake-clocking)'''
          ]
          kind: "spec"
          testpoint: "usb_conn"
          checks: ["module on AON reset (check_UsbConn_ModuleOnAonReset)"]
          why: '''The check requires `rst_aon_ni` to drive the reset pin of every flop of the module.'''
          milestone: "V2"
          priority: "2"
          security: false
          state: "open"
        }
        {
          name: REQ_USB_05a
          desc: '''The module's D+ input shall be the signal that the pinmux delivers to usbdev as its D+ input. That signal is the input of the USB D+ pad, which is a DIO pad.'''
          source: [
            '''[AON/Wake Interface Pins](hw/ip/usbdev/doc/theory_of_operation.md#aonwake-interface-pins)'''
            '''[top_earlgrey.hjson `pinout.pads USB_P`](hw/top_earlgrey/data/top_earlgrey.hjson)'''
            '''[top_earlgrey.hjson `pinmux`](hw/top_earlgrey/data/top_earlgrey.hjson)'''
            '''[top_earlgrey.hjson `pinmux.signals`](hw/top_earlgrey/data/top_earlgrey.hjson)'''
            '''[top_earlgrey_pinmux.ipconfig.hjson `enable_usb_wakeup`](hw/top_earlgrey/ip_autogen/pinmux/data/top_earlgrey_pinmux.ipconfig.hjson)'''
          ]
          kind: "spec"
          testpoint: "usb_conn"
          checks: ["bus inputs (assert_UsbConn_BusInputs)"]
          why: '''The check compares the module's D+ input with the USB D+ pad in every cycle. An input taken from the USB D- pad, from another pad or through a flop fails the check.'''
          milestone: "V2"
          priority: "2"
          security: false
          state: "open"
        }
        {
          name: REQ_USB_05b
          desc: '''The module's D- input shall be the signal that the pinmux delivers to usbdev as its D- input. That signal is the input of the USB D- pad, which is a DIO pad.'''
          source: [
            '''[AON/Wake Interface Pins](hw/ip/usbdev/doc/theory_of_operation.md#aonwake-interface-pins)'''
            '''[top_earlgrey.hjson `pinout.pads USB_N`](hw/top_earlgrey/data/top_earlgrey.hjson)'''
            '''[top_earlgrey.hjson `pinmux`](hw/top_earlgrey/data/top_earlgrey.hjson)'''
            '''[top_earlgrey.hjson `pinmux.signals`](hw/top_earlgrey/data/top_earlgrey.hjson)'''
            '''[top_earlgrey_pinmux.ipconfig.hjson `enable_usb_wakeup`](hw/top_earlgrey/ip_autogen/pinmux/data/top_earlgrey_pinmux.ipconfig.hjson)'''
          ]
          kind: "spec"
          testpoint: "usb_conn"
          checks: ["bus inputs (assert_UsbConn_BusInputs)"]
          why: '''The check compares the module's D- input with the USB D- pad in every cycle. An input taken from the USB D+ pad, from another pad or through a flop fails the check.'''
          milestone: "V2"
          priority: "2"
          security: false
          state: "open"
        }
        {
          name: REQ_USB_05c
          desc: '''The module's VBUS input shall be the signal that the pinmux delivers to usbdev as its VBUS input. That signal is the muxed input `sense` after its input select.'''
          source: [
            '''[AON/Wake Interface Pins](hw/ip/usbdev/doc/theory_of_operation.md#aonwake-interface-pins)'''
            '''[top_earlgrey.hjson `pinmux`](hw/top_earlgrey/data/top_earlgrey.hjson)'''
            '''[top_earlgrey.hjson `pinmux.signals`](hw/top_earlgrey/data/top_earlgrey.hjson)'''
            '''[top_earlgrey_pinmux.ipconfig.hjson `enable_usb_wakeup`](hw/top_earlgrey/ip_autogen/pinmux/data/top_earlgrey_pinmux.ipconfig.hjson)'''
          ]
          kind: "spec"
          testpoint: "usb_conn"
          checks: ["bus inputs (assert_UsbConn_BusInputs)"]
          why: '''The check compares the module's VBUS input with usbdev's sense input in every cycle. The check takes the sense input after its input select.'''
          milestone: "V2"
          priority: "2"
          security: false
          state: "open"
        }
        {
          name: REQ_USB_06a
          desc: '''While the module is inactive, a suspend request shall make it active within a bounded time.'''
          source: [
            '''[Suspending](hw/ip/usbdev/doc/wake_resume.md#suspending)'''
            '''[usbdev.hjson `wake_control.suspend_req`](hw/ip/usbdev/data/usbdev.hjson)'''
            '''[Inter-Module Signals](hw/ip/usbdev/doc/interfaces.md#inter-module-signals)'''
            '''[top_earlgrey_pinmux.ipconfig.hjson `enable_usb_wakeup`](hw/top_earlgrey/ip_autogen/pinmux/data/top_earlgrey_pinmux.ipconfig.hjson)'''
            '''No specification states the length of the bound.'''
          ]
          kind: "spec"
          testpoint: "usb_module"
          checks: ["request activates (assert_UsbModule_RequestActivates)"]
          why: '''The check requires `usbdev_wake_detect_active` to be 1 within 2 AON clock cycles of each suspend request that comes while the module is inactive.'''
          milestone: "V2"
          priority: "2"
          security: false
          state: "open"
        }
        {
          name: REQ_USB_06b
          desc: '''While the module is active, a wake acknowledge shall make it inactive within a bounded time.'''
          source: [
            '''[Resuming](hw/ip/usbdev/doc/wake_resume.md#resuming)'''
            '''[usbdev.hjson `wake_control.wake_ack`](hw/ip/usbdev/data/usbdev.hjson)'''
            '''[Inter-Module Signals](hw/ip/usbdev/doc/interfaces.md#inter-module-signals)'''
            '''[Inter-Module Signals](hw/top_earlgrey/ip_autogen/pinmux/doc/interfaces.md#inter-module-signals)'''
            '''[top_earlgrey_pinmux.ipconfig.hjson `enable_usb_wakeup`](hw/top_earlgrey/ip_autogen/pinmux/data/top_earlgrey_pinmux.ipconfig.hjson)'''
            '''No specification states the length of the bound.'''
          ]
          kind: "spec"
          testpoint: "usb_module"
          checks: ["acknowledge releases (assert_UsbModule_AcknowledgeReleases)"]
          why: '''The check requires `usbdev_wake_detect_active` to be 0 within 2 AON clock cycles of each wake acknowledge that comes while the module is active.'''
          milestone: "V2"
          priority: "2"
          security: false
          state: "open"
        }
        {
          name: REQ_USB_06c
          desc: '''Only a suspend request made while the module is inactive shall make the module active. Only a wake acknowledge made while the module is active shall make the module inactive.'''
          source: [
            '''[Suspending](hw/ip/usbdev/doc/wake_resume.md#suspending)'''
            '''[Resuming](hw/ip/usbdev/doc/wake_resume.md#resuming)'''
            '''[usbdev.hjson `wake_control.suspend_req`](hw/ip/usbdev/data/usbdev.hjson)'''
            '''[usbdev.hjson `wake_control.wake_ack`](hw/ip/usbdev/data/usbdev.hjson)'''
            '''[Inter-Module Signals](hw/ip/usbdev/doc/interfaces.md#inter-module-signals)'''
            '''[top_earlgrey_pinmux.ipconfig.hjson `enable_usb_wakeup`](hw/top_earlgrey/ip_autogen/pinmux/data/top_earlgrey_pinmux.ipconfig.hjson)'''
          ]
          kind: "spec"
          testpoint: "usb_module"
          checks: ["no other state change (assert_UsbModule_NoOtherStateChange)"]
          why: '''The check allows `usbdev_wake_detect_active` to rise only after a suspend request, and to fall only after a wake acknowledge.'''
          milestone: "V2"
          priority: "2"
          security: false
          state: "open"
        }
        {
          name: REQ_USB_06d
          desc: '''While the module is inactive, each pad pull-up enable (`usb_dppullup_en` and `usb_dnpullup_en`) shall equal usbdev's pull-up enable for the same line, in the same cycle.'''
          source: [
            '''[AON/Wake Interface Pins](hw/ip/usbdev/doc/theory_of_operation.md#aonwake-interface-pins)'''
            '''[Resuming](hw/ip/usbdev/doc/wake_resume.md#resuming)'''
            '''[usbdev.hjson `wake_control.wake_ack`](hw/ip/usbdev/data/usbdev.hjson)'''
            '''[Inter-Module Signals](hw/top_earlgrey/ip_autogen/pinmux/doc/interfaces.md#inter-module-signals)'''
            '''[top_earlgrey_pinmux.ipconfig.hjson `enable_usb_wakeup`](hw/top_earlgrey/ip_autogen/pinmux/data/top_earlgrey_pinmux.ipconfig.hjson)'''
          ]
          kind: "spec"
          testpoint: "usb_module"
          checks: ["inactive passes pull-ups (assert_UsbModule_InactivePassesPullUps)"]
          why: '''In every cycle that the module is inactive, the check compares each pull-up enable to the pads with usbdev's enable of the same line.'''
          milestone: "V2"
          priority: "2"
          security: false
          state: "open"
        }
        {
          name: REQ_USB_06e
          desc: '''While the module is active and `usbdev_sense_lost` is 0, each pad pull-up enable shall keep the value that usbdev's pull-up enable for the same line had at the suspend request that made the module active.'''
          source: [
            '''[Overview](hw/ip/usbdev/doc/wake_resume.md#overview)'''
            '''[Inter-Module Signals](hw/top_earlgrey/ip_autogen/pinmux/doc/interfaces.md#inter-module-signals)'''
            '''[chip_usbdev_testplan.hjson `chip_sw_usbdev_aon_pullup`](hw/top_earlgrey/data/ip/chip_usbdev_testplan.hjson)'''
            '''[top_earlgrey_pinmux.ipconfig.hjson `enable_usb_wakeup`](hw/top_earlgrey/ip_autogen/pinmux/data/top_earlgrey_pinmux.ipconfig.hjson)'''
          ]
          kind: "spec"
          testpoint: "usb_module"
          checks: ["active holds pull-ups (assert_UsbModule_ActiveHoldsPullUps)", "waits: pull-ups after VBUS loss"]
          why: '''In every cycle that the module is active and `usbdev_sense_lost` is 0, the check requires each pull-up enable to the pads to equal usbdev's enable of its line at the suspend request. No specification says what the pull-ups do after VBUS is lost.'''
          milestone: "V2"
          priority: "2"
          security: false
          state: "open"
        }
        {
          name: REQ_USB_06f
          desc: '''While the module is active, each of three conditions that is held on the USB lines shall set its event within a bounded time. The three conditions are bus not idle, bus reset (D+ and D- both low) and sense lost (VBUS low).'''
          source: [
            '''[Optional external AON/Wake functionality](hw/ip/usbdev/doc/theory_of_operation.md#optional-external-aonwake-functionality)'''
            '''[AON/Wake Clocking](hw/ip/usbdev/doc/theory_of_operation.md#aonwake-clocking)'''
            '''[usbdev.hjson `wake_events.disconnected`](hw/ip/usbdev/data/usbdev.hjson)'''
            '''[usbdev.hjson `wake_events.bus_reset`](hw/ip/usbdev/data/usbdev.hjson)'''
            '''[usbdev.hjson `wake_events.bus_not_idle`](hw/ip/usbdev/data/usbdev.hjson)'''
            '''[Inter-Module Signals](hw/ip/usbdev/doc/interfaces.md#inter-module-signals)'''
            '''[Inter-Module Signals](hw/top_earlgrey/ip_autogen/pinmux/doc/interfaces.md#inter-module-signals)'''
            '''[usbdev_testplan.hjson `aon_wake_resume`](hw/ip/usbdev/data/usbdev_testplan.hjson)'''
            '''[usbdev_testplan.hjson `aon_wake_reset`](hw/ip/usbdev/data/usbdev_testplan.hjson)'''
            '''[usbdev_testplan.hjson `aon_wake_disconnect`](hw/ip/usbdev/data/usbdev_testplan.hjson)'''
            '''[top_earlgrey_pinmux.ipconfig.hjson `enable_usb_wakeup`](hw/top_earlgrey/ip_autogen/pinmux/data/top_earlgrey_pinmux.ipconfig.hjson)'''
            '''No specification states the length of the bound, and the idle state of the lines while no pull-up enable is 1 or both are 1.'''
          ]
          kind: "spec"
          testpoint: "usb_module"
          checks: ["held condition sets event (assert_UsbModule_HeldConditionSetsEvent)"]
          why: '''The check requires each event to be 1 once its condition has been on the USB lines in one cycle and in each of the 8 cycles after it.'''
          milestone: "V2"
          priority: "2"
          security: false
          state: "open"
        }
        {
          name: REQ_USB_06g
          desc: '''The module shall set an event only after the event's own condition has been on the USB lines, with the module active, for at least the shortest time that the module must report.'''
          source: [
            '''[usbdev.hjson `wake_events.disconnected`](hw/ip/usbdev/data/usbdev.hjson)'''
            '''[usbdev.hjson `wake_events.bus_reset`](hw/ip/usbdev/data/usbdev.hjson)'''
            '''[usbdev.hjson `wake_events.bus_not_idle`](hw/ip/usbdev/data/usbdev.hjson)'''
            '''[Inter-Module Signals](hw/top_earlgrey/ip_autogen/pinmux/doc/interfaces.md#inter-module-signals)'''
            '''[AON/Wake Clocking](hw/ip/usbdev/doc/theory_of_operation.md#aonwake-clocking)'''
            '''[top_earlgrey_pinmux.ipconfig.hjson `enable_usb_wakeup`](hw/top_earlgrey/ip_autogen/pinmux/data/top_earlgrey_pinmux.ipconfig.hjson)'''
          ]
          kind: "spec"
          testpoint: "usb_module"
          checks: ["event only after its condition (assert_UsbModule_EventOnlyAfterItsCondition)", "waits: short condition sets no event"]
          why: '''The check allows an event to rise only on its own condition. The condition must be seen while the module is active, and the module must stay active from then until the rise. No specification gives the shortest time that a condition must last.'''
          milestone: "V2"
          priority: "2"
          security: false
          state: "open"
        }
        {
          name: REQ_USB_06h
          desc: '''An event, once set, shall stay set for as long as the module stays active.'''
          source: [
            '''[Resuming](hw/ip/usbdev/doc/wake_resume.md#resuming)'''
            '''[Inter-Module Signals](hw/ip/usbdev/doc/interfaces.md#inter-module-signals)'''
            '''[top_earlgrey_pinmux.ipconfig.hjson `enable_usb_wakeup`](hw/top_earlgrey/ip_autogen/pinmux/data/top_earlgrey_pinmux.ipconfig.hjson)'''
          ]
          kind: "spec"
          testpoint: "usb_module"
          checks: ["event holds while active (assert_UsbModule_EventHoldsWhileActive)"]
          why: '''The check requires an event that is 1 to stay 1 in the next cycle while the module stays active. The check applies at every value of the USB lines.'''
          milestone: "V2"
          priority: "2"
          security: false
          state: "open"
        }
        {
          name: REQ_USB_06i
          desc: '''A wake acknowledge made while the module is active shall clear each of the three events within a bounded time.'''
          source: [
            '''[Resuming](hw/ip/usbdev/doc/wake_resume.md#resuming)'''
            '''[Inter-Module Signals](hw/top_earlgrey/ip_autogen/pinmux/doc/interfaces.md#inter-module-signals)'''
            '''[top_earlgrey_pinmux.ipconfig.hjson `enable_usb_wakeup`](hw/top_earlgrey/ip_autogen/pinmux/data/top_earlgrey_pinmux.ipconfig.hjson)'''
            '''No specification states the length of the bound.'''
          ]
          kind: "spec"
          testpoint: "usb_module"
          checks: ["acknowledge clears events (assert_UsbModule_AcknowledgeClearsEvents)"]
          why: '''After each wake acknowledge that comes while the module is active, the check requires each of the three events to be 0 in one of the next 4 AON clock cycles.'''
          milestone: "V2"
          priority: "2"
          security: false
          state: "open"
        }
        {
          name: REQ_USB_06j
          desc: '''The module's wake request shall be 1 while at least one of its three events is set, and 0 while none of them is set.'''
          source: [
            '''[Overview](hw/ip/usbdev/doc/wake_resume.md#overview)'''
            '''[usbdev_testplan.hjson `aon_wake_resume`](hw/ip/usbdev/data/usbdev_testplan.hjson)'''
            '''[usbdev_testplan.hjson `aon_wake_reset`](hw/ip/usbdev/data/usbdev_testplan.hjson)'''
            '''[usbdev_testplan.hjson `aon_wake_disconnect`](hw/ip/usbdev/data/usbdev_testplan.hjson)'''
            '''[Inter-Module Signals](hw/ip/usbdev/doc/interfaces.md#inter-module-signals)'''
            '''[Inter-Module Signals](hw/top_earlgrey/ip_autogen/pinmux/doc/interfaces.md#inter-module-signals)'''
            '''[Wakeup Recording](hw/top_earlgrey/ip_autogen/pwrmgr/doc/theory_of_operation.md#wakeup-recording)'''
            '''[top_earlgrey_pinmux.ipconfig.hjson `enable_usb_wakeup`](hw/top_earlgrey/ip_autogen/pinmux/data/top_earlgrey_pinmux.ipconfig.hjson)'''
            '''No specification states the delay from the events to the request.'''
          ]
          kind: "spec"
          testpoint: "usb_module"
          checks: ["wake request follows events (assert_UsbModule_WakeRequestFollowsEvents)"]
          why: '''The check compares `usb_wkup_req` with the three events in every cycle. The check requires `usb_wkup_req` to be 1 when at least one event is 1, and 0 when none is.'''
          milestone: "V2"
          priority: "2"
          security: false
          state: "open"
        }
      ]
    }
    {
      name: '''Strap sampling'''
      conditions: [
        '''The TAP straps are seen through the TAP that is connected (TAP selection and the JTAG pads).'''
        '''Full reset and NDM reset are defined in the Terms.'''
        '''The life cycle conditions follow the table of life cycle states ([Manufacturing States](doc/security/specs/device_life_cycle/README.md#manufacturing-states)), after the delay of the input synchronizers.'''
        '''The top description assigns the TAP strap 0 pad and the TAP strap 1 pad, which the table Pads by role lists.'''
      ]
      requirements: [
        {
          name: REQ_STRAP_01
          desc: '''At each `strap_en_i` pulse, TAP strap 0 shall take the value of the TAP strap 0 pad, if `dft_hold_tap_sel_i` is 0. This holds in every life cycle state.'''
          source: [
            '''[Strap Sampling and TAP Isolation](hw/top_earlgrey/ip_autogen/pinmux/doc/theory_of_operation.md#strap-sampling-and-tap-isolation)'''
            '''[top_earlgrey.hjson `targets.asic.pinmux.special_signals tap0`](hw/top_earlgrey/data/top_earlgrey.hjson)'''
            '''[top_earlgrey_pinmux.ipconfig.hjson `enable_strap_sampling`](hw/top_earlgrey/ip_autogen/pinmux/data/top_earlgrey_pinmux.ipconfig.hjson)'''
          ]
          kind: "spec"
          testpoint: "strap"
          checks: ["pulse samples the straps (assert_Strap_PulseSamplesTheStraps)"]
          why: '''The check compares strap 0 after a strap pulse with the TAP strap 0 pad. The check accepts the value of the pad in the pulse cycle or in the cycle after it.'''
          milestone: "V2S"
          priority: "1"
          security: true
          state: "open"
        }
        {
          name: REQ_STRAP_02a
          desc: '''At a `strap_en_i` pulse, TAP strap 1 shall take the value of the TAP strap 1 pad, if `dft_hold_tap_sel_i` is 0 and `lc_hw_debug_en_i` is On. `REQ_STRAP_03` states the one exception.'''
          source: [
            '''[Strap Sampling and TAP Isolation](hw/top_earlgrey/ip_autogen/pinmux/doc/theory_of_operation.md#strap-sampling-and-tap-isolation)'''
            '''[top_earlgrey.hjson `targets.asic.pinmux.special_signals tap1`](hw/top_earlgrey/data/top_earlgrey.hjson)'''
            '''[top_earlgrey_pinmux.ipconfig.hjson `enable_strap_sampling`](hw/top_earlgrey/ip_autogen/pinmux/data/top_earlgrey_pinmux.ipconfig.hjson)'''
            '''[Manufacturing States](doc/security/specs/device_life_cycle/README.md#manufacturing-states)'''
          ]
          kind: "spec"
          testpoint: "strap"
          checks: ["pulse samples the straps (assert_Strap_PulseSamplesTheStraps)"]
          why: '''When `lc_hw_debug_en_i` is steadily On at a strap pulse, the check compares strap 1 after the pulse with the TAP strap 1 pad. The check accepts the value of the pad in the pulse cycle or in the cycle after it.'''
          milestone: "V2S"
          priority: "1"
          security: true
          state: "open"
        }
        {
          name: REQ_STRAP_02b
          desc: '''At each `strap_en_i` pulse, TAP strap 1 shall keep its value, if `lc_hw_debug_en_i` is not On. `REQ_STRAP_03` states the one exception.'''
          source: [
            '''[Strap Sampling and TAP Isolation](hw/top_earlgrey/ip_autogen/pinmux/doc/theory_of_operation.md#strap-sampling-and-tap-isolation)'''
            '''[top_earlgrey.hjson `targets.asic.pinmux.special_signals tap1`](hw/top_earlgrey/data/top_earlgrey.hjson)'''
            '''[top_earlgrey_pinmux.ipconfig.hjson `enable_strap_sampling`](hw/top_earlgrey/ip_autogen/pinmux/data/top_earlgrey_pinmux.ipconfig.hjson)'''
            '''[Manufacturing States](doc/security/specs/device_life_cycle/README.md#manufacturing-states)'''
          ]
          kind: "spec"
          testpoint: "strap"
          checks: ["pulse samples the straps (assert_Strap_PulseSamplesTheStraps)"]
          why: '''When neither `lc_hw_debug_en_i` nor `lc_dft_en_i` was On before a strap pulse, the check requires strap 1 to be unchanged after the pulse.'''
          milestone: "V2S"
          priority: "1"
          security: true
          state: "open"
        }
        {
          name: REQ_STRAP_03
          desc: '''While `lc_dft_en_i` is On and `dft_hold_tap_sel_i` is 0, each TAP strap shall take the value that its pad had in the cycle before. TAP strap 0 is sampled from the TAP strap 0 pad, and TAP strap 1 is sampled from the TAP strap 1 pad.'''
          source: [
            '''[Strap Sampling and TAP Isolation](hw/top_earlgrey/ip_autogen/pinmux/doc/theory_of_operation.md#strap-sampling-and-tap-isolation)'''
            '''[top_earlgrey.hjson `targets.asic.pinmux.special_signals`](hw/top_earlgrey/data/top_earlgrey.hjson)'''
            '''[top_earlgrey_pinmux.ipconfig.hjson `enable_strap_sampling`](hw/top_earlgrey/ip_autogen/pinmux/data/top_earlgrey_pinmux.ipconfig.hjson)'''
            '''[Manufacturing States](doc/security/specs/device_life_cycle/README.md#manufacturing-states)'''
          ]
          kind: "spec"
          testpoint: "strap"
          checks: ["straps follow the pads (assert_Strap_StrapsFollowThePads)"]
          why: '''While `lc_dft_en_i` is steadily On, the check compares strap 0 with the value of the TAP strap 0 pad in the cycle before. The check compares strap 1 with the TAP strap 1 pad in the same way.'''
          milestone: "V2S"
          priority: "1"
          security: true
          state: "open"
        }
        {
          name: REQ_STRAP_04
          desc: '''While `dft_hold_tap_sel_i` is 1, the TAP straps shall keep their values. This holds at a `strap_en_i` pulse too.'''
          source: [
            '''[Strap Sampling and TAP Isolation](hw/top_earlgrey/ip_autogen/pinmux/doc/theory_of_operation.md#strap-sampling-and-tap-isolation)'''
            '''[top_earlgrey_pinmux.ipconfig.hjson `enable_strap_sampling`](hw/top_earlgrey/ip_autogen/pinmux/data/top_earlgrey_pinmux.ipconfig.hjson)'''
          ]
          kind: "spec"
          testpoint: "strap"
          checks: ["straps hold (assert_Strap_StrapsHold)"]
          why: '''While `dft_hold_tap_sel_i` is 1, the check requires both straps to be unchanged in the next cycle. The check requires this at a strap pulse too, and while `lc_dft_en_i` is On.'''
          milestone: "V2S"
          priority: "1"
          security: true
          state: "open"
        }
        {
          name: REQ_STRAP_05
          desc: '''In a cycle without a `strap_en_i` pulse, the TAP straps shall keep their values. `REQ_STRAP_03` states the one exception, which applies while `lc_dft_en_i` is On and `dft_hold_tap_sel_i` is 0.'''
          source: [
            '''[Strap Sampling and TAP Isolation](hw/top_earlgrey/ip_autogen/pinmux/doc/theory_of_operation.md#strap-sampling-and-tap-isolation)'''
            '''[top_earlgrey_pinmux.ipconfig.hjson `enable_strap_sampling`](hw/top_earlgrey/ip_autogen/pinmux/data/top_earlgrey_pinmux.ipconfig.hjson)'''
          ]
          kind: "spec"
          testpoint: "strap"
          checks: ["straps hold (assert_Strap_StrapsHold)"]
          why: '''The check applies in a cycle without a strap pulse when `lc_dft_en_i` was On in neither of the two cycles before. In such a cycle, the check requires both straps to be unchanged and allows the pads to take any value.'''
          milestone: "V2S"
          priority: "1"
          security: true
          state: "open"
        }
        {
          name: REQ_STRAP_06
          desc: '''A TAP strap that has not been sampled since the last full reset shall read 0.'''
          source: [
            '''[Strap Sampling and TAP Isolation](hw/top_earlgrey/ip_autogen/pinmux/doc/theory_of_operation.md#strap-sampling-and-tap-isolation)'''
            '''[top_earlgrey_pinmux.ipconfig.hjson `enable_strap_sampling`](hw/top_earlgrey/ip_autogen/pinmux/data/top_earlgrey_pinmux.ipconfig.hjson)'''
          ]
          kind: "RTL"
          testpoint: "strap"
          checks: ["unsampled strap reads 0 (assert_Strap_UnsampledStrapReads0)", "pulse samples the straps (assert_Strap_PulseSamplesTheStraps)", "straps hold (assert_Strap_StrapsHold)"]
          why: '''The check _unsampled strap reads 0_ requires both straps to be 0 from a full reset until a sample. The other two checks require a strap 1 that was never sampled to stay at 0.'''
          milestone: "V2S"
          priority: "1"
          security: true
          state: "open"
        }
        {
          name: REQ_STRAP_07
          desc: '''An NDM reset shall leave both TAP straps unchanged.'''
          source: [
            '''[Non-debug Module Reset](hw/top_earlgrey/ip_autogen/pinmux/doc/theory_of_operation.md#non-debug-module-reset)'''
            '''[Reset Request Handling](hw/top_earlgrey/ip_autogen/pwrmgr/doc/theory_of_operation.md#reset-request-handling)'''
            '''[System Reset Tree](hw/top_earlgrey/ip_autogen/rstmgr/doc/theory_of_operation.md#system-reset-tree)'''
            '''[Summary](hw/top_earlgrey/ip_autogen/rstmgr/doc/theory_of_operation.md#summary)'''
            '''[top_earlgrey.hjson `resets.nodes lc_io_div4`](hw/top_earlgrey/data/top_earlgrey.hjson)'''
            '''[top_earlgrey.hjson `resets.nodes sys_io_div4`](hw/top_earlgrey/data/top_earlgrey.hjson)'''
            '''[top_earlgrey.hjson `module.pinmux`](hw/top_earlgrey/data/top_earlgrey.hjson)'''
            '''[top_earlgrey_pinmux.ipconfig.hjson `enable_strap_sampling`](hw/top_earlgrey/ip_autogen/pinmux/data/top_earlgrey_pinmux.ipconfig.hjson)'''
          ]
          kind: "spec"
          testpoint: "strap"
          checks: ["straps outside NDM reset (check_Strap_StrapsOutsideNdmReset)"]
          why: '''The check fails when `rst_ni` or `rst_aon_ni` reaches the reset pin or the input cone of a flop that holds a sampled TAP strap. An NDM reset asserts these two resets.'''
          milestone: "V2S"
          priority: "1"
          security: true
          state: "open"
        }
        {
          name: REQ_STRAP_08
          desc: '''While the parameter `SecVolatileRawUnlockEn` is 0, `strap_en_override_i` shall not change the straps.'''
          source: [
            '''[Inter-Module Signals](hw/top_earlgrey/ip_autogen/pinmux/doc/interfaces.md#inter-module-signals)'''
            '''[pinmux.hjson `param_list` SecVolatileRawUnlockEn](hw/top_earlgrey/ip_autogen/pinmux/data/pinmux.hjson)'''
            '''[Volatile `RAW` -> `TEST_UNLOCKED0` Transition](hw/ip/lc_ctrl/doc/programmers_guide.md#volatile-raw---test_unlocked0-transition)'''
            '''[top_earlgrey_pinmux.ipconfig.hjson `enable_strap_sampling`](hw/top_earlgrey/ip_autogen/pinmux/data/top_earlgrey_pinmux.ipconfig.hjson)'''
          ]
          kind: "spec"
          testpoint: "strap"
          checks: ["straps hold (assert_Strap_StrapsHold)"]
          why: '''With `strap_en_override_i` free in every cycle, the check requires the straps to be unchanged in each cycle in which no sample is due.'''
          milestone: "V2S"
          priority: "1"
          security: true
          state: "open"
        }
      ]
    }
    {
      name: '''Latched debug enable'''
      conditions: [
        '''The latch, On and Off are defined in the Terms.'''
      ]
      requirements: [
        {
          name: REQ_DBG_01a
          desc: '''At each `strap_en_i` pulse, the latch shall take the value On if `lc_hw_debug_en_i` is On. `REQ_DBG_09` states the one exception.'''
          source: [
            '''[Non-debug Module Reset](hw/top_earlgrey/ip_autogen/pinmux/doc/theory_of_operation.md#non-debug-module-reset)'''
            '''[Inter-Module Signals](hw/top_earlgrey/ip_autogen/pinmux/doc/interfaces.md#inter-module-signals)'''
            '''[top_earlgrey_pinmux.ipconfig.hjson `enable_strap_sampling`](hw/top_earlgrey/ip_autogen/pinmux/data/top_earlgrey_pinmux.ipconfig.hjson)'''
          ]
          kind: "spec"
          testpoint: "latch"
          checks: ["pulse samples debug enable (assert_Latch_PulseSamplesDebugEnable)"]
          why: '''At a strap pulse with `lc_hw_debug_en_i` steadily On and the clear inputs at Off, the check compares `pinmux_hw_debug_en_o` with On in the next cycle.'''
          milestone: "V2S"
          priority: "1"
          security: true
          state: "open"
        }
        {
          name: REQ_DBG_01b
          desc: '''At each `strap_en_i` pulse, the latch shall take the value Off if `lc_hw_debug_en_i` is not On.'''
          source: [
            '''[Non-debug Module Reset](hw/top_earlgrey/ip_autogen/pinmux/doc/theory_of_operation.md#non-debug-module-reset)'''
            '''[Inter-Module Signals](hw/top_earlgrey/ip_autogen/pinmux/doc/interfaces.md#inter-module-signals)'''
            '''[top_earlgrey_pinmux.ipconfig.hjson `enable_strap_sampling`](hw/top_earlgrey/ip_autogen/pinmux/data/top_earlgrey_pinmux.ipconfig.hjson)'''
          ]
          kind: "spec"
          testpoint: "latch"
          checks: ["pulse samples debug enable (assert_Latch_PulseSamplesDebugEnable)", "On only at a pulse (assert_Latch_OnOnlyAtAPulse)"]
          why: '''The check _pulse samples debug enable_ requires the latch to be Off after a strap pulse with the debug enable not On. The check _On only at a pulse_ allows a rise to On only at a strap pulse with the debug enable On.'''
          milestone: "V2S"
          priority: "1"
          security: true
          state: "open"
        }
        {
          name: REQ_DBG_02
          desc: '''The latch shall keep its value in each cycle with no `strap_en_i` pulse, no clear and no full reset. This holds through an NDM reset too.'''
          source: [
            '''[Non-debug Module Reset](hw/top_earlgrey/ip_autogen/pinmux/doc/theory_of_operation.md#non-debug-module-reset)'''
            '''[System Reset Tree](hw/top_earlgrey/ip_autogen/rstmgr/doc/theory_of_operation.md#system-reset-tree)'''
            '''[Summary](hw/top_earlgrey/ip_autogen/rstmgr/doc/theory_of_operation.md#summary)'''
            '''[top_earlgrey.hjson `resets.nodes lc_io_div4`](hw/top_earlgrey/data/top_earlgrey.hjson)'''
            '''[top_earlgrey.hjson `resets.nodes sys_io_div4`](hw/top_earlgrey/data/top_earlgrey.hjson)'''
            '''[top_earlgrey.hjson `module.pinmux`](hw/top_earlgrey/data/top_earlgrey.hjson)'''
            '''[top_earlgrey_pinmux.ipconfig.hjson `enable_strap_sampling`](hw/top_earlgrey/ip_autogen/pinmux/data/top_earlgrey_pinmux.ipconfig.hjson)'''
          ]
          kind: "spec"
          testpoint: "latch"
          checks: ["latch holds (assert_Latch_LatchHolds)", "latch outside NDM reset (check_Latch_LatchOutsideNdmReset)"]
          why: '''The check _latch holds_ requires the output to keep its value. The check _latch outside NDM reset_ fails when `rst_ni` or `rst_aon_ni`, which an NDM reset asserts, reaches the reset pin or input cone of a latch flop.'''
          milestone: "V2S"
          priority: "1"
          security: true
          state: "open"
        }
        {
          name: REQ_DBG_03
          desc: '''Any value other than Off on `lc_hw_debug_clr_i` shall turn the latch Off.'''
          source: [
            '''[Non-debug Module Reset](hw/top_earlgrey/ip_autogen/pinmux/doc/theory_of_operation.md#non-debug-module-reset)'''
            '''[lc_ctrl.hjson `inter_signal_list` lc_hw_debug_clr](hw/ip/lc_ctrl/data/lc_ctrl.hjson)'''
            '''[HW_DEBUG_CLR](hw/ip/lc_ctrl/doc/theory_of_operation.md#hw_debug_clr)'''
            '''[Control Signal Propagation](hw/ip/lc_ctrl/doc/interfaces.md#control-signal-propagation)'''
            '''[top_earlgrey_pinmux.ipconfig.hjson `enable_strap_sampling`](hw/top_earlgrey/ip_autogen/pinmux/data/top_earlgrey_pinmux.ipconfig.hjson)'''
          ]
          kind: "spec"
          testpoint: "latch"
          checks: ["clear turns Off (assert_Latch_ClearTurnsOff)"]
          why: '''The check requires the latch to be Off one cycle after `lc_hw_debug_clr_i` has held a value other than Off for two cycles. The value On counts as other than Off.'''
          milestone: "V2S"
          priority: "1"
          security: true
          state: "open"
        }
        {
          name: REQ_DBG_04
          desc: '''Any value other than Off on `lc_check_byp_en_i` shall turn the latch Off.'''
          source: [
            '''[Non-debug Module Reset](hw/top_earlgrey/ip_autogen/pinmux/doc/theory_of_operation.md#non-debug-module-reset)'''
            '''[Inter-Module Signals](hw/top_earlgrey/ip_autogen/pinmux/doc/interfaces.md#inter-module-signals)'''
            '''[top_earlgrey_pinmux.ipconfig.hjson `enable_strap_sampling`](hw/top_earlgrey/ip_autogen/pinmux/data/top_earlgrey_pinmux.ipconfig.hjson)'''
          ]
          kind: "spec"
          testpoint: "latch"
          checks: ["clear turns Off (assert_Latch_ClearTurnsOff)"]
          why: '''The check requires the latch to be Off one cycle after `lc_check_byp_en_i` has held a value other than Off for two cycles. The value On counts as other than Off.'''
          milestone: "V2S"
          priority: "1"
          security: true
          state: "open"
        }
        {
          name: REQ_DBG_05
          desc: '''Any value other than Off on `lc_escalate_en_i` shall turn the latch Off.'''
          source: [
            '''[Non-debug Module Reset](hw/top_earlgrey/ip_autogen/pinmux/doc/theory_of_operation.md#non-debug-module-reset)'''
            '''[Control Signal Propagation](hw/ip/lc_ctrl/doc/interfaces.md#control-signal-propagation)'''
            '''[top_earlgrey_pinmux.ipconfig.hjson `enable_strap_sampling`](hw/top_earlgrey/ip_autogen/pinmux/data/top_earlgrey_pinmux.ipconfig.hjson)'''
          ]
          kind: "spec"
          testpoint: "latch"
          checks: ["clear turns Off (assert_Latch_ClearTurnsOff)"]
          why: '''The check requires the latch to be Off one cycle after `lc_escalate_en_i` has held any of its 15 values other than Off for two cycles.'''
          milestone: "V2S"
          priority: "1"
          security: true
          state: "open"
        }
        {
          name: REQ_DBG_06
          desc: '''The value Off on `lc_hw_debug_clr_i` and on `lc_check_byp_en_i` shall not turn the latch Off.'''
          source: [
            '''[Non-debug Module Reset](hw/top_earlgrey/ip_autogen/pinmux/doc/theory_of_operation.md#non-debug-module-reset)'''
            '''[top_earlgrey_pinmux.ipconfig.hjson `enable_strap_sampling`](hw/top_earlgrey/ip_autogen/pinmux/data/top_earlgrey_pinmux.ipconfig.hjson)'''
          ]
          kind: "spec"
          testpoint: "latch"
          checks: ["latch holds (assert_Latch_LatchHolds)", "pulse samples debug enable (assert_Latch_PulseSamplesDebugEnable)"]
          why: '''Both checks apply with `lc_hw_debug_clr_i` and `lc_check_byp_en_i` at Off. The checks require the output to hold outside a strap pulse (_latch holds_) and to be On after a sample of On (_pulse samples debug enable_).'''
          milestone: "V2S"
          priority: "1"
          security: true
          state: "open"
        }
        {
          name: REQ_DBG_07a
          desc: '''`pinmux_hw_debug_en_o` shall be On while the latch is On.'''
          source: [
            '''[Inter-Module Signals](hw/top_earlgrey/ip_autogen/pinmux/doc/interfaces.md#inter-module-signals)'''
            '''[pinmux.hjson `countermeasures` PINMUX_HW_DEBUG_EN.INTERSIG.MUBI](hw/top_earlgrey/ip_autogen/pinmux/data/pinmux.hjson)'''
            '''[top_earlgrey_pinmux.ipconfig.hjson `enable_strap_sampling`](hw/top_earlgrey/ip_autogen/pinmux/data/top_earlgrey_pinmux.ipconfig.hjson)'''
          ]
          kind: "spec"
          testpoint: "latch"
          checks: ["output On or Off (assert_Latch_OutputOnOrOff)", "pulse samples debug enable (assert_Latch_PulseSamplesDebugEnable)", "latch holds (assert_Latch_LatchHolds)"]
          why: '''The checks _pulse samples debug enable_ and _latch holds_ require the output to be On after a sample of On and while the latch holds On. The check _output On or Off_ rejects any value but On and Off.'''
          milestone: "V2S"
          priority: "1"
          security: true
          state: "open"
        }
        {
          name: REQ_DBG_07b
          desc: '''`pinmux_hw_debug_en_o` shall be Off while the latch is not On.'''
          source: [
            '''[Inter-Module Signals](hw/top_earlgrey/ip_autogen/pinmux/doc/interfaces.md#inter-module-signals)'''
            '''[pinmux.hjson `countermeasures` PINMUX_HW_DEBUG_EN.INTERSIG.MUBI](hw/top_earlgrey/ip_autogen/pinmux/data/pinmux.hjson)'''
            '''[top_earlgrey_pinmux.ipconfig.hjson `enable_strap_sampling`](hw/top_earlgrey/ip_autogen/pinmux/data/top_earlgrey_pinmux.ipconfig.hjson)'''
          ]
          kind: "spec"
          testpoint: "latch"
          checks: ["output On or Off (assert_Latch_OutputOnOrOff)", "On only at a pulse (assert_Latch_OnOnlyAtAPulse)", "clear turns Off (assert_Latch_ClearTurnsOff)"]
          why: '''The check _output On or Off_ rejects any value but On and Off. The check _On only at a pulse_ rejects an On not taken at a strap pulse. The check _clear turns Off_ rejects any value but Off after a clear.'''
          milestone: "V2S"
          priority: "1"
          security: true
          state: "open"
        }
        {
          name: REQ_DBG_08
          desc: '''After a full reset, the latch shall be Off until the next `strap_en_i` pulse.'''
          source: [
            '''[Inter-Module Signals](hw/top_earlgrey/ip_autogen/pinmux/doc/interfaces.md#inter-module-signals)'''
            '''[lc_ctrl.hjson `inter_signal_list` lc_hw_debug_en](hw/ip/lc_ctrl/data/lc_ctrl.hjson)'''
            '''[top_earlgrey.hjson `resets.nodes lc_io_div4`](hw/top_earlgrey/data/top_earlgrey.hjson)'''
            '''[top_earlgrey.hjson `resets.nodes sys_io_div4`](hw/top_earlgrey/data/top_earlgrey.hjson)'''
            '''[top_earlgrey.hjson `module.pinmux`](hw/top_earlgrey/data/top_earlgrey.hjson)'''
            '''[top_earlgrey_pinmux.ipconfig.hjson `enable_strap_sampling`](hw/top_earlgrey/ip_autogen/pinmux/data/top_earlgrey_pinmux.ipconfig.hjson)'''
          ]
          kind: "spec"
          testpoint: "latch"
          checks: ["Off from full reset (assert_Latch_OffFromFullReset)", "On only at a pulse (assert_Latch_OnOnlyAtAPulse)"]
          why: '''The check _Off from full reset_ requires the latch to be Off in full reset. The check _On only at a pulse_ rejects any rise to On before a strap pulse at which the debug enable is On.'''
          milestone: "V2S"
          priority: "1"
          security: true
          state: "open"
        }
        {
          name: REQ_DBG_09
          desc: '''A clear in the same cycle as a `strap_en_i` pulse shall leave the latch Off.'''
          source: [
            '''[Non-debug Module Reset](hw/top_earlgrey/ip_autogen/pinmux/doc/theory_of_operation.md#non-debug-module-reset)'''
            '''[top_earlgrey_pinmux.ipconfig.hjson `enable_strap_sampling`](hw/top_earlgrey/ip_autogen/pinmux/data/top_earlgrey_pinmux.ipconfig.hjson)'''
          ]
          kind: "spec"
          testpoint: "latch"
          checks: ["clear turns Off (assert_Latch_ClearTurnsOff)"]
          why: '''The check applies to a strap pulse when a clear input held a value other than Off in both of the two cycles before the pulse. The check then requires the latch to be Off in the next cycle, even with `lc_hw_debug_en_i` On.'''
          milestone: "V2S"
          priority: "1"
          security: true
          state: "open"
        }
      ]
    }
    {
      name: '''TAP selection and the JTAG pads'''
      conditions: [
        '''The JTAG pads are the TCK pad, the TMS pad, the TDI pad, the TRST_N pad and the TDO pad, which the top description assigns ([top_earlgrey.hjson `targets.asic.pinmux.special_signals`](hw/top_earlgrey/data/top_earlgrey.hjson)) and the table Pads by role lists.'''
        '''The rows hold once the TAP straps and the life cycle inputs have kept their values for the delay of the input synchronizers.'''
        '''The rows do not hold for TRST_N while scan mode is on.'''
        '''Two documents disagree on the attributes of a JTAG pad that a TAP owns. The theory of operation says "all-zero" ([Strap Sampling and TAP Isolation](hw/top_earlgrey/ip_autogen/pinmux/doc/theory_of_operation.md#strap-sampling-and-tap-isolation)), and the assertion `MioJtagAttrO_A` of the existing testplan keeps the Schmitt trigger on. REQ_TAP_08 follows the theory of operation.'''
      ]
      requirements: [
        {
          name: REQ_TAP_01a
          desc: '''While the TAP straps are 01, the TCK of `lc_jtag_o` shall carry the input of the TCK pad, in every life cycle state.'''
          source: [
            '''[Strap Sampling and TAP Isolation](hw/top_earlgrey/ip_autogen/pinmux/doc/theory_of_operation.md#strap-sampling-and-tap-isolation)'''
            '''[top_earlgrey.hjson `inter_module.connect pinmux.lc_jtag`](hw/top_earlgrey/data/top_earlgrey.hjson)'''
            '''[top_earlgrey.hjson `targets.asic.pinmux.special_signals`](hw/top_earlgrey/data/top_earlgrey.hjson)'''
            '''[top_earlgrey_pinmux.ipconfig.hjson `enable_strap_sampling`](hw/top_earlgrey/ip_autogen/pinmux/data/top_earlgrey_pinmux.ipconfig.hjson)'''
          ]
          kind: "spec"
          testpoint: "jtag"
          checks: ["connected TAP gets the pads (assert_Jtag_ConnectedTapGetsThePads)"]
          why: '''The check compares the `tck` field of `lc_jtag_o` with the TCK pad in the same cycle. The check does this in every life cycle state and in scan mode.'''
          milestone: "V2S"
          priority: "1"
          security: true
          state: "open"
        }
        {
          name: REQ_TAP_01b
          desc: '''While the TAP straps are 01, the TMS of `lc_jtag_o` shall carry the input of the TMS pad, in every life cycle state.'''
          source: [
            '''[Strap Sampling and TAP Isolation](hw/top_earlgrey/ip_autogen/pinmux/doc/theory_of_operation.md#strap-sampling-and-tap-isolation)'''
            '''[top_earlgrey.hjson `inter_module.connect pinmux.lc_jtag`](hw/top_earlgrey/data/top_earlgrey.hjson)'''
            '''[top_earlgrey.hjson `targets.asic.pinmux.special_signals`](hw/top_earlgrey/data/top_earlgrey.hjson)'''
            '''[top_earlgrey_pinmux.ipconfig.hjson `enable_strap_sampling`](hw/top_earlgrey/ip_autogen/pinmux/data/top_earlgrey_pinmux.ipconfig.hjson)'''
          ]
          kind: "spec"
          testpoint: "jtag"
          checks: ["connected TAP gets the pads (assert_Jtag_ConnectedTapGetsThePads)"]
          why: '''The check compares the `tms` field of `lc_jtag_o` with the TMS pad in the same cycle. The check does this in every life cycle state and in scan mode.'''
          milestone: "V2S"
          priority: "1"
          security: true
          state: "open"
        }
        {
          name: REQ_TAP_01c
          desc: '''While the TAP straps are 01, the TDI of `lc_jtag_o` shall carry the input of the TDI pad, in every life cycle state.'''
          source: [
            '''[Strap Sampling and TAP Isolation](hw/top_earlgrey/ip_autogen/pinmux/doc/theory_of_operation.md#strap-sampling-and-tap-isolation)'''
            '''[top_earlgrey.hjson `inter_module.connect pinmux.lc_jtag`](hw/top_earlgrey/data/top_earlgrey.hjson)'''
            '''[top_earlgrey.hjson `targets.asic.pinmux.special_signals`](hw/top_earlgrey/data/top_earlgrey.hjson)'''
            '''[top_earlgrey_pinmux.ipconfig.hjson `enable_strap_sampling`](hw/top_earlgrey/ip_autogen/pinmux/data/top_earlgrey_pinmux.ipconfig.hjson)'''
          ]
          kind: "spec"
          testpoint: "jtag"
          checks: ["connected TAP gets the pads (assert_Jtag_ConnectedTapGetsThePads)"]
          why: '''The check compares the `tdi` field of `lc_jtag_o` with the TDI pad in the same cycle. The check does this in every life cycle state and in scan mode.'''
          milestone: "V2S"
          priority: "1"
          security: true
          state: "open"
        }
        {
          name: REQ_TAP_01d
          desc: '''While the TAP straps are 01, the TRST_N of `lc_jtag_o` shall carry the input of the TRST_N pad, in every life cycle state.'''
          source: [
            '''[Strap Sampling and TAP Isolation](hw/top_earlgrey/ip_autogen/pinmux/doc/theory_of_operation.md#strap-sampling-and-tap-isolation)'''
            '''[top_earlgrey.hjson `inter_module.connect pinmux.lc_jtag`](hw/top_earlgrey/data/top_earlgrey.hjson)'''
            '''[top_earlgrey.hjson `targets.asic.pinmux.special_signals`](hw/top_earlgrey/data/top_earlgrey.hjson)'''
            '''[top_earlgrey_pinmux.ipconfig.hjson `enable_strap_sampling`](hw/top_earlgrey/ip_autogen/pinmux/data/top_earlgrey_pinmux.ipconfig.hjson)'''
          ]
          kind: "spec"
          testpoint: "jtag"
          checks: ["connected TAP gets the pads (assert_Jtag_ConnectedTapGetsThePads)"]
          why: '''Outside scan mode, the check compares the `trst_n` field of `lc_jtag_o` with the TRST_N pad in the same cycle. In scan mode, no specification names the reset that `trst_n` follows.'''
          milestone: "V2S"
          priority: "1"
          security: true
          state: "open"
        }
        {
          name: REQ_TAP_02a
          desc: '''While the TAP straps are 10 and the latch is On, `rv_jtag_o` shall carry the inputs of the TCK pad, the TMS pad, the TDI pad and the TRST_N pad.'''
          source: [
            '''[Strap Sampling and TAP Isolation](hw/top_earlgrey/ip_autogen/pinmux/doc/theory_of_operation.md#strap-sampling-and-tap-isolation)'''
            '''[Non-debug Module Reset](hw/top_earlgrey/ip_autogen/pinmux/doc/theory_of_operation.md#non-debug-module-reset)'''
            '''[Inter-Module Signals](hw/top_earlgrey/ip_autogen/pinmux/doc/interfaces.md#inter-module-signals)'''
            '''[top_earlgrey.hjson `inter_module.connect pinmux.rv_jtag`](hw/top_earlgrey/data/top_earlgrey.hjson)'''
            '''[top_earlgrey.hjson `targets.asic.pinmux.special_signals`](hw/top_earlgrey/data/top_earlgrey.hjson)'''
            '''[top_earlgrey_pinmux.ipconfig.hjson `enable_strap_sampling`](hw/top_earlgrey/ip_autogen/pinmux/data/top_earlgrey_pinmux.ipconfig.hjson)'''
          ]
          kind: "spec"
          testpoint: "jtag"
          checks: ["connected TAP gets the pads (assert_Jtag_ConnectedTapGetsThePads)"]
          why: '''With TAP straps 10 and `pinmux_hw_debug_en_o` On, the check compares `rv_jtag_o` with the JTAG pads in the same cycle. The check compares the `trst_n` field only outside scan mode.'''
          milestone: "V2S"
          priority: "1"
          security: true
          state: "open"
        }
        {
          name: REQ_TAP_02b
          desc: '''While the TAP straps are 10 and the latch is Off, `rv_jtag_o` shall not carry the inputs of the TCK pad, the TMS pad, the TDI pad and the TRST_N pad.'''
          source: [
            '''[Strap Sampling and TAP Isolation](hw/top_earlgrey/ip_autogen/pinmux/doc/theory_of_operation.md#strap-sampling-and-tap-isolation)'''
            '''[Non-debug Module Reset](hw/top_earlgrey/ip_autogen/pinmux/doc/theory_of_operation.md#non-debug-module-reset)'''
            '''[Inter-Module Signals](hw/top_earlgrey/ip_autogen/pinmux/doc/interfaces.md#inter-module-signals)'''
            '''[top_earlgrey.hjson `inter_module.connect pinmux.rv_jtag`](hw/top_earlgrey/data/top_earlgrey.hjson)'''
            '''[top_earlgrey.hjson `targets.asic.pinmux.special_signals`](hw/top_earlgrey/data/top_earlgrey.hjson)'''
            '''[top_earlgrey_pinmux.ipconfig.hjson `enable_strap_sampling`](hw/top_earlgrey/ip_autogen/pinmux/data/top_earlgrey_pinmux.ipconfig.hjson)'''
          ]
          kind: "spec"
          testpoint: "jtag"
          checks: ["cut TAP gets zero (assert_Jtag_CutTapGetsZero)"]
          why: '''With TAP straps 10 and `pinmux_hw_debug_en_o` Off, the check requires all four fields of `rv_jtag_o` to be 0.'''
          milestone: "V2S"
          priority: "1"
          security: true
          state: "open"
        }
        {
          name: REQ_TAP_03a
          desc: '''While the TAP straps are 11 and `lc_dft_en_i` is On, `dft_jtag_o` shall carry the inputs of the TCK pad, the TMS pad, the TDI pad and the TRST_N pad.'''
          source: [
            '''[Strap Sampling and TAP Isolation](hw/top_earlgrey/ip_autogen/pinmux/doc/theory_of_operation.md#strap-sampling-and-tap-isolation)'''
            '''[pinmux.hjson `countermeasures` TAP.MUX.LC_GATED](hw/top_earlgrey/ip_autogen/pinmux/data/pinmux.hjson)'''
            '''[top_earlgrey.hjson `inter_module.top`](hw/top_earlgrey/data/top_earlgrey.hjson)'''
            '''[top_earlgrey.hjson `targets.asic.pinmux.special_signals`](hw/top_earlgrey/data/top_earlgrey.hjson)'''
            '''[top_earlgrey_pinmux.ipconfig.hjson `enable_strap_sampling`](hw/top_earlgrey/ip_autogen/pinmux/data/top_earlgrey_pinmux.ipconfig.hjson)'''
          ]
          kind: "spec"
          testpoint: "jtag"
          checks: ["connected TAP gets the pads (assert_Jtag_ConnectedTapGetsThePads)"]
          why: '''With TAP straps 11 and `lc_dft_en_i` steadily On, the check compares `dft_jtag_o` with the JTAG pads in the same cycle. The check compares the `trst_n` field only outside scan mode.'''
          milestone: "V2S"
          priority: "1"
          security: true
          state: "open"
        }
        {
          name: REQ_TAP_03b
          desc: '''While the TAP straps are 11 and `lc_dft_en_i` is Off, `dft_jtag_o` shall not carry the inputs of the TCK pad, the TMS pad, the TDI pad and the TRST_N pad.'''
          source: [
            '''[Strap Sampling and TAP Isolation](hw/top_earlgrey/ip_autogen/pinmux/doc/theory_of_operation.md#strap-sampling-and-tap-isolation)'''
            '''[pinmux.hjson `countermeasures` TAP.MUX.LC_GATED](hw/top_earlgrey/ip_autogen/pinmux/data/pinmux.hjson)'''
            '''[top_earlgrey.hjson `inter_module.top`](hw/top_earlgrey/data/top_earlgrey.hjson)'''
            '''[top_earlgrey.hjson `targets.asic.pinmux.special_signals`](hw/top_earlgrey/data/top_earlgrey.hjson)'''
            '''[top_earlgrey_pinmux.ipconfig.hjson `enable_strap_sampling`](hw/top_earlgrey/ip_autogen/pinmux/data/top_earlgrey_pinmux.ipconfig.hjson)'''
          ]
          kind: "spec"
          testpoint: "jtag"
          checks: ["cut TAP gets zero (assert_Jtag_CutTapGetsZero)"]
          why: '''With TAP straps 11 and `lc_dft_en_i` On in neither of the two cycles before, the check requires `dft_jtag_o` to be all 0.'''
          milestone: "V2S"
          priority: "1"
          security: true
          state: "open"
        }
        {
          name: REQ_TAP_04
          desc: '''The life cycle TAP, the RISC-V TAP and the DFT TAP shall each receive an all-zero request while that TAP is not connected.'''
          source: [
            '''[Strap Sampling and TAP Isolation](hw/top_earlgrey/ip_autogen/pinmux/doc/theory_of_operation.md#strap-sampling-and-tap-isolation)'''
            '''[top_earlgrey.hjson `inter_module.connect`](hw/top_earlgrey/data/top_earlgrey.hjson)'''
            '''[top_earlgrey.hjson `inter_module.top`](hw/top_earlgrey/data/top_earlgrey.hjson)'''
            '''[top_earlgrey_pinmux.ipconfig.hjson `enable_strap_sampling`](hw/top_earlgrey/ip_autogen/pinmux/data/top_earlgrey_pinmux.ipconfig.hjson)'''
          ]
          kind: "spec"
          testpoint: "jtag"
          checks: ["cut TAP gets zero (assert_Jtag_CutTapGetsZero)"]
          why: '''The check applies to the life cycle, RISC-V and DFT TAPs in every cycle and at every scan mode value. In a cycle in which one of these TAPs is cut, the check requires all four fields of its request to be 0.'''
          milestone: "V2S"
          priority: "1"
          security: true
          state: "open"
        }
        {
          name: REQ_TAP_05
          desc: '''In strap sampling, in the latch and in TAP selection, `lc_dft_en_i` and `lc_hw_debug_en_i` shall count as On only at the value 4'b0101.'''
          source: [
            '''[Control Signal Propagation](hw/ip/lc_ctrl/doc/interfaces.md#control-signal-propagation)'''
            '''[pinmux.hjson `countermeasures` LC_DFT_EN.INTERSIG.MUBI](hw/top_earlgrey/ip_autogen/pinmux/data/pinmux.hjson)'''
            '''[top_earlgrey_pinmux.ipconfig.hjson `enable_strap_sampling`](hw/top_earlgrey/ip_autogen/pinmux/data/top_earlgrey_pinmux.ipconfig.hjson)'''
          ]
          kind: "spec"
          testpoint: "jtag"
          checks: ["only On opens", "cut TAP gets zero (assert_Jtag_CutTapGetsZero)", "pulse samples the straps (assert_Strap_PulseSamplesTheStraps)", "straps hold (assert_Strap_StrapsHold)", "pulse samples debug enable (assert_Latch_PulseSamplesDebugEnable)"]
          why: '''Each of these checks counts an enable as On only at the value 4'b0101.'''
          milestone: "V2S"
          priority: "1"
          security: true
          state: "open"
        }
        {
          name: REQ_TAP_06a
          desc: '''While a TAP is connected, the TDO pad shall drive the TDO of that TAP.'''
          source: [
            '''[top_earlgrey.hjson `targets.asic.pinmux.special_signals tdo`](hw/top_earlgrey/data/top_earlgrey.hjson)'''
            '''[JTAG](hw/ip/rv_dm/doc/interfaces.md#jtag)'''
            '''[Security Countermeasures](hw/ip/lc_ctrl/doc/interfaces.md#security-countermeasures)'''
            '''[top_earlgrey_pinmux.ipconfig.hjson `enable_strap_sampling`](hw/top_earlgrey/ip_autogen/pinmux/data/top_earlgrey_pinmux.ipconfig.hjson)'''
          ]
          kind: "spec"
          testpoint: "jtag_pad"
          checks: ["TDO pad drives the TAP (assert_JtagPad_TdoPadDrivesTheTap)"]
          why: '''While the TDO pad is awake, the check compares the pad's bit of `mio_out_o` with the `tdo` of the connected TAP in the same cycle. The RRAM TAP is included.'''
          milestone: "V2S"
          priority: "2"
          security: true
          state: "open"
        }
        {
          name: REQ_TAP_06b
          desc: '''While a TAP is connected, the TDO pad shall take its output enable from that TAP.'''
          source: [
            '''[top_earlgrey.hjson `targets.asic.pinmux.special_signals tdo`](hw/top_earlgrey/data/top_earlgrey.hjson)'''
            '''[JTAG](hw/ip/rv_dm/doc/interfaces.md#jtag)'''
            '''[Security Countermeasures](hw/ip/lc_ctrl/doc/interfaces.md#security-countermeasures)'''
            '''[top_earlgrey_pinmux.ipconfig.hjson `enable_strap_sampling`](hw/top_earlgrey/ip_autogen/pinmux/data/top_earlgrey_pinmux.ipconfig.hjson)'''
          ]
          kind: "spec"
          testpoint: "jtag_pad"
          checks: ["TDO pad drives the TAP (assert_JtagPad_TdoPadDrivesTheTap)"]
          why: '''While the TDO pad is awake, the check compares the pad's bit of `mio_oe_o` with the `tdo_oe` of the connected TAP in the same cycle.'''
          milestone: "V2S"
          priority: "2"
          security: true
          state: "open"
        }
        {
          name: REQ_TAP_07
          desc: '''While a TAP is connected, the TCK pad, the TMS pad, the TDI pad and the TRST_N pad shall have output enable 0.'''
          source: [
            '''The TAPs' standard JTAG port takes TCK, TMS, TRST_N and TDI as pad inputs and drives only TDO and its enable ([JTAG](hw/ip/rv_dm/doc/interfaces.md#jtag); [Security Countermeasures](hw/ip/lc_ctrl/doc/interfaces.md#security-countermeasures)); the RRAM TAP's port has the same JTAG type ([Inter-Module Signals](hw/top_earlgrey/ip_autogen/pinmux/doc/interfaces.md#inter-module-signals)) and takes the JTAG IOs ([Strap Sampling and TAP Isolation](hw/top_earlgrey/ip_autogen/pinmux/doc/theory_of_operation.md#strap-sampling-and-tap-isolation))'''
            '''[top_earlgrey.hjson `targets.asic.pinmux.special_signals`](hw/top_earlgrey/data/top_earlgrey.hjson)'''
            '''[top_earlgrey_pinmux.ipconfig.hjson `enable_strap_sampling`](hw/top_earlgrey/ip_autogen/pinmux/data/top_earlgrey_pinmux.ipconfig.hjson)'''
          ]
          kind: "spec"
          testpoint: "jtag_pad"
          checks: ["input pads not driven (assert_JtagPad_InputPadsNotDriven)"]
          why: '''While a TAP is connected and the pads are awake, the check requires `mio_oe_o` to be 0 for the TMS, TDI, TCK and TRST_N pads. The check allows the output selects of these pads to hold any value.'''
          milestone: "V2S"
          priority: "2"
          security: true
          state: "open"
        }
        {
          name: REQ_TAP_08
          desc: '''While a TAP is connected, every attribute of the five JTAG pads shall be 0.'''
          source: [
            '''[Strap Sampling and TAP Isolation](hw/top_earlgrey/ip_autogen/pinmux/doc/theory_of_operation.md#strap-sampling-and-tap-isolation)'''
            '''[top_earlgrey.hjson `targets.asic.pinmux.special_signals`](hw/top_earlgrey/data/top_earlgrey.hjson)'''
            '''[top_earlgrey_pinmux.ipconfig.hjson `enable_strap_sampling`](hw/top_earlgrey/ip_autogen/pinmux/data/top_earlgrey_pinmux.ipconfig.hjson)'''
          ]
          kind: "spec"
          testpoint: "jtag_pad"
          checks: ["JTAG attributes zero (assert_JtagPad_JtagAttributesZero)"]
          why: '''While a TAP is connected and the pads are awake, the check requires every field of `mio_attr_o` to be 0 on the five JTAG pads. The check allows the attribute registers of these pads to hold any value.'''
          milestone: "V2S"
          priority: "2"
          security: true
          state: "open"
        }
        {
          name: REQ_TAP_09
          desc: '''Connecting a TAP shall not change the JTAG pads' attribute registers.'''
          source: [
            '''[Strap Sampling and TAP Isolation](hw/top_earlgrey/ip_autogen/pinmux/doc/theory_of_operation.md#strap-sampling-and-tap-isolation)'''
            '''[top_earlgrey.hjson `targets.asic.pinmux.special_signals`](hw/top_earlgrey/data/top_earlgrey.hjson)'''
            '''[top_earlgrey_pinmux.ipconfig.hjson `enable_strap_sampling`](hw/top_earlgrey/ip_autogen/pinmux/data/top_earlgrey_pinmux.ipconfig.hjson)'''
          ]
          kind: "spec"
          testpoint: "jtag_pad"
          checks: ["attribute registers untouched (assert_JtagPad_AttributeRegistersUntouched)"]
          why: '''In every cycle, the check allows the attribute read-back of each JTAG pad to change only by a software write.'''
          milestone: "V2S"
          priority: "2"
          security: true
          state: "open"
        }
        {
          name: REQ_TAP_12
          desc: '''An NDM reset with no clear shall leave a connected RISC-V TAP connected.'''
          source: [
            '''[Life Cycle Control](hw/ip/rv_dm/doc/interfaces.md#life-cycle-control)'''
            '''[Non-debug Module Reset](hw/top_earlgrey/ip_autogen/pinmux/doc/theory_of_operation.md#non-debug-module-reset)'''
            '''[lc_ctrl.hjson `inter_signal_list` lc_hw_debug_en](hw/ip/lc_ctrl/data/lc_ctrl.hjson)'''
            '''[top_earlgrey.hjson `resets.nodes lc_io_div4`](hw/top_earlgrey/data/top_earlgrey.hjson)'''
            '''[top_earlgrey.hjson `resets.nodes sys_io_div4`](hw/top_earlgrey/data/top_earlgrey.hjson)'''
            '''[top_earlgrey.hjson `module.pinmux`](hw/top_earlgrey/data/top_earlgrey.hjson)'''
            '''[top_earlgrey.hjson `inter_module.connect pinmux.rv_jtag`](hw/top_earlgrey/data/top_earlgrey.hjson)'''
            '''[top_earlgrey_pinmux.ipconfig.hjson `enable_strap_sampling`](hw/top_earlgrey/ip_autogen/pinmux/data/top_earlgrey_pinmux.ipconfig.hjson)'''
            '''[System Reset Tree](hw/top_earlgrey/ip_autogen/rstmgr/doc/theory_of_operation.md#system-reset-tree)'''
            '''[Summary](hw/top_earlgrey/ip_autogen/rstmgr/doc/theory_of_operation.md#summary)'''
          ]
          kind: "spec"
          testpoint: "jtag"
          checks: ["TAP selection outside NDM reset (check_Jtag_TapSelectionOutsideNdmReset)", "connected TAP gets the pads (assert_Jtag_ConnectedTapGetsThePads)", "cut TAP gets zero (assert_Jtag_CutTapGetsZero)"]
          why: '''The structure check requires that an NDM reset reaches no flop of the TAP selection. The `jtag` checks require that the state of these flops alone picks the connected TAP.'''
          milestone: "V2S"
          priority: "1"
          security: true
          state: "open"
        }
      ]
    }
    {
      name: '''RRAM TAP'''
      conditions: [
        '''These rows apply to a top that has the RRAM TAP ([top_earlgrey_pinmux.ipconfig.hjson](hw/top_earlgrey/ip_autogen/pinmux/data/top_earlgrey_pinmux.ipconfig.hjson) `enable_rram_tap`). On a top without the RRAM TAP, TAP straps at 00 select no TAP ([Strap Sampling and TAP Isolation](hw/top_earlgrey/ip_autogen/pinmux/doc/theory_of_operation.md#strap-sampling-and-tap-isolation)).'''
        '''The JTAG pad rows of TAP selection and the JTAG pads also hold for the RRAM TAP while it is connected. No row covers the TRST_N of the RRAM TAP while scan mode is on (Out of scope).'''
        '''The rows hold once the TAP straps and `lc_nvm_debug_en_i` have kept their values for the delay of the input synchronizers.'''
        '''In `REQ_RRAM_01`, TCK and TRST_N follow the TCK pad and the TRST_N pad from the second `clk_i` cycle in which the RRAM TAP is connected.'''
      ]
      requirements: [
        {
          name: REQ_RRAM_01
          desc: '''While the TAP straps are 00, `rram_jtag_o` shall carry the inputs of the TCK pad, the TMS pad, the TDI pad and the TRST_N pad, if `RRAM_JTAG_SEL` is `kMultiBitBool4True` and `lc_nvm_debug_en_i` is On.'''
          source: [
            '''[Strap Sampling and TAP Isolation](hw/top_earlgrey/ip_autogen/pinmux/doc/theory_of_operation.md#strap-sampling-and-tap-isolation)'''
            '''[Inter-Module Signals](hw/top_earlgrey/ip_autogen/pinmux/doc/interfaces.md#inter-module-signals)'''
            '''[pinmux.hjson `countermeasures` TAP.MUX.LC_GATED](hw/top_earlgrey/ip_autogen/pinmux/data/pinmux.hjson)'''
            '''!!RRAM_JTAG_SEL'''
            '''[top_earlgrey.hjson `inter_module.connect pinmux.rram_jtag`](hw/top_earlgrey/data/top_earlgrey.hjson)'''
            '''[top_earlgrey.hjson `targets.asic.pinmux.special_signals`](hw/top_earlgrey/data/top_earlgrey.hjson)'''
            '''[top_earlgrey_pinmux.ipconfig.hjson `enable_rram_tap`](hw/top_earlgrey/ip_autogen/pinmux/data/top_earlgrey_pinmux.ipconfig.hjson)'''
            '''No specification states the values of TCK and TRST_N in the first `clk_i` cycle of a connection.'''
          ]
          kind: "spec"
          testpoint: "rram_tap"
          checks: ["connected RRAM TAP gets the pads (assert_RramTap_ConnectedRramTapGetsThePads)"]
          why: '''While the RRAM TAP is connected, the check compares `rram_jtag_o` with the TCK, TMS, TDI and TRST_N pads in the same cycle. The check compares `tck` and `trst_n` only from the second cycle of the connection.'''
          milestone: "V2S"
          priority: "2"
          security: true
          state: "open"
        }
        {
          name: REQ_RRAM_02
          desc: '''While the RRAM TAP is not connected, the TMS and TDI of `rram_jtag_o` shall be 0.'''
          source: [
            '''[Strap Sampling and TAP Isolation](hw/top_earlgrey/ip_autogen/pinmux/doc/theory_of_operation.md#strap-sampling-and-tap-isolation)'''
            '''!!RRAM_JTAG_SEL'''
            '''[Inter-Module Signals](hw/top_earlgrey/ip_autogen/pinmux/doc/interfaces.md#inter-module-signals)'''
            '''[top_earlgrey_pinmux.ipconfig.hjson `enable_rram_tap`](hw/top_earlgrey/ip_autogen/pinmux/data/top_earlgrey_pinmux.ipconfig.hjson)'''
          ]
          kind: "spec"
          testpoint: "rram_tap"
          checks: ["cut RRAM TAP gets TMS and TDI 0 (assert_RramTap_CutRramTapGetsTmsAndTdi0)"]
          why: '''From the release of `rst_ni` on, the check requires `tms` and `tdi` of `rram_jtag_o` to be 0 in every cycle in which the RRAM TAP is cut. The check allows the pads to carry any value.'''
          milestone: "V2S"
          priority: "2"
          security: true
          state: "open"
        }
        {
          name: REQ_RRAM_03
          desc: '''The TCK and TRST_N of `rram_jtag_o` shall be 0 during reset and in the `clk_i` cycle after reset. They shall also be 0 in the `clk_i` cycle after any cycle in which the RRAM TAP is not connected.'''
          source: [
            '''[Strap Sampling and TAP Isolation](hw/top_earlgrey/ip_autogen/pinmux/doc/theory_of_operation.md#strap-sampling-and-tap-isolation)'''
            '''[pinmux.hjson `clocking`](hw/top_earlgrey/ip_autogen/pinmux/data/pinmux.hjson)'''
            '''[top_earlgrey_pinmux.ipconfig.hjson `enable_rram_tap`](hw/top_earlgrey/ip_autogen/pinmux/data/top_earlgrey_pinmux.ipconfig.hjson)'''
          ]
          kind: "RTL"
          testpoint: "rram_tap"
          checks: ["TCK and TRST low after a cut (assert_RramTap_TckAndTrstLowAfterACut)"]
          why: '''The check requires `tck` and `trst_n` of `rram_jtag_o` to be 0 in reset and in the first cycle after reset. The check requires the same in every cycle that follows a cycle in which the RRAM TAP is cut.'''
          milestone: "V2S"
          priority: "2"
          security: true
          state: "open"
        }
        {
          name: REQ_RRAM_09
          desc: '''In the first `clk_i` cycle in which the RRAM TAP is no longer connected, the TCK and TRST_N of `rram_jtag_o` shall still carry the inputs of the TCK pad and the TRST_N pad. This holds outside reset.'''
          source: [
            '''[Strap Sampling and TAP Isolation](hw/top_earlgrey/ip_autogen/pinmux/doc/theory_of_operation.md#strap-sampling-and-tap-isolation)'''
            '''[pinmux.hjson `clocking`](hw/top_earlgrey/ip_autogen/pinmux/data/pinmux.hjson)'''
            '''[top_earlgrey_pinmux.ipconfig.hjson `enable_rram_tap`](hw/top_earlgrey/ip_autogen/pinmux/data/top_earlgrey_pinmux.ipconfig.hjson)'''
            '''No specification states the clock that counts the cycle, and the value of TRST_N.'''
          ]
          kind: "spec"
          testpoint: "rram_tap"
          checks: ["TCK and TRST run one cycle more (assert_RramTap_TckAndTrstRunOneCycleMore)"]
          why: '''The check applies to each cycle outside reset in which the RRAM TAP is cut and was connected in the cycle before. In such a cycle, the check compares `tck` with the TCK pad and `trst_n` with the TRST_N pad.'''
          milestone: "V2S"
          priority: "2"
          security: true
          state: "open"
        }
        {
          name: REQ_RRAM_04
          desc: '''In the selection of the RRAM TAP, `lc_nvm_debug_en_i` shall count as On only at the value 4'b0101.'''
          source: [
            '''[Control Signal Propagation](hw/ip/lc_ctrl/doc/interfaces.md#control-signal-propagation)'''
            '''[pinmux.hjson `countermeasures` LC_NVM_DEBUG_EN.INTERSIG.MUBI](hw/top_earlgrey/ip_autogen/pinmux/data/pinmux.hjson)'''
            '''[top_earlgrey_pinmux.ipconfig.hjson `enable_rram_tap`](hw/top_earlgrey/ip_autogen/pinmux/data/top_earlgrey_pinmux.ipconfig.hjson)'''
          ]
          kind: "spec"
          testpoint: "rram_tap"
          checks: ["only True and On open", "cut RRAM TAP gets TMS and TDI 0 (assert_RramTap_CutRramTapGetsTmsAndTdi0)"]
          why: '''With `lc_nvm_debug_en_i` free, any held value other than 4'b0101 cuts the RRAM TAP. The check _cut RRAM TAP gets TMS and TDI 0_ then requires `tms` and `tdi` of `rram_jtag_o` to be 0.'''
          milestone: "V2S"
          priority: "2"
          security: true
          state: "open"
        }
        {
          name: REQ_RRAM_05
          desc: '''After a reset, the RRAM TAP shall not be connected until software writes `kMultiBitBool4True` to `RRAM_JTAG_SEL`.'''
          source: [
            '''[Strap Sampling and TAP Isolation](hw/top_earlgrey/ip_autogen/pinmux/doc/theory_of_operation.md#strap-sampling-and-tap-isolation)'''
            '''!!RRAM_JTAG_SEL'''
            '''[top_earlgrey_pinmux.ipconfig.hjson `enable_rram_tap`](hw/top_earlgrey/ip_autogen/pinmux/data/top_earlgrey_pinmux.ipconfig.hjson)'''
          ]
          kind: "spec"
          testpoint: "rram_tap"
          checks: ["cut until the register is written (assert_RramTap_CutUntilTheRegisterIsWritten)"]
          why: '''Until the first accepted write to `RRAM_JTAG_SEL`, the check requires `tms` and `tdi` of `rram_jtag_o` to be 0. The check allows the straps and `lc_nvm_debug_en_i` to take any value.'''
          milestone: "V2S"
          priority: "2"
          security: true
          state: "open"
        }
        {
          name: REQ_RRAM_06
          desc: '''`RRAM_JTAG_SEL` and `lc_nvm_debug_en_i` shall not change which of the life cycle TAP, the RISC-V TAP and the DFT TAP is connected. They shall not change what that TAP receives either.'''
          source: [
            '''[Strap Sampling and TAP Isolation](hw/top_earlgrey/ip_autogen/pinmux/doc/theory_of_operation.md#strap-sampling-and-tap-isolation)'''
            '''!!RRAM_JTAG_SEL'''
            '''[top_earlgrey_pinmux.ipconfig.hjson `enable_rram_tap`](hw/top_earlgrey/ip_autogen/pinmux/data/top_earlgrey_pinmux.ipconfig.hjson)'''
          ]
          kind: "spec"
          testpoint: "rram_tap"
          checks: ["connected TAP gets the pads (assert_Jtag_ConnectedTapGetsThePads)", "cut TAP gets zero (assert_Jtag_CutTapGetsZero)"]
          why: '''Both checks cover the requests of the life cycle, RISC-V and DFT TAPs while `RRAM_JTAG_SEL` and `lc_nvm_debug_en_i` are free.'''
          milestone: "V2S"
          priority: "2"
          security: true
          state: "open"
        }
        {
          name: REQ_RRAM_07
          desc: '''`lc_check_byp_en_i` and the latch shall not change whether the RRAM TAP is connected.'''
          source: [
            '''[Strap Sampling and TAP Isolation](hw/top_earlgrey/ip_autogen/pinmux/doc/theory_of_operation.md#strap-sampling-and-tap-isolation)'''
            '''[Non-debug Module Reset](hw/top_earlgrey/ip_autogen/pinmux/doc/theory_of_operation.md#non-debug-module-reset)'''
            '''[top_earlgrey_pinmux.ipconfig.hjson `enable_rram_tap`](hw/top_earlgrey/ip_autogen/pinmux/data/top_earlgrey_pinmux.ipconfig.hjson)'''
          ]
          kind: "spec"
          testpoint: "rram_tap"
          checks: ["RRAM TAP kept through a transition (assert_RramTap_RramTapKeptThroughATransition)", "cut RRAM TAP gets TMS and TDI 0 (assert_RramTap_CutRramTapGetsTmsAndTdi0)"]
          why: '''The check _RRAM TAP kept through a transition_ requires a connected RRAM TAP to stay connected during a life cycle transition or while the latch is Off.'''
          milestone: "V2S"
          priority: "2"
          security: true
          state: "open"
        }
      ]
    }
    {
      name: '''DFT straps'''
      conditions: [
        '''The output `dft_strap_test_o` holds a valid bit and the straps.'''
        '''The straps take bit 0 from the DFT strap 0 pad and bit 1 from the DFT strap 1 pad ([existing pinmux FPV testplan: DftStrapTestO_A](hw/top_earlgrey/ip_autogen/pinmux/data/pinmux_fpv_testplan.hjson)), two pads that the top description assigns and that the table Pads by role lists.'''
        '''Two documents disagree on the number of DFT strap pads. The top description gives two, and the theory of operation gives three ([Strap Sampling and TAP Isolation](hw/top_earlgrey/ip_autogen/pinmux/doc/theory_of_operation.md#strap-sampling-and-tap-isolation)). The rows follow the top description, because it sets the pads that the pinmux is built with.'''
      ]
      requirements: [
        {
          name: REQ_DFT_01a
          desc: '''At a `strap_en_i` pulse, the valid bit of `dft_strap_test_o` shall take the value 1, if `lc_dft_en_i` is On.'''
          source: [
            '''[Strap Sampling and TAP Isolation](hw/top_earlgrey/ip_autogen/pinmux/doc/theory_of_operation.md#strap-sampling-and-tap-isolation)'''
            '''[Inter-Module Signals](hw/top_earlgrey/ip_autogen/pinmux/doc/interfaces.md#inter-module-signals)'''
            '''[top_earlgrey.hjson `targets.asic.pinmux.special_signals`](hw/top_earlgrey/data/top_earlgrey.hjson)'''
            '''[top_earlgrey_pinmux.ipconfig.hjson `enable_strap_sampling`](hw/top_earlgrey/ip_autogen/pinmux/data/top_earlgrey_pinmux.ipconfig.hjson)'''
            '''[Manufacturing States](doc/security/specs/device_life_cycle/README.md#manufacturing-states)'''
          ]
          kind: "spec"
          testpoint: "dft_strap"
          checks: ["pulse samples DFT straps (assert_DftStrap_PulseSamplesDftStraps)"]
          why: '''At a strap pulse with `lc_dft_en_i` On in each of the two cycles before, the check requires the valid bit to be 1 from the next cycle on.'''
          milestone: "V2S"
          priority: "2"
          security: true
          state: "open"
        }
        {
          name: REQ_DFT_01b
          desc: '''At a `strap_en_i` pulse, the straps of `dft_strap_test_o` shall take the values of the DFT strap 0 pad and the DFT strap 1 pad, if `lc_dft_en_i` is On.'''
          source: [
            '''[Strap Sampling and TAP Isolation](hw/top_earlgrey/ip_autogen/pinmux/doc/theory_of_operation.md#strap-sampling-and-tap-isolation)'''
            '''[Inter-Module Signals](hw/top_earlgrey/ip_autogen/pinmux/doc/interfaces.md#inter-module-signals)'''
            '''[top_earlgrey.hjson `targets.asic.pinmux.special_signals`](hw/top_earlgrey/data/top_earlgrey.hjson)'''
            '''[top_earlgrey_pinmux.ipconfig.hjson `enable_strap_sampling`](hw/top_earlgrey/ip_autogen/pinmux/data/top_earlgrey_pinmux.ipconfig.hjson)'''
            '''[Manufacturing States](doc/security/specs/device_life_cycle/README.md#manufacturing-states)'''
          ]
          kind: "spec"
          testpoint: "dft_strap"
          checks: ["pulse samples DFT straps (assert_DftStrap_PulseSamplesDftStraps)"]
          why: '''At a strap pulse with `lc_dft_en_i` steadily On, the check compares the two straps after the pulse with the DFT strap 0 pad and the DFT strap 1 pad. The check accepts the value of each pad in the pulse cycle or in the cycle after it.'''
          milestone: "V2S"
          priority: "2"
          security: true
          state: "open"
        }
        {
          name: REQ_DFT_02a
          desc: '''Once the valid bit of `dft_strap_test_o` is 1, the valid bit shall stay 1 until a full reset.'''
          source: [
            '''[Strap Sampling and TAP Isolation](hw/top_earlgrey/ip_autogen/pinmux/doc/theory_of_operation.md#strap-sampling-and-tap-isolation)'''
            '''[Non-debug Module Reset](hw/top_earlgrey/ip_autogen/pinmux/doc/theory_of_operation.md#non-debug-module-reset)'''
            '''[top_earlgrey.hjson `resets.nodes lc_io_div4`](hw/top_earlgrey/data/top_earlgrey.hjson)'''
            '''[top_earlgrey.hjson `resets.nodes sys_io_div4`](hw/top_earlgrey/data/top_earlgrey.hjson)'''
            '''[top_earlgrey.hjson `module.pinmux`](hw/top_earlgrey/data/top_earlgrey.hjson)'''
            '''[top_earlgrey_pinmux.ipconfig.hjson `enable_strap_sampling`](hw/top_earlgrey/ip_autogen/pinmux/data/top_earlgrey_pinmux.ipconfig.hjson)'''
          ]
          kind: "spec"
          testpoint: "dft_strap"
          checks: ["DFT straps held (assert_DftStrap_DftStrapsHeld)"]
          why: '''Once the valid bit is 1, the check requires the output to keep its value into each next cycle that is not in full reset. The check allows `lc_dft_en_i` and the pads to take any value.'''
          milestone: "V2S"
          priority: "2"
          security: true
          state: "open"
        }
        {
          name: REQ_DFT_02b
          desc: '''Once the valid bit of `dft_strap_test_o` is 1, the straps of `dft_strap_test_o` shall keep their values until a full reset.'''
          source: [
            '''[Strap Sampling and TAP Isolation](hw/top_earlgrey/ip_autogen/pinmux/doc/theory_of_operation.md#strap-sampling-and-tap-isolation)'''
            '''[Non-debug Module Reset](hw/top_earlgrey/ip_autogen/pinmux/doc/theory_of_operation.md#non-debug-module-reset)'''
            '''[top_earlgrey.hjson `resets.nodes lc_io_div4`](hw/top_earlgrey/data/top_earlgrey.hjson)'''
            '''[top_earlgrey.hjson `resets.nodes sys_io_div4`](hw/top_earlgrey/data/top_earlgrey.hjson)'''
            '''[top_earlgrey.hjson `module.pinmux`](hw/top_earlgrey/data/top_earlgrey.hjson)'''
            '''[top_earlgrey_pinmux.ipconfig.hjson `enable_strap_sampling`](hw/top_earlgrey/ip_autogen/pinmux/data/top_earlgrey_pinmux.ipconfig.hjson)'''
          ]
          kind: "spec"
          testpoint: "dft_strap"
          checks: ["DFT straps held (assert_DftStrap_DftStrapsHeld)"]
          why: '''Once the valid bit is 1, the check requires the two straps to keep their values into each next cycle that is not in full reset.'''
          milestone: "V2S"
          priority: "2"
          security: true
          state: "open"
        }
        {
          name: REQ_DFT_03
          desc: '''`dft_strap_test_o` shall be all 0 before a sample, which takes place at a `strap_en_i` pulse while `lc_dft_en_i` is On. This holds for any value on the DFT strap 0 pad and the DFT strap 1 pad.'''
          source: [
            '''[chip_testplan.hjson `chip_sw_tap_strap_sampling`](hw/top_earlgrey/data/chip_testplan.hjson)'''
            '''[top_earlgrey.hjson `targets.asic.pinmux.special_signals`](hw/top_earlgrey/data/top_earlgrey.hjson)'''
            '''[top_earlgrey_pinmux.ipconfig.hjson `enable_strap_sampling`](hw/top_earlgrey/ip_autogen/pinmux/data/top_earlgrey_pinmux.ipconfig.hjson)'''
            '''No specification states the value before the first sample.'''
          ]
          kind: "spec"
          testpoint: "dft_strap"
          checks: ["zero until sampled (assert_DftStrap_ZeroUntilSampled)"]
          why: '''The check requires every bit of `dft_strap_test_o` to be 0 until a strap pulse at which `lc_dft_en_i` was On in either of the two cycles before.'''
          milestone: "V2S"
          priority: "2"
          security: true
          state: "open"
        }
      ]
    }
  ]
}
