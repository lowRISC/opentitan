// Copyright lowRISC contributors (OpenTitan project).
// Licensed under the Apache License, Version 2.0, see LICENSE for details.
// SPDX-License-Identifier: Apache-2.0
//
// ------------------- W A R N I N G: A U T O - G E N E R A T E D   C O D E !! -------------------//
// PLEASE DO NOT HAND-EDIT THIS FILE. IT HAS BEEN AUTO-GENERATED WITH THE FOLLOWING COMMAND:
//
// util/topgen.py -t hw/top_earlgrey/data/top_earlgrey.hjson \
//                -o hw/top_earlgrey/ \
//                --rnd_cnst_seed 1017106219537032642877583828875051302543807092889754935647094601236425074047
{
  name: earlgrey
  type: top
  rnd_cnst_seed: 1017106219537032642877583828875051302543807092889754935647094601236425074047
  datawidth: "32"
  power:
  {
    domains:
    [
      Aon
      "0"
    ]
    default: "0"
    wait_for_external_reset: false
  }
  unmanaged_clocks: {}
  clocks:
  {
    hier_paths:
    {
      top: clkmgr_aon_clocks.
      ext: ""
      lpg: clkmgr_aon_cg_en.
    }
    srcs:
    [
      {
        name: main
        aon: no
        freq: "100000000"
        ref: false
      }
      {
        name: io
        aon: no
        freq: "96000000"
        ref: false
      }
      {
        name: usb
        aon: no
        freq: "48000000"
        ref: false
      }
      {
        name: aon
        aon: yes
        freq: "200000"
        ref: true
      }
    ]
    derived_srcs:
    [
      {
        name: io_div2
        aon: no
        freq: "48000000"
        ref: false
        div: "2"
        src: io
      }
      {
        name: io_div4
        aon: no
        freq: "24000000"
        ref: false
        div: "4"
        src: io
      }
    ]
    groups:
    [
      {
        name: ast
        src: ext
        sw_cg: no
        unique: no
        clocks:
        {
          clk_main_i: main
          clk_io_i: io
          clk_usb_i: usb
          clk_aon_i: aon
        }
      }
      {
        name: powerup
        src: top
        sw_cg: no
        unique: no
        clocks:
        {
          clk_io_div4_powerup: io_div4
          clk_aon_powerup: aon
          clk_main_powerup: main
          clk_io_powerup: io
          clk_usb_powerup: usb
          clk_io_div2_powerup: io_div2
        }
      }
      {
        name: trans
        src: top
        sw_cg: hint
        unique: yes
        clocks:
        {
          clk_main_aes: main
          clk_main_hmac: main
          clk_main_kmac: main
          clk_main_otbn: main
        }
      }
      {
        name: infra
        src: top
        sw_cg: no
        unique: no
        clocks:
        {
          clk_io_div4_infra: io_div4
          clk_main_infra: main
          clk_usb_infra: usb
          clk_io_infra: io
          clk_io_div2_infra: io_div2
        }
      }
      {
        name: secure
        src: top
        sw_cg: no
        unique: no
        clocks:
        {
          clk_io_div4_secure: io_div4
          clk_main_secure: main
          clk_aon_secure: aon
        }
      }
      {
        name: peri
        src: top
        sw_cg: yes
        unique: no
        clocks:
        {
          clk_io_div4_peri: io_div4
          clk_io_div2_peri: io_div2
          clk_io_peri: io
          clk_usb_peri: usb
          clk_aon_peri: aon
        }
      }
      {
        name: timers
        src: top
        sw_cg: no
        unique: no
        clocks:
        {
          clk_io_div4_timers: io_div4
          clk_aon_timers: aon
        }
      }
    ]
  }
  resets:
  {
    hier_paths:
    {
      top: rstmgr_aon_resets.
      ext: ""
      lpg: rstmgr_aon_rst_en.
    }
    nodes:
    [
      {
        name: por_aon
        gen: false
        type: top
        domains:
        [
          "0"
          Aon
        ]
        shadowed: false
        sw: false
        path: rstmgr_aon_resets.rst_por_aon_n
        clock: aon
      }
      {
        name: lc_src
        gen: false
        type: int
        domains: []
        shadowed: false
        sw: false
        path: ""
        clock: io_div4
      }
      {
        name: sys_src
        gen: false
        type: int
        domains: []
        shadowed: false
        sw: false
        path: ""
        clock: io_div4
      }
      {
        name: por
        gen: true
        type: top
        domains:
        [
          Aon
        ]
        shadowed: false
        sw: false
        path: rstmgr_aon_resets.rst_por_n
        parent: por_aon
        clock: main
      }
      {
        name: por_io
        gen: true
        type: top
        domains:
        [
          Aon
        ]
        shadowed: false
        sw: false
        path: rstmgr_aon_resets.rst_por_io_n
        parent: por_aon
        clock: io
      }
      {
        name: por_io_div2
        gen: true
        type: top
        domains:
        [
          Aon
        ]
        shadowed: false
        sw: false
        path: rstmgr_aon_resets.rst_por_io_div2_n
        parent: por_aon
        clock: io_div2
      }
      {
        name: por_io_div4
        gen: true
        type: top
        domains:
        [
          Aon
        ]
        shadowed: false
        sw: false
        path: rstmgr_aon_resets.rst_por_io_div4_n
        parent: por_aon
        clock: io_div4
      }
      {
        name: por_usb
        gen: true
        type: top
        domains:
        [
          Aon
        ]
        shadowed: false
        sw: false
        path: rstmgr_aon_resets.rst_por_usb_n
        parent: por_aon
        clock: usb
      }
      {
        name: lc
        gen: true
        type: top
        domains:
        [
          "0"
          Aon
        ]
        shadowed: true
        sw: false
        path: rstmgr_aon_resets.rst_lc_n
        parent: lc_src
        clock: main
      }
      {
        name: lc_aon
        gen: true
        type: top
        domains:
        [
          Aon
        ]
        shadowed: false
        sw: false
        path: rstmgr_aon_resets.rst_lc_aon_n
        parent: lc_src
        clock: aon
      }
      {
        name: lc_io
        gen: true
        type: top
        domains:
        [
          Aon
          "0"
        ]
        shadowed: false
        sw: false
        path: rstmgr_aon_resets.rst_lc_io_n
        parent: lc_src
        clock: io
      }
      {
        name: lc_io_div2
        gen: true
        type: top
        domains:
        [
          Aon
          "0"
        ]
        shadowed: false
        sw: false
        path: rstmgr_aon_resets.rst_lc_io_div2_n
        parent: lc_src
        clock: io_div2
      }
      {
        name: lc_io_div4
        gen: true
        type: top
        domains:
        [
          "0"
          Aon
        ]
        shadowed: true
        sw: false
        path: rstmgr_aon_resets.rst_lc_io_div4_n
        parent: lc_src
        clock: io_div4
      }
      {
        name: lc_usb
        gen: true
        type: top
        domains:
        [
          Aon
          "0"
        ]
        shadowed: false
        sw: false
        path: rstmgr_aon_resets.rst_lc_usb_n
        parent: lc_src
        clock: usb
      }
      {
        name: sys
        gen: true
        type: top
        domains:
        [
          "0"
        ]
        shadowed: false
        sw: false
        path: rstmgr_aon_resets.rst_sys_n
        parent: sys_src
        clock: main
      }
      {
        name: sys_io_div4
        gen: true
        type: top
        domains:
        [
          Aon
        ]
        shadowed: false
        sw: false
        path: rstmgr_aon_resets.rst_sys_io_div4_n
        parent: sys_src
        clock: io_div4
      }
      {
        name: spi_device
        gen: true
        type: top
        domains:
        [
          "0"
        ]
        shadowed: false
        sw: true
        path: rstmgr_aon_resets.rst_spi_device_n
        parent: lc_src
        clock: io_div4
      }
      {
        name: spi_host0
        gen: true
        type: top
        domains:
        [
          "0"
        ]
        shadowed: false
        sw: true
        path: rstmgr_aon_resets.rst_spi_host0_n
        parent: lc_src
        clock: io
      }
      {
        name: spi_host1
        gen: true
        type: top
        domains:
        [
          "0"
        ]
        shadowed: false
        sw: true
        path: rstmgr_aon_resets.rst_spi_host1_n
        parent: lc_src
        clock: io_div2
      }
      {
        name: usb
        gen: true
        type: top
        domains:
        [
          "0"
        ]
        shadowed: false
        sw: true
        path: rstmgr_aon_resets.rst_usb_n
        parent: lc_src
        clock: usb
      }
      {
        name: usb_aon
        gen: true
        type: top
        domains:
        [
          "0"
        ]
        shadowed: false
        sw: true
        path: rstmgr_aon_resets.rst_usb_aon_n
        parent: lc_src
        clock: aon
      }
      {
        name: i2c0
        gen: true
        type: top
        domains:
        [
          "0"
        ]
        shadowed: false
        sw: true
        path: rstmgr_aon_resets.rst_i2c0_n
        parent: lc_src
        clock: io_div4
      }
      {
        name: i2c1
        gen: true
        type: top
        domains:
        [
          "0"
        ]
        shadowed: false
        sw: true
        path: rstmgr_aon_resets.rst_i2c1_n
        parent: lc_src
        clock: io_div4
      }
      {
        name: i2c2
        gen: true
        type: top
        domains:
        [
          "0"
        ]
        shadowed: false
        sw: true
        path: rstmgr_aon_resets.rst_i2c2_n
        parent: lc_src
        clock: io_div4
      }
    ]
  }
  reset_requests:
  {
    int:
    [
      {
        name: MainPwr
        desc: main power glitch reset request
        module: pwrmgr_aon
      }
      {
        name: Esc
        desc: escalation reset request
        module: alert_handler
      }
    ]
    debug:
    [
      {
        name: Ndm
        desc: non-debug-module reset request
        module: rv_dm
      }
    ]
    peripheral:
    [
      {
        name: rst_req
        width: "1"
        module: sysrst_ctrl_aon
        desc: OpenTitan reset request to `rstmgr` (running on AON clock).
      }
      {
        name: aon_timer_rst_req
        width: "1"
        module: aon_timer_aon
        desc: Watchdog reset request.
      }
    ]
  }
  num_cores: "1"
  addr_spaces:
  [
    {
      name: hart
      desc: The main address space, shared between the CPU and DM
      subspaces:
      [
        {
          name: mmio
          desc:
            '''
            MMIO region excludes any memory that is separate from the module configuration
            space, i.e. ROM, main SRAM, and flash are excluded but retention SRAM, spi_device
            memory, or usbdev memory are included.
            '''
          nodes:
          [
            uart0
            uart1
            uart2
            uart3
            gpio
            spi_device
            i2c0
            i2c1
            i2c2
            pattgen
            rv_timer
            otp_ctrl
            lc_ctrl.regs
            alert_handler
            spi_host0
            spi_host1
            usbdev
            pwrmgr_aon
            rstmgr_aon
            clkmgr_aon
            sysrst_ctrl_aon
            adc_ctrl_aon
            pwm_aon
            pinmux_aon
            aon_timer_aon
            ast
            sensor_ctrl
            sram_ctrl_ret_aon
            flash_ctrl.core
            flash_ctrl.prim
            rv_plic
            aes
            hmac
            kmac
            otbn
            keymgr
            csrng
            entropy_src
            edn0
            edn1
            sram_ctrl_main.regs
            rom_ctrl.regs
            rv_core_ibex
          ]
        }
      ]
    }
  ]
  module:
  [
    {
      name: uart0
      type: uart
      clock_srcs:
      {
        clk_i: io_div4
      }
      clock_group: peri
      reset_connections:
      {
        rst_ni:
        {
          name: lc_io_div4
          domain: "0"
        }
      }
      clock_connections:
      {
        clk_i: clkmgr_aon_clocks.clk_io_div4_peri
      }
      param_decl: {}
      param_list: []
      inter_signal_list:
      [
        {
          name: lsio_trigger
          desc:
            '''
            Self-clearing status trigger for the DMA.
            Set when RX or TX FIFOs are past their configured watermarks matching watermark interrupt behaviour.
            '''
          struct: logic
          type: uni
          act: req
          width: 1
          inst_name: uart0
          index: -1
        }
        {
          name: racl_policies
          desc:
            '''
            Incoming RACL policy vector from a racl_ctrl instance.
            The policy selection vector (parameter) selects the policy for each register.
            '''
          struct: racl_policy_vec
          package: top_racl_pkg
          type: uni
          act: rcv
          width: 1
          inst_name: uart0
          index: -1
        }
        {
          name: racl_error
          desc: RACL error log information of this module.
          struct: racl_error_log
          package: top_racl_pkg
          type: uni
          act: req
          width: 1
          inst_name: uart0
          index: -1
        }
        {
          name: tl
          struct: tl
          package: tlul_pkg
          type: req_rsp
          act: rsp
          width: 1
          inst_name: uart0
          default: ""
          end_idx: -1
          top_signame: uart0_tl
          index: -1
        }
      ]
      base_addrs:
      {
        null:
        {
          hart: 0x40000000
        }
      }
      generate_dif: true
      domain:
      [
        "0"
      ]
    }
    {
      name: uart1
      type: uart
      clock_srcs:
      {
        clk_i: io_div4
      }
      clock_group: peri
      reset_connections:
      {
        rst_ni:
        {
          name: lc_io_div4
          domain: "0"
        }
      }
      clock_connections:
      {
        clk_i: clkmgr_aon_clocks.clk_io_div4_peri
      }
      param_decl: {}
      param_list: []
      inter_signal_list:
      [
        {
          name: lsio_trigger
          desc:
            '''
            Self-clearing status trigger for the DMA.
            Set when RX or TX FIFOs are past their configured watermarks matching watermark interrupt behaviour.
            '''
          struct: logic
          type: uni
          act: req
          width: 1
          inst_name: uart1
          index: -1
        }
        {
          name: racl_policies
          desc:
            '''
            Incoming RACL policy vector from a racl_ctrl instance.
            The policy selection vector (parameter) selects the policy for each register.
            '''
          struct: racl_policy_vec
          package: top_racl_pkg
          type: uni
          act: rcv
          width: 1
          inst_name: uart1
          index: -1
        }
        {
          name: racl_error
          desc: RACL error log information of this module.
          struct: racl_error_log
          package: top_racl_pkg
          type: uni
          act: req
          width: 1
          inst_name: uart1
          index: -1
        }
        {
          name: tl
          struct: tl
          package: tlul_pkg
          type: req_rsp
          act: rsp
          width: 1
          inst_name: uart1
          default: ""
          end_idx: -1
          top_signame: uart1_tl
          index: -1
        }
      ]
      base_addrs:
      {
        null:
        {
          hart: 0x40010000
        }
      }
      generate_dif: true
      domain:
      [
        "0"
      ]
    }
    {
      name: uart2
      type: uart
      clock_srcs:
      {
        clk_i: io_div4
      }
      clock_group: peri
      reset_connections:
      {
        rst_ni:
        {
          name: lc_io_div4
          domain: "0"
        }
      }
      clock_connections:
      {
        clk_i: clkmgr_aon_clocks.clk_io_div4_peri
      }
      param_decl: {}
      param_list: []
      inter_signal_list:
      [
        {
          name: lsio_trigger
          desc:
            '''
            Self-clearing status trigger for the DMA.
            Set when RX or TX FIFOs are past their configured watermarks matching watermark interrupt behaviour.
            '''
          struct: logic
          type: uni
          act: req
          width: 1
          inst_name: uart2
          index: -1
        }
        {
          name: racl_policies
          desc:
            '''
            Incoming RACL policy vector from a racl_ctrl instance.
            The policy selection vector (parameter) selects the policy for each register.
            '''
          struct: racl_policy_vec
          package: top_racl_pkg
          type: uni
          act: rcv
          width: 1
          inst_name: uart2
          index: -1
        }
        {
          name: racl_error
          desc: RACL error log information of this module.
          struct: racl_error_log
          package: top_racl_pkg
          type: uni
          act: req
          width: 1
          inst_name: uart2
          index: -1
        }
        {
          name: tl
          struct: tl
          package: tlul_pkg
          type: req_rsp
          act: rsp
          width: 1
          inst_name: uart2
          default: ""
          end_idx: -1
          top_signame: uart2_tl
          index: -1
        }
      ]
      base_addrs:
      {
        null:
        {
          hart: 0x40020000
        }
      }
      generate_dif: true
      domain:
      [
        "0"
      ]
    }
    {
      name: uart3
      type: uart
      clock_srcs:
      {
        clk_i: io_div4
      }
      clock_group: peri
      reset_connections:
      {
        rst_ni:
        {
          name: lc_io_div4
          domain: "0"
        }
      }
      clock_connections:
      {
        clk_i: clkmgr_aon_clocks.clk_io_div4_peri
      }
      param_decl: {}
      param_list: []
      inter_signal_list:
      [
        {
          name: lsio_trigger
          desc:
            '''
            Self-clearing status trigger for the DMA.
            Set when RX or TX FIFOs are past their configured watermarks matching watermark interrupt behaviour.
            '''
          struct: logic
          type: uni
          act: req
          width: 1
          inst_name: uart3
          index: -1
        }
        {
          name: racl_policies
          desc:
            '''
            Incoming RACL policy vector from a racl_ctrl instance.
            The policy selection vector (parameter) selects the policy for each register.
            '''
          struct: racl_policy_vec
          package: top_racl_pkg
          type: uni
          act: rcv
          width: 1
          inst_name: uart3
          index: -1
        }
        {
          name: racl_error
          desc: RACL error log information of this module.
          struct: racl_error_log
          package: top_racl_pkg
          type: uni
          act: req
          width: 1
          inst_name: uart3
          index: -1
        }
        {
          name: tl
          struct: tl
          package: tlul_pkg
          type: req_rsp
          act: rsp
          width: 1
          inst_name: uart3
          default: ""
          end_idx: -1
          top_signame: uart3_tl
          index: -1
        }
      ]
      base_addrs:
      {
        null:
        {
          hart: 0x40030000
        }
      }
      generate_dif: true
      domain:
      [
        "0"
      ]
    }
    {
      name: gpio
      type: gpio
      template_type: gpio
      clock_srcs:
      {
        clk_i: io_div4
      }
      clock_group: peri
      reset_connections:
      {
        rst_ni:
        {
          name: lc_io_div4
          domain: "0"
        }
      }
      param_decl:
      {
        GpioAsHwStrapsEn: "0"
        GpioAsyncOn: "1"
      }
      attr: ipgen
      clock_connections:
      {
        clk_i: clkmgr_aon_clocks.clk_io_div4_peri
      }
      memory: {}
      param_list:
      [
        {
          name: GpioAsyncOn
          desc: Instantiates 2-flop synchronizers on all GPIO inputs if set to 1.
          type: bit
          default: "1"
          local: "false"
          expose: "true"
          name_top: GpioGpioAsyncOn
        }
        {
          name: GpioAsHwStrapsEn
          desc: Enable HW straps sampling logic for GPIO inputs at initial cold boot
          type: bit
          default: "0"
          local: "false"
          expose: "true"
          name_top: GpioGpioAsHwStrapsEn
        }
      ]
      inter_signal_list:
      [
        {
          name: strap_en
          desc:
            '''
            The strap enable signal tells gpio to take a snapshot of the input pins.
            The behaviour of this signal after that event will have no effect.
            '''
          struct: logic
          type: uni
          act: rcv
          width: 1
          default: 1'b0
          inst_name: gpio
          index: -1
        }
        {
          name: sampled_straps
          desc: This vector contains the sampled strap values.
          struct: gpio_straps
          package: gpio_pkg
          type: uni
          act: req
          width: 1
          default: "'0"
          inst_name: gpio
          index: -1
        }
        {
          name: racl_policies
          desc:
            '''
            Incoming RACL policy vector from a racl_ctrl instance.
            The policy selection vector (parameter) selects the policy for each register.
            '''
          struct: racl_policy_vec
          package: top_racl_pkg
          type: uni
          act: rcv
          width: 1
          inst_name: gpio
          index: -1
        }
        {
          name: racl_error
          desc: RACL error log information of this module.
          struct: racl_error_log
          package: top_racl_pkg
          type: uni
          act: req
          width: 1
          inst_name: gpio
          index: -1
        }
        {
          name: tl
          struct: tl
          package: tlul_pkg
          type: req_rsp
          act: rsp
          width: 1
          inst_name: gpio
          default: ""
          end_idx: -1
          top_signame: gpio_tl
          index: -1
        }
      ]
      base_addrs:
      {
        null:
        {
          hart: 0x40040000
        }
      }
      generate_dif: true
      domain:
      [
        "0"
      ]
    }
    {
      name: spi_device
      type: spi_device
      clock_srcs:
      {
        clk_i: io_div4
        scan_clk_i: io_div2
      }
      clock_group: peri
      reset_connections:
      {
        rst_ni:
        {
          name: spi_device
          domain: "0"
        }
      }
      clock_connections:
      {
        clk_i: clkmgr_aon_clocks.clk_io_div4_peri
        scan_clk_i: clkmgr_aon_clocks.clk_io_div2_peri
      }
      param_decl: {}
      memory: {}
      param_list:
      [
        {
          name: SramType
          desc: Sram Entries. Word size is 32bit width.
          type: spi_device_pkg::sram_type_e
          default: spi_device_pkg::DefaultSramType
          local: "false"
          expose: "true"
          name_top: SpiDeviceSramType
        }
      ]
      inter_signal_list:
      [
        {
          name: ram_cfg_sys2spi
          struct: ram_2p_cfg
          package: prim_ram_2p_pkg
          type: uni
          act: rcv
          width: 1
          inst_name: spi_device
          default: ""
          top_signame: ast_spi_ram_2p_cfg
          index: -1
        }
        {
          name: ram_cfg_rsp_sys2spi
          struct: ram_2p_cfg_rsp
          package: prim_ram_2p_pkg
          type: uni
          act: req
          width: 1
          inst_name: spi_device
          index: -1
        }
        {
          name: ram_cfg_spi2sys
          struct: ram_2p_cfg
          package: prim_ram_2p_pkg
          type: uni
          act: rcv
          width: 1
          inst_name: spi_device
          default: ""
          top_signame: ast_spi_ram_2p_cfg
          index: -1
        }
        {
          name: ram_cfg_rsp_spi2sys
          struct: ram_2p_cfg_rsp
          package: prim_ram_2p_pkg
          type: uni
          act: req
          width: 1
          inst_name: spi_device
          index: -1
        }
        {
          name: passthrough
          struct: passthrough
          package: spi_device_pkg
          type: req_rsp
          act: req
          width: 1
          inst_name: spi_device
          default: ""
          end_idx: -1
          top_signame: spi_device_passthrough
          index: -1
        }
        {
          name: mbist_en
          struct: logic
          type: uni
          act: rcv
          width: 1
          inst_name: spi_device
          index: -1
        }
        {
          name: sck_monitor
          struct: logic
          type: uni
          act: req
          width: 1
          inst_name: spi_device
          default: ""
          package: ""
          external: true
          top_signame: sck_monitor
          conn_type: false
          index: -1
        }
        {
          name: racl_policies
          desc:
            '''
            Incoming RACL policy vector from a racl_ctrl instance.
            The policy selection vector (parameter) selects the policy for each register.
            '''
          struct: racl_policy_vec
          package: top_racl_pkg
          type: uni
          act: rcv
          width: 1
          inst_name: spi_device
          index: -1
        }
        {
          name: racl_error
          desc: RACL error log information of this module.
          struct: racl_error_log
          package: top_racl_pkg
          type: uni
          act: req
          width: 1
          inst_name: spi_device
          index: -1
        }
        {
          name: tl
          struct: tl
          package: tlul_pkg
          type: req_rsp
          act: rsp
          width: 1
          inst_name: spi_device
          default: ""
          end_idx: -1
          top_signame: spi_device_tl
          index: -1
        }
      ]
      base_addrs:
      {
        null:
        {
          hart: 0x40050000
        }
      }
      generate_dif: true
      domain:
      [
        "0"
      ]
    }
    {
      name: i2c0
      type: i2c
      clock_srcs:
      {
        clk_i: io_div4
      }
      clock_group: peri
      reset_connections:
      {
        rst_ni:
        {
          name: i2c0
          domain: "0"
        }
      }
      clock_connections:
      {
        clk_i: clkmgr_aon_clocks.clk_io_div4_peri
      }
      param_decl: {}
      memory: {}
      param_list:
      [
        {
          name: InputDelayCycles
          desc:
            '''
            Maximum number of cycles of propagation delay between a change on the cio_scl_en_o or cio_sda_en_o pins and sensing the new values on the corresponding input pins, not including the rise/fall times.
            For the purposes of this calculation, an input delay of 0 cycles means an output pin changing at the beginning of clock edge N will be sampled and observed on the input pins at clock edge N+1.
            '''
          type: int
          default: "0"
          local: "false"
          expose: "true"
          name_top: I2c0InputDelayCycles
        }
      ]
      inter_signal_list:
      [
        {
          name: ram_cfg
          struct: ram_1p_cfg
          package: prim_ram_1p_pkg
          type: uni
          act: rcv
          width: 1
          inst_name: i2c0
          default: ""
          top_signame: ast_ram_1p_cfg
          index: -1
        }
        {
          name: ram_cfg_rsp
          struct: ram_1p_cfg_rsp
          package: prim_ram_1p_pkg
          type: uni
          act: req
          width: 1
          inst_name: i2c0
          index: -1
        }
        {
          name: lsio_trigger
          desc:
            '''
            Self-clearing status trigger for the DMA.
            Set when RX TX FIFO is past their configured watermark matching watermark interrupt behaviour.
            '''
          struct: logic
          type: uni
          act: req
          width: 1
          inst_name: i2c0
          index: -1
        }
        {
          name: racl_policies
          desc:
            '''
            Incoming RACL policy vector from a racl_ctrl instance.
            The policy selection vector (parameter) selects the policy for each register.
            '''
          struct: racl_policy_vec
          package: top_racl_pkg
          type: uni
          act: rcv
          width: 1
          inst_name: i2c0
          index: -1
        }
        {
          name: racl_error
          desc: RACL error log information of this module.
          struct: racl_error_log
          package: top_racl_pkg
          type: uni
          act: req
          width: 1
          inst_name: i2c0
          index: -1
        }
        {
          name: tl
          struct: tl
          package: tlul_pkg
          type: req_rsp
          act: rsp
          width: 1
          inst_name: i2c0
          default: ""
          end_idx: -1
          top_signame: i2c0_tl
          index: -1
        }
      ]
      base_addrs:
      {
        null:
        {
          hart: 0x40080000
        }
      }
      generate_dif: true
      domain:
      [
        "0"
      ]
    }
    {
      name: i2c1
      type: i2c
      clock_srcs:
      {
        clk_i: io_div4
      }
      clock_group: peri
      reset_connections:
      {
        rst_ni:
        {
          name: i2c1
          domain: "0"
        }
      }
      clock_connections:
      {
        clk_i: clkmgr_aon_clocks.clk_io_div4_peri
      }
      param_decl: {}
      memory: {}
      param_list:
      [
        {
          name: InputDelayCycles
          desc:
            '''
            Maximum number of cycles of propagation delay between a change on the cio_scl_en_o or cio_sda_en_o pins and sensing the new values on the corresponding input pins, not including the rise/fall times.
            For the purposes of this calculation, an input delay of 0 cycles means an output pin changing at the beginning of clock edge N will be sampled and observed on the input pins at clock edge N+1.
            '''
          type: int
          default: "0"
          local: "false"
          expose: "true"
          name_top: I2c1InputDelayCycles
        }
      ]
      inter_signal_list:
      [
        {
          name: ram_cfg
          struct: ram_1p_cfg
          package: prim_ram_1p_pkg
          type: uni
          act: rcv
          width: 1
          inst_name: i2c1
          default: ""
          top_signame: ast_ram_1p_cfg
          index: -1
        }
        {
          name: ram_cfg_rsp
          struct: ram_1p_cfg_rsp
          package: prim_ram_1p_pkg
          type: uni
          act: req
          width: 1
          inst_name: i2c1
          index: -1
        }
        {
          name: lsio_trigger
          desc:
            '''
            Self-clearing status trigger for the DMA.
            Set when RX TX FIFO is past their configured watermark matching watermark interrupt behaviour.
            '''
          struct: logic
          type: uni
          act: req
          width: 1
          inst_name: i2c1
          index: -1
        }
        {
          name: racl_policies
          desc:
            '''
            Incoming RACL policy vector from a racl_ctrl instance.
            The policy selection vector (parameter) selects the policy for each register.
            '''
          struct: racl_policy_vec
          package: top_racl_pkg
          type: uni
          act: rcv
          width: 1
          inst_name: i2c1
          index: -1
        }
        {
          name: racl_error
          desc: RACL error log information of this module.
          struct: racl_error_log
          package: top_racl_pkg
          type: uni
          act: req
          width: 1
          inst_name: i2c1
          index: -1
        }
        {
          name: tl
          struct: tl
          package: tlul_pkg
          type: req_rsp
          act: rsp
          width: 1
          inst_name: i2c1
          default: ""
          end_idx: -1
          top_signame: i2c1_tl
          index: -1
        }
      ]
      base_addrs:
      {
        null:
        {
          hart: 0x40090000
        }
      }
      generate_dif: true
      domain:
      [
        "0"
      ]
    }
    {
      name: i2c2
      type: i2c
      clock_srcs:
      {
        clk_i: io_div4
      }
      clock_group: peri
      reset_connections:
      {
        rst_ni:
        {
          name: i2c2
          domain: "0"
        }
      }
      clock_connections:
      {
        clk_i: clkmgr_aon_clocks.clk_io_div4_peri
      }
      param_decl: {}
      memory: {}
      param_list:
      [
        {
          name: InputDelayCycles
          desc:
            '''
            Maximum number of cycles of propagation delay between a change on the cio_scl_en_o or cio_sda_en_o pins and sensing the new values on the corresponding input pins, not including the rise/fall times.
            For the purposes of this calculation, an input delay of 0 cycles means an output pin changing at the beginning of clock edge N will be sampled and observed on the input pins at clock edge N+1.
            '''
          type: int
          default: "0"
          local: "false"
          expose: "true"
          name_top: I2c2InputDelayCycles
        }
      ]
      inter_signal_list:
      [
        {
          name: ram_cfg
          struct: ram_1p_cfg
          package: prim_ram_1p_pkg
          type: uni
          act: rcv
          width: 1
          inst_name: i2c2
          default: ""
          top_signame: ast_ram_1p_cfg
          index: -1
        }
        {
          name: ram_cfg_rsp
          struct: ram_1p_cfg_rsp
          package: prim_ram_1p_pkg
          type: uni
          act: req
          width: 1
          inst_name: i2c2
          index: -1
        }
        {
          name: lsio_trigger
          desc:
            '''
            Self-clearing status trigger for the DMA.
            Set when RX TX FIFO is past their configured watermark matching watermark interrupt behaviour.
            '''
          struct: logic
          type: uni
          act: req
          width: 1
          inst_name: i2c2
          index: -1
        }
        {
          name: racl_policies
          desc:
            '''
            Incoming RACL policy vector from a racl_ctrl instance.
            The policy selection vector (parameter) selects the policy for each register.
            '''
          struct: racl_policy_vec
          package: top_racl_pkg
          type: uni
          act: rcv
          width: 1
          inst_name: i2c2
          index: -1
        }
        {
          name: racl_error
          desc: RACL error log information of this module.
          struct: racl_error_log
          package: top_racl_pkg
          type: uni
          act: req
          width: 1
          inst_name: i2c2
          index: -1
        }
        {
          name: tl
          struct: tl
          package: tlul_pkg
          type: req_rsp
          act: rsp
          width: 1
          inst_name: i2c2
          default: ""
          end_idx: -1
          top_signame: i2c2_tl
          index: -1
        }
      ]
      base_addrs:
      {
        null:
        {
          hart: 0x400A0000
        }
      }
      generate_dif: true
      domain:
      [
        "0"
      ]
    }
    {
      name: pattgen
      type: pattgen
      clock_srcs:
      {
        clk_i: io_div4
      }
      clock_group: peri
      reset_connections:
      {
        rst_ni:
        {
          name: lc_io_div4
          domain: "0"
        }
      }
      clock_connections:
      {
        clk_i: clkmgr_aon_clocks.clk_io_div4_peri
      }
      param_decl: {}
      param_list: []
      inter_signal_list:
      [
        {
          name: tl
          struct: tl
          package: tlul_pkg
          type: req_rsp
          act: rsp
          width: 1
          inst_name: pattgen
          default: ""
          end_idx: -1
          top_signame: pattgen_tl
          index: -1
        }
      ]
      base_addrs:
      {
        null:
        {
          hart: 0x400E0000
        }
      }
      generate_dif: true
      domain:
      [
        "0"
      ]
    }
    {
      name: rv_timer
      type: rv_timer
      clock_srcs:
      {
        clk_i: io_div4
      }
      clock_group: timers
      reset_connections:
      {
        rst_ni:
        {
          name: lc_io_div4
          domain: "0"
        }
      }
      clock_connections:
      {
        clk_i: clkmgr_aon_clocks.clk_io_div4_timers
      }
      param_decl: {}
      param_list: []
      inter_signal_list:
      [
        {
          name: racl_policies
          desc:
            '''
            Incoming RACL policy vector from a racl_ctrl instance.
            The policy selection vector (parameter) selects the policy for each register.
            '''
          struct: racl_policy_vec
          package: top_racl_pkg
          type: uni
          act: rcv
          width: 1
          inst_name: rv_timer
          index: -1
        }
        {
          name: racl_error
          desc: RACL error log information of this module.
          struct: racl_error_log
          package: top_racl_pkg
          type: uni
          act: req
          width: 1
          inst_name: rv_timer
          index: -1
        }
        {
          name: tl
          struct: tl
          package: tlul_pkg
          type: req_rsp
          act: rsp
          width: 1
          inst_name: rv_timer
          default: ""
          end_idx: -1
          top_signame: rv_timer_tl
          index: -1
        }
      ]
      base_addrs:
      {
        null:
        {
          hart: 0x40100000
        }
      }
      generate_dif: true
      domain:
      [
        "0"
      ]
    }
    {
      name: otp_ctrl
      type: otp_ctrl
      template_type: otp_ctrl
      clock_srcs:
      {
        clk_i: io_div4
        clk_edn_i: main
      }
      clock_group: secure
      reset_connections:
      {
        rst_ni:
        {
          name: lc_io_div4
          domain: "0"
        }
        rst_edn_ni:
        {
          name: lc
          domain: "0"
        }
      }
      base_addrs:
      {
        core:
        {
          hart: 0x40130000
        }
      }
      attr: ipgen
      clock_connections:
      {
        clk_i: clkmgr_aon_clocks.clk_io_div4_secure
        clk_edn_i: clkmgr_aon_clocks.clk_main_secure
      }
      param_decl: {}
      memory: {}
      param_list:
      [
        {
          name: RndCnstLfsrSeed
          desc: Compile-time random bits for initial LFSR seed
          type: otp_ctrl_top_specific_pkg::lfsr_seed_t
          randcount: 40
          randtype: data
          name_top: RndCnstOtpCtrlLfsrSeed
          default: 0x50c2c82deb
          randwidth: 40
        }
        {
          name: RndCnstLfsrPerm
          desc: Compile-time random permutation for LFSR output
          type: otp_ctrl_top_specific_pkg::lfsr_perm_t
          randcount: 40
          randtype: perm
          name_top: RndCnstOtpCtrlLfsrPerm
          default: 0x8573e042648a54e4c07e42e770944376231b1c278894d119623156181694
          randwidth: 240
        }
        {
          name: RndCnstScrmblKeyInit
          desc: Compile-time random permutation for scrambling key/nonce register reset value
          type: otp_ctrl_top_specific_pkg::scrmbl_key_init_t
          randcount: 256
          randtype: data
          name_top: RndCnstOtpCtrlScrmblKeyInit
          default: 0xdbb4685f7eb27eb3b35f352752e34f64ce978305bfc3481a2162ea2792b7508f
          randwidth: 256
        }
      ]
      inter_signal_list:
      [
        {
          name: edn
          desc: Entropy request to the entropy distribution network for LFSR reseeding and ephemeral key derivation.
          struct: edn
          package: edn_pkg
          type: req_rsp
          act: req
          width: 1
          inst_name: otp_ctrl
          default: ""
          top_signame: edn0_edn
          index: 1
        }
        {
          name: pwr_otp
          desc: Initialization request/acknowledge from/to power manager.
          struct: pwr_otp
          package: pwrmgr_pkg
          type: req_rsp
          act: rsp
          width: 1
          default: "'0"
          inst_name: otp_ctrl
          top_signame: pwrmgr_aon_pwr_otp
          index: -1
        }
        {
          name: lc_otp_program
          desc: Life cycle state transition interface.
          struct: lc_otp_program
          package: otp_ctrl_pkg
          type: req_rsp
          act: rsp
          width: 1
          default: "'0"
          inst_name: otp_ctrl
          top_signame: lc_ctrl_lc_otp_program
          index: -1
        }
        {
          name: otp_lc_data
          desc:
            '''
            Life cycle state output holding the current life cycle state,
            the value of the transition counter and the tokens needed for life cycle transitions.
            '''
          struct: otp_lc_data
          package: otp_ctrl_pkg
          type: uni
          act: req
          width: 1
          default: "'0"
          inst_name: otp_ctrl
          end_idx: -1
          top_type: broadcast
          top_signame: otp_ctrl_otp_lc_data
          index: -1
        }
        {
          name: lc_escalate_en
          desc:
            '''
            Life cycle escalation enable coming from life cycle controller.
            This signal moves all FSMs within OTP into the error state.
            '''
          struct: lc_tx
          package: lc_ctrl_pkg
          type: uni
          act: rcv
          width: 1
          default: lc_ctrl_pkg::Off
          inst_name: otp_ctrl
          top_signame: lc_ctrl_lc_escalate_en
          index: -1
        }
        {
          name: lc_creator_seed_sw_rw_en
          desc:
            '''
            Provision enable qualifier coming from life cycle controller.
            This signal enables SW read / write access to the RMA_TOKEN and CREATOR_ROOT_KEY_SHARE0 and CREATOR_ROOT_KEY_SHARE1.
            '''
          struct: lc_tx
          package: lc_ctrl_pkg
          type: uni
          act: rcv
          width: 1
          default: lc_ctrl_pkg::Off
          inst_name: otp_ctrl
          top_signame: lc_ctrl_lc_creator_seed_sw_rw_en
          index: -1
        }
        {
          name: lc_owner_seed_sw_rw_en
          desc:
            '''
            Provision enable qualifier coming from life cycle controller.
            This signal enables SW read / write access to the OWNER_SEED.
            '''
          struct: lc_tx
          package: lc_ctrl_pkg
          type: uni
          act: rcv
          width: 1
          default: lc_ctrl_pkg::Off
          inst_name: otp_ctrl
          index: -1
        }
        {
          name: lc_seed_hw_rd_en
          desc:
            '''
            Seed read enable coming from life cycle controller.
            This signal enables HW read access to the CREATOR_ROOT_KEY_SHARE0 and CREATOR_ROOT_KEY_SHARE1.
            '''
          struct: lc_tx
          package: lc_ctrl_pkg
          type: uni
          act: rcv
          width: 1
          default: lc_ctrl_pkg::Off
          inst_name: otp_ctrl
          top_signame: lc_ctrl_lc_seed_hw_rd_en
          index: -1
        }
        {
          name: lc_check_byp_en
          desc:
            '''
            Life cycle partition check bypass signal.
            This signal causes the life cycle partition to bypass consistency checks during life cycle state transitions in order to prevent spurious consistency check failures.
            '''
          struct: lc_tx
          package: lc_ctrl_pkg
          type: uni
          act: rcv
          width: 1
          default: lc_ctrl_pkg::Off
          inst_name: otp_ctrl
          top_signame: lc_ctrl_lc_check_byp_en
          index: -1
        }
        {
          name: otp_keymgr_key
          desc: Key output to the key manager holding CREATOR_ROOT_KEY_SHARE0 and CREATOR_ROOT_KEY_SHARE1.
          struct: otp_keymgr_key
          package: otp_ctrl_pkg
          type: uni
          act: req
          width: 1
          default: "'0"
          inst_name: otp_ctrl
          end_idx: -1
          top_type: broadcast
          top_signame: otp_ctrl_otp_keymgr_key
          index: -1
        }
        {
          name: flash_otp_key
          desc: Key derivation interface for FLASH scrambling.
          struct: flash_otp_key
          package: otp_ctrl_pkg
          type: req_rsp
          act: rsp
          width: 1
          default: "'0"
          inst_name: otp_ctrl
          top_signame: flash_ctrl_otp
          index: -1
        }
        {
          name: sram_otp_key
          desc: Array with key derivation interfaces for SRAM scrambling devices.
          struct: sram_otp_key
          package: otp_ctrl_pkg
          type: req_rsp
          act: rsp
          width: 4
          default: "'0"
          inst_name: otp_ctrl
          end_idx: 3
          top_type: partial-one-to-N
          top_signame: otp_ctrl_sram_otp_key
          index: -1
        }
        {
          name: otbn_otp_key
          desc: Key derivation interface for OTBN scrambling devices.
          struct: otbn_otp_key
          package: otp_ctrl_pkg
          type: req_rsp
          act: rsp
          width: 1
          default: "'0"
          inst_name: otp_ctrl
          end_idx: -1
          top_signame: otp_ctrl_otbn_otp_key
          index: -1
        }
        {
          name: otp_broadcast
          desc: Output of the HW partitions with breakout data types.
          struct: otp_broadcast
          package: otp_ctrl_part_pkg
          type: uni
          act: req
          width: 1
          default: "'0"
          inst_name: otp_ctrl
          top_signame: otp_ctrl_otp_broadcast
          index: -1
        }
        {
          name: otp_macro
          desc: Data interface for the OTP macro.
          struct: otp_ctrl_macro
          package: otp_ctrl_macro_pkg
          type: req_rsp
          act: req
          width: 1
          default: "'0"
          inst_name: otp_ctrl
          end_idx: -1
          top_signame: otp_ctrl_otp_macro
          index: -1
        }
        {
          name: core_tl
          struct: tl
          package: tlul_pkg
          type: req_rsp
          act: rsp
          width: 1
          inst_name: otp_ctrl
          default: ""
          end_idx: -1
          top_signame: otp_ctrl_core_tl
          index: -1
        }
      ]
      generate_dif: true
      domain:
      [
        "0"
      ]
    }
    {
      name: otp_macro
      type: otp_macro
      clock_srcs:
      {
        clk_i: io_div4
      }
      clock_group: secure
      reset_connections:
      {
        rst_ni:
        {
          name: lc_io_div4
          domain: "0"
        }
      }
      param_decl:
      {
        Width: otp_ctrl_macro_pkg::OtpWidth
        Depth: otp_ctrl_macro_pkg::OtpDepth
        SizeWidth: otp_ctrl_macro_pkg::OtpSizeWidth
        VendorTestOffset: otp_ctrl_reg_pkg::VendorTestOffset
        VendorTestSize: otp_ctrl_reg_pkg::VendorTestSize
      }
      clock_connections:
      {
        clk_i: clkmgr_aon_clocks.clk_io_div4_secure
      }
      memory: {}
      param_list:
      [
        {
          name: Width
          desc: Size of storage words in bits
          type: int
          default: otp_ctrl_macro_pkg::OtpWidth
          local: "false"
          expose: "false"
          name_top: OtpMacroWidth
        }
        {
          name: Depth
          desc: Number of words
          type: int
          default: otp_ctrl_macro_pkg::OtpDepth
          local: "false"
          expose: "false"
          name_top: OtpMacroDepth
        }
        {
          name: SizeWidth
          desc: Number of words transferred per access
          type: int
          default: otp_ctrl_macro_pkg::OtpSizeWidth
          local: "false"
          expose: "false"
          name_top: OtpMacroSizeWidth
        }
        {
          name: MemInitFile
          desc: ""
          type: ""
          default: '''""'''
          local: "false"
          expose: "true"
          name_top: OtpMacroMemInitFile
        }
        {
          name: VendorTestOffset
          desc: ""
          type: int
          default: otp_ctrl_reg_pkg::VendorTestOffset
          local: "false"
          expose: "false"
          name_top: OtpMacroVendorTestOffset
        }
        {
          name: VendorTestSize
          desc: ""
          type: int
          default: otp_ctrl_reg_pkg::VendorTestSize
          local: "false"
          expose: "false"
          name_top: OtpMacroVendorTestSize
        }
      ]
      inter_signal_list:
      [
        {
          name: obs_ctrl
          desc: AST observability control signals.
          struct: ast_obs_ctrl
          package: ast_pkg
          type: uni
          act: rcv
          width: 1
          inst_name: otp_macro
          default: ""
          top_signame: ast_obs_ctrl
          index: -1
        }
        {
          name: otp_obs
          desc: AST observability bus.
          struct: logic
          type: uni
          act: req
          width: 8
          inst_name: otp_macro
          default: ""
          package: ""
          external: true
          top_signame: otp_obs
          conn_type: false
          index: -1
        }
        {
          name: pwr_seq
          desc: Power sequencing signals to AST (VDD domain).
          struct: pwr_seq
          package: otp_macro_pkg
          type: uni
          act: req
          width: 1
          default: "'0"
          inst_name: otp_macro
          external: true
          top_signame: otp_macro_pwr_seq
          conn_type: false
          index: -1
        }
        {
          name: pwr_seq_h
          desc: Power sequencing signals coming from AST (VCC domain).
          struct: pwr_seq
          package: otp_macro_pkg
          type: uni
          act: rcv
          width: 1
          default: "'0"
          inst_name: otp_macro
          external: true
          top_signame: otp_macro_pwr_seq_h
          conn_type: false
          index: -1
        }
        {
          name: ext_voltage_h
          struct: ""
          type: io
          act: none
          width: 1
          default: "'0"
          inst_name: otp_macro
          package: ""
          external: true
          top_signame: otp_ext_voltage_h
          conn_type: false
          index: -1
        }
        {
          name: lc_dft_en
          desc:
            '''
            Test enable qualifier coming from life cycle controller.
            This signals enables the TL-UL access port.
            '''
          struct: lc_tx
          package: lc_ctrl_pkg
          type: uni
          act: rcv
          width: 1
          default: lc_ctrl_pkg::Off
          inst_name: otp_macro
          top_signame: lc_ctrl_lc_dft_en
          index: -1
        }
        {
          name: test
          desc: Vendor test control signals from/to the life cycle TAP.
          struct: otp_test
          package: otp_macro_pkg
          type: req_rsp
          act: rsp
          width: 1
          default: "'0"
          inst_name: otp_macro
          top_signame: lc_ctrl_lc_otp_vendor_test
          index: -1
        }
        {
          name: otp
          desc: Data interface for the OTP macro.
          struct: otp_ctrl_macro
          package: otp_ctrl_macro_pkg
          type: req_rsp
          act: rsp
          width: 1
          default: "'0"
          inst_name: otp_macro
          top_signame: otp_ctrl_otp_macro
          index: -1
        }
        {
          name: cfg
          struct: otp_cfg
          package: otp_macro_pkg
          type: uni
          act: rcv
          width: 1
          default: "'0"
          inst_name: otp_macro
          index: -1
        }
        {
          name: cfg_rsp
          struct: otp_cfg_rsp
          package: otp_macro_pkg
          type: uni
          act: req
          width: 1
          default: "'0"
          inst_name: otp_macro
          index: -1
        }
        {
          name: tl
          struct: tl
          package: tlul_pkg
          type: req_rsp
          act: rsp
          width: 1
          inst_name: otp_macro
          default: ""
          end_idx: -1
          top_signame: otp_macro_tl
          index: -1
        }
      ]
      base_addrs:
      {
        null:
        {
          hart: 0x40138000
        }
      }
      generate_dif: true
      domain:
      [
        "0"
      ]
    }
    {
      name: lc_ctrl
      type: lc_ctrl
      clock_srcs:
      {
        clk_i: io_div4
        clk_kmac_i: main
      }
      clock_group: secure
      reset_connections:
      {
        rst_ni:
        {
          name: lc_io_div4
          domain: "0"
        }
        rst_kmac_ni:
        {
          name: lc
          domain: "0"
        }
      }
      base_addrs:
      {
        regs:
        {
          hart: 0x40140000
        }
        dmi:
        {
          hart: 0x0
        }
      }
      param_decl:
      {
        SecVolatileRawUnlockEn: top_pkg::SecVolatileRawUnlockEn
        SiliconCreatorId: 16'h 4001
        ProductId: 16'h 0002
        RevisionId: 8'h 01
        IdcodeValue: jtag_id_pkg::LC_CTRL_JTAG_IDCODE
        EscNumSeverities: AlertHandlerEscNumSeverities
        EscPingCountWidth: AlertHandlerEscPingCountWidth
      }
      clock_connections:
      {
        clk_i: clkmgr_aon_clocks.clk_io_div4_secure
        clk_kmac_i: clkmgr_aon_clocks.clk_main_secure
      }
      memory: {}
      param_list:
      [
        {
          name: SecVolatileRawUnlockEn
          desc:
            '''
            Disable (0) or enable (1) volatile RAW UNLOCK capability.
            If enabled, it is possible to perform a volatile RAW -> TEST_UNLOCKED0 transition
            without programming the OTP. This is a useful fallback mode in case the OTP is
            not working correctly.

            IMPORTANT NOTE: This should only be used in test chips. The parameter must be set
            to 0 in production tapeouts since this weakens the security posture of the RAW
            UNLOCK mechanism.
            '''
          type: bit
          default: top_pkg::SecVolatileRawUnlockEn
          local: "false"
          expose: "true"
          name_top: SecLcCtrlVolatileRawUnlockEn
        }
        {
          name: UseDmiInterface
          desc: When 1, a TLUL-based DMI interface is used. When 0, a JTAG TAP is used.
          type: bit
          default: "0"
          local: "false"
          expose: "true"
          name_top: LcCtrlUseDmiInterface
        }
        {
          name: RndCnstLcKeymgrDivInvalid
          desc: Diversification value used for all invalid life cycle states.
          type: lc_ctrl_pkg::lc_keymgr_div_t
          randcount: 128
          randtype: data
          name_top: RndCnstLcCtrlLcKeymgrDivInvalid
          default: 0x1eab067af954dda5491439a9dde63208
          randwidth: 128
        }
        {
          name: RndCnstLcKeymgrDivTestUnlocked
          desc: Diversification value used for the TEST_UNLOCKED* life cycle states.
          type: lc_ctrl_pkg::lc_keymgr_div_t
          randcount: 128
          randtype: data
          name_top: RndCnstLcCtrlLcKeymgrDivTestUnlocked
          default: 0x1fdcf25a4fba528399117069e77c887
          randwidth: 128
        }
        {
          name: RndCnstLcKeymgrDivDev
          desc: Diversification value used for the DEV life cycle state.
          type: lc_ctrl_pkg::lc_keymgr_div_t
          randcount: 128
          randtype: data
          name_top: RndCnstLcCtrlLcKeymgrDivDev
          default: 0xf53dda6fb4ef8758b99027b6aa7468bc
          randwidth: 128
        }
        {
          name: RndCnstLcKeymgrDivProduction
          desc: Diversification value used for the PROD/PROD_END life cycle states.
          type: lc_ctrl_pkg::lc_keymgr_div_t
          randcount: 128
          randtype: data
          name_top: RndCnstLcCtrlLcKeymgrDivProduction
          default: 0xbd8d70368e7cfb11a99675b14624061
          randwidth: 128
        }
        {
          name: RndCnstLcKeymgrDivRma
          desc: Diversification value used for the RMA life cycle state.
          type: lc_ctrl_pkg::lc_keymgr_div_t
          randcount: 128
          randtype: data
          name_top: RndCnstLcCtrlLcKeymgrDivRma
          default: 0x9335a9e2d123834d18744778be5e63c0
          randwidth: 128
        }
        {
          name: RndCnstInvalidTokens
          desc: Compile-time random bits used for invalid tokens in the token mux
          type: lc_ctrl_pkg::lc_token_mux_t
          randcount: 1024
          randtype: data
          name_top: RndCnstLcCtrlInvalidTokens
          default: 0x87e36838b56b1a45f6fd312f5353fa7b2ce9fc83ddaf1dd8c5a42e2ad24fa02221b6ff5aad7a9c09d5d9fdd1cfcf512835c0cfae2ed0c69fa488685cea9bc1c89bfb7399aef5c6eb5d6e4e23416a0aa6d7ac7ec9c3304470fbe505f9649400ca9864fd4ce49d2cfc6ecc102540ead8734700a5207132689471aa822bc51cdd4d
          randwidth: 1024
        }
        {
          name: SiliconCreatorId
          desc: Chip generation number.
          type: logic [15:0]
          default: 16'h 4001
          local: "false"
          expose: "true"
          name_top: LcCtrlSiliconCreatorId
        }
        {
          name: ProductId
          desc: Chip revision number.
          type: logic [15:0]
          default: 16'h 0002
          local: "false"
          expose: "true"
          name_top: LcCtrlProductId
        }
        {
          name: RevisionId
          desc: Chip revision number.
          type: logic [7:0]
          default: 8'h 01
          local: "false"
          expose: "true"
          name_top: LcCtrlRevisionId
        }
        {
          name: IdcodeValue
          desc: JTAG ID code.
          type: logic [31:0]
          default: jtag_id_pkg::LC_CTRL_JTAG_IDCODE
          local: "false"
          expose: "true"
          name_top: LcCtrlIdcodeValue
        }
        {
          name: NumRmaAckSigs
          desc: Number of Flash RMA wiping response signals
          type: int
          default: "2"
          local: "true"
          expose: "true"
          name_top: LcCtrlNumRmaAckSigs
        }
        {
          name: EscNumSeverities
          desc: Number of escalation severities
          type: int
          default: AlertHandlerEscNumSeverities
          local: "false"
          expose: "false"
          name_top: LcCtrlEscNumSeverities
        }
        {
          name: EscPingCountWidth
          desc: Width of ping count for the escalation receiver
          type: int
          default: AlertHandlerEscPingCountWidth
          local: "false"
          expose: "false"
          name_top: LcCtrlEscPingCountWidth
        }
      ]
      inter_signal_list:
      [
        {
          name: jtag
          struct: jtag
          package: jtag_pkg
          type: req_rsp
          act: rsp
          width: 1
          inst_name: lc_ctrl
          default: ""
          top_signame: pinmux_aon_lc_jtag
          index: -1
        }
        {
          name: esc_scrap_state0_tx
          struct: esc_tx
          package: prim_esc_pkg
          type: uni
          act: rcv
          width: 1
          inst_name: lc_ctrl
          default: ""
          top_signame: alert_handler_esc_tx
          index: 1
        }
        {
          name: esc_scrap_state0_rx
          struct: esc_rx
          package: prim_esc_pkg
          type: uni
          act: req
          width: 1
          inst_name: lc_ctrl
          default: ""
          top_signame: alert_handler_esc_rx
          index: 1
        }
        {
          name: esc_scrap_state1_tx
          struct: esc_tx
          package: prim_esc_pkg
          type: uni
          act: rcv
          width: 1
          inst_name: lc_ctrl
          default: ""
          top_signame: alert_handler_esc_tx
          index: 2
        }
        {
          name: esc_scrap_state1_rx
          struct: esc_rx
          package: prim_esc_pkg
          type: uni
          act: req
          width: 1
          inst_name: lc_ctrl
          default: ""
          top_signame: alert_handler_esc_rx
          index: 2
        }
        {
          name: pwr_lc
          struct: pwr_lc
          package: lc_ctrl_pkg
          type: req_rsp
          act: rsp
          width: 1
          inst_name: lc_ctrl
          default: ""
          top_signame: pwrmgr_aon_pwr_lc
          index: -1
        }
        {
          name: lc_otp_vendor_test
          struct: otp_test
          package: otp_macro_pkg
          type: req_rsp
          act: req
          width: 1
          default: "'0"
          inst_name: lc_ctrl
          end_idx: -1
          top_signame: lc_ctrl_lc_otp_vendor_test
          index: -1
        }
        {
          name: otp_lc_data
          struct: otp_lc_data
          package: otp_ctrl_pkg
          type: uni
          act: rcv
          width: 1
          default: otp_ctrl_pkg::OTP_LC_DATA_DEFAULT
          inst_name: lc_ctrl
          top_signame: otp_ctrl_otp_lc_data
          index: -1
        }
        {
          name: lc_otp_program
          struct: lc_otp_program
          package: otp_ctrl_pkg
          type: req_rsp
          act: req
          width: 1
          default: "'0"
          inst_name: lc_ctrl
          end_idx: -1
          top_signame: lc_ctrl_lc_otp_program
          index: -1
        }
        {
          name: kmac_data
          struct: app
          package: kmac_pkg
          type: req_rsp
          act: req
          width: 1
          default: "'0"
          inst_name: lc_ctrl
          top_signame: kmac_app
          index: 1
        }
        {
          name: lc_raw_test_rma
          struct: lc_tx
          package: lc_ctrl_pkg
          type: uni
          act: req
          width: 1
          default: lc_ctrl_pkg::Off
          inst_name: lc_ctrl
          index: -1
        }
        {
          name: lc_dft_en
          struct: lc_tx
          package: lc_ctrl_pkg
          type: uni
          act: req
          width: 1
          default: lc_ctrl_pkg::Off
          inst_name: lc_ctrl
          end_idx: -1
          top_type: broadcast
          top_signame: lc_ctrl_lc_dft_en
          index: -1
        }
        {
          name: lc_nvm_debug_en
          struct: lc_tx
          package: lc_ctrl_pkg
          type: uni
          act: req
          width: 1
          default: lc_ctrl_pkg::Off
          inst_name: lc_ctrl
          end_idx: -1
          top_type: broadcast
          top_signame: lc_ctrl_lc_nvm_debug_en
          index: -1
        }
        {
          name: lc_hw_debug_en
          struct: lc_tx
          package: lc_ctrl_pkg
          type: uni
          act: req
          width: 1
          default: lc_ctrl_pkg::Off
          inst_name: lc_ctrl
          end_idx: -1
          top_type: broadcast
          top_signame: lc_ctrl_lc_hw_debug_en
          index: -1
        }
        {
          name: lc_cpu_en
          struct: lc_tx
          package: lc_ctrl_pkg
          type: uni
          act: req
          width: 1
          default: lc_ctrl_pkg::Off
          inst_name: lc_ctrl
          end_idx: -1
          top_type: broadcast
          top_signame: lc_ctrl_lc_cpu_en
          index: -1
        }
        {
          name: lc_keymgr_en
          struct: lc_tx
          package: lc_ctrl_pkg
          type: uni
          act: req
          width: 1
          default: lc_ctrl_pkg::Off
          inst_name: lc_ctrl
          end_idx: -1
          top_type: broadcast
          top_signame: lc_ctrl_lc_keymgr_en
          index: -1
        }
        {
          name: lc_escalate_en
          struct: lc_tx
          package: lc_ctrl_pkg
          type: uni
          act: req
          width: 1
          default: lc_ctrl_pkg::Off
          inst_name: lc_ctrl
          end_idx: -1
          top_type: broadcast
          top_signame: lc_ctrl_lc_escalate_en
          index: -1
        }
        {
          name: lc_clk_byp_req
          struct: lc_tx
          package: lc_ctrl_pkg
          type: uni
          act: req
          width: 1
          default: lc_ctrl_pkg::Off
          inst_name: lc_ctrl
          end_idx: -1
          top_type: broadcast
          top_signame: lc_ctrl_lc_clk_byp_req
          index: -1
        }
        {
          name: lc_clk_byp_ack
          struct: lc_tx
          package: lc_ctrl_pkg
          type: uni
          act: rcv
          width: 1
          default: lc_ctrl_pkg::Off
          inst_name: lc_ctrl
          end_idx: -1
          top_type: broadcast
          top_signame: lc_ctrl_lc_clk_byp_ack
          index: -1
        }
        {
          name: lc_flash_rma_req
          struct: lc_tx
          package: lc_ctrl_pkg
          type: uni
          act: req
          width: 1
          default: lc_ctrl_pkg::Off
          inst_name: lc_ctrl
          end_idx: -1
          top_type: broadcast
          top_signame: lc_ctrl_lc_flash_rma_req
          index: -1
        }
        {
          name: lc_flash_rma_ack
          struct: lc_tx
          package: lc_ctrl_pkg
          type: uni
          act: rcv
          width: 2
          default: lc_ctrl_pkg::On
          inst_name: lc_ctrl
          end_idx: -1
          top_type: one-to-N
          top_signame: lc_ctrl_lc_flash_rma_ack
          index: -1
        }
        {
          name: lc_flash_rma_seed
          struct: lc_flash_rma_seed
          package: lc_ctrl_pkg
          type: uni
          act: req
          width: 1
          default: "'0"
          inst_name: lc_ctrl
          top_signame: flash_ctrl_rma_seed
          index: -1
        }
        {
          name: lc_check_byp_en
          struct: lc_tx
          package: lc_ctrl_pkg
          type: uni
          act: req
          width: 1
          default: lc_ctrl_pkg::Off
          inst_name: lc_ctrl
          end_idx: -1
          top_type: broadcast
          top_signame: lc_ctrl_lc_check_byp_en
          index: -1
        }
        {
          name: lc_creator_seed_sw_rw_en
          struct: lc_tx
          package: lc_ctrl_pkg
          type: uni
          act: req
          width: 1
          default: lc_ctrl_pkg::Off
          inst_name: lc_ctrl
          end_idx: -1
          top_type: broadcast
          top_signame: lc_ctrl_lc_creator_seed_sw_rw_en
          index: -1
        }
        {
          name: lc_owner_seed_sw_rw_en
          struct: lc_tx
          package: lc_ctrl_pkg
          type: uni
          act: req
          width: 1
          default: lc_ctrl_pkg::Off
          inst_name: lc_ctrl
          end_idx: -1
          top_type: broadcast
          top_signame: lc_ctrl_lc_owner_seed_sw_rw_en
          index: -1
        }
        {
          name: lc_iso_part_sw_rd_en
          struct: lc_tx
          package: lc_ctrl_pkg
          type: uni
          act: req
          width: 1
          default: lc_ctrl_pkg::Off
          inst_name: lc_ctrl
          end_idx: -1
          top_type: broadcast
          top_signame: lc_ctrl_lc_iso_part_sw_rd_en
          index: -1
        }
        {
          name: lc_iso_part_sw_wr_en
          struct: lc_tx
          package: lc_ctrl_pkg
          type: uni
          act: req
          width: 1
          default: lc_ctrl_pkg::Off
          inst_name: lc_ctrl
          end_idx: -1
          top_type: broadcast
          top_signame: lc_ctrl_lc_iso_part_sw_wr_en
          index: -1
        }
        {
          name: lc_seed_hw_rd_en
          struct: lc_tx
          package: lc_ctrl_pkg
          type: uni
          act: req
          width: 1
          default: lc_ctrl_pkg::Off
          inst_name: lc_ctrl
          end_idx: -1
          top_type: broadcast
          top_signame: lc_ctrl_lc_seed_hw_rd_en
          index: -1
        }
        {
          name: lc_keymgr_div
          struct: lc_keymgr_div
          package: lc_ctrl_pkg
          type: uni
          act: req
          width: 1
          default: "'0"
          inst_name: lc_ctrl
          end_idx: -1
          top_type: broadcast
          top_signame: lc_ctrl_lc_keymgr_div
          index: -1
        }
        {
          name: otp_device_id
          struct: otp_device_id
          package: otp_ctrl_pkg
          type: uni
          act: rcv
          width: 1
          default: "'0"
          inst_name: lc_ctrl
          top_signame: lc_ctrl_otp_device_id
          index: -1
        }
        {
          name: otp_manuf_state
          struct: otp_manuf_state
          package: otp_ctrl_pkg
          type: uni
          act: rcv
          width: 1
          default: "'0"
          inst_name: lc_ctrl
          top_signame: lc_ctrl_otp_manuf_state
          index: -1
        }
        {
          name: hw_rev
          struct: lc_hw_rev
          package: lc_ctrl_pkg
          type: uni
          act: req
          width: 1
          default: "'0"
          inst_name: lc_ctrl
          index: -1
        }
        {
          name: strap_en_override
          desc:
            '''
            This signal transitions from 0 -> 1 by the lc_ctrl manager after volatile RAW_UNLOCK in order to re-sample the HW straps.
            The signal stays at 1 until reset.
            Note that this is only used in test chips when SecVolatileRawUnlockEn = 1.
            Otherwise this signal is tied off to 0.
            '''
          struct: logic
          type: uni
          act: req
          width: 1
          default: 1'b0
          inst_name: lc_ctrl
          package: ""
          end_idx: -1
          top_type: broadcast
          top_signame: lc_ctrl_strap_en_override
          index: -1
        }
        {
          name: regs_tl
          struct: tl
          package: tlul_pkg
          type: req_rsp
          act: rsp
          width: 1
          inst_name: lc_ctrl
          default: ""
          end_idx: -1
          top_signame: lc_ctrl_regs_tl
          index: -1
        }
        {
          name: dmi_tl
          struct: tl
          package: tlul_pkg
          type: req_rsp
          act: rsp
          width: 1
          inst_name: lc_ctrl
          index: -1
        }
      ]
      generate_dif: true
      domain:
      [
        "0"
      ]
    }
    {
      name: alert_handler
      type: alert_handler
      template_type: alert_handler
      clock_srcs:
      {
        clk_i: io_div4
        clk_edn_i: main
      }
      clock_group: secure
      reset_connections:
      {
        rst_ni:
        {
          name: lc_io_div4
          domain: "0"
        }
        rst_edn_ni:
        {
          name: lc
          domain: "0"
        }
      }
      param_decl:
      {
        EscNumSeverities: "4"
        EscPingCountWidth: "16"
      }
      attr: ipgen
      clock_connections:
      {
        clk_i: clkmgr_aon_clocks.clk_io_div4_secure
        clk_edn_i: clkmgr_aon_clocks.clk_main_secure
      }
      memory: {}
      param_list:
      [
        {
          name: RndCnstLfsrSeed
          desc: Compile-time random bits for initial LFSR seed
          type: alert_handler_pkg::lfsr_seed_t
          randcount: 32
          randtype: data
          name_top: RndCnstAlertHandlerLfsrSeed
          default: 0x37ac2d24
          randwidth: 32
        }
        {
          name: RndCnstLfsrPerm
          desc: Compile-time random permutation for LFSR output
          type: alert_handler_pkg::lfsr_perm_t
          randcount: 32
          randtype: perm
          name_top: RndCnstAlertHandlerLfsrPerm
          default: 0x83a2b09fb9d7006b1534f2bf7d8eb2112787b10d
          randwidth: 160
        }
        {
          name: EscNumSeverities
          desc: Number of escalation severities as regular parameter
          type: int
          default: "4"
          local: "false"
          expose: "true"
          name_top: AlertHandlerEscNumSeverities
        }
        {
          name: EscPingCountWidth
          desc: Width of ping counter as regular parameter
          type: int
          default: "16"
          local: "false"
          expose: "true"
          name_top: AlertHandlerEscPingCountWidth
        }
      ]
      inter_signal_list:
      [
        {
          name: crashdump
          struct: alert_crashdump
          package: alert_handler_pkg
          type: uni
          act: req
          width: 1
          inst_name: alert_handler
          default: ""
          end_idx: -1
          top_type: broadcast
          top_signame: alert_handler_crashdump
          index: -1
        }
        {
          name: edn
          struct: edn
          package: edn_pkg
          type: req_rsp
          act: req
          width: 1
          inst_name: alert_handler
          default: ""
          top_signame: edn0_edn
          index: 4
        }
        {
          name: esc_rx
          struct: esc_rx
          package: prim_esc_pkg
          type: uni
          act: rcv
          width: 4
          inst_name: alert_handler
          default: ""
          end_idx: -1
          top_type: one-to-N
          top_signame: alert_handler_esc_rx
          index: -1
        }
        {
          name: esc_tx
          struct: esc_tx
          package: prim_esc_pkg
          type: uni
          act: req
          width: 4
          inst_name: alert_handler
          default: ""
          end_idx: -1
          top_type: one-to-N
          top_signame: alert_handler_esc_tx
          index: -1
        }
        {
          name: tl
          struct: tl
          package: tlul_pkg
          type: req_rsp
          act: rsp
          width: 1
          inst_name: alert_handler
          default: ""
          end_idx: -1
          top_signame: alert_handler_tl
          index: -1
        }
      ]
      base_addrs:
      {
        null:
        {
          hart: 0x40150000
        }
      }
      generate_dif: true
      domain:
      [
        "0"
      ]
    }
    {
      name: spi_host0
      type: spi_host
      clock_srcs:
      {
        clk_i: io
      }
      clock_group: peri
      reset_connections:
      {
        rst_ni:
        {
          name: spi_host0
          domain: "0"
        }
      }
      clock_connections:
      {
        clk_i: clkmgr_aon_clocks.clk_io_peri
      }
      param_decl: {}
      memory: {}
      param_list:
      [
        {
          name: NumCS
          desc: The number of active-low chip select (cs_n) lines to create.
          type: int
          default: "1"
          local: "true"
          expose: "true"
          name_top: SpiHost0NumCS
        }
      ]
      inter_signal_list:
      [
        {
          name: passthrough
          struct: passthrough
          package: spi_device_pkg
          type: req_rsp
          act: rsp
          width: 1
          inst_name: spi_host0
          default: ""
          top_signame: spi_device_passthrough
          index: -1
        }
        {
          name: lsio_trigger
          desc:
            '''
            Self-clearing status trigger for the DMA.
            Set when RX or TX FIFOs are past their configured watermarks matching watermark interrupt behaviour.
            '''
          struct: logic
          type: uni
          act: req
          width: 1
          inst_name: spi_host0
          index: -1
        }
        {
          name: racl_policies
          desc:
            '''
            Incoming RACL policy vector from a racl_ctrl instance.
            The policy selection vector (parameter) selects the policy for each register.
            '''
          struct: racl_policy_vec
          package: top_racl_pkg
          type: uni
          act: rcv
          width: 1
          inst_name: spi_host0
          index: -1
        }
        {
          name: racl_error
          desc: RACL error log information of this module.
          struct: racl_error_log
          package: top_racl_pkg
          type: uni
          act: req
          width: 1
          inst_name: spi_host0
          index: -1
        }
        {
          name: tl
          struct: tl
          package: tlul_pkg
          type: req_rsp
          act: rsp
          width: 1
          inst_name: spi_host0
          default: ""
          end_idx: -1
          top_signame: spi_host0_tl
          index: -1
        }
      ]
      base_addrs:
      {
        null:
        {
          hart: 0x40300000
        }
      }
      generate_dif: true
      domain:
      [
        "0"
      ]
    }
    {
      name: spi_host1
      type: spi_host
      clock_srcs:
      {
        clk_i: io_div2
      }
      clock_group: peri
      reset_connections:
      {
        rst_ni:
        {
          name: spi_host1
          domain: "0"
        }
      }
      clock_connections:
      {
        clk_i: clkmgr_aon_clocks.clk_io_div2_peri
      }
      param_decl: {}
      memory: {}
      param_list:
      [
        {
          name: NumCS
          desc: The number of active-low chip select (cs_n) lines to create.
          type: int
          default: "1"
          local: "true"
          expose: "true"
          name_top: SpiHost1NumCS
        }
      ]
      inter_signal_list:
      [
        {
          name: passthrough
          struct: passthrough
          package: spi_device_pkg
          type: req_rsp
          act: rsp
          width: 1
          inst_name: spi_host1
          index: -1
        }
        {
          name: lsio_trigger
          desc:
            '''
            Self-clearing status trigger for the DMA.
            Set when RX or TX FIFOs are past their configured watermarks matching watermark interrupt behaviour.
            '''
          struct: logic
          type: uni
          act: req
          width: 1
          inst_name: spi_host1
          index: -1
        }
        {
          name: racl_policies
          desc:
            '''
            Incoming RACL policy vector from a racl_ctrl instance.
            The policy selection vector (parameter) selects the policy for each register.
            '''
          struct: racl_policy_vec
          package: top_racl_pkg
          type: uni
          act: rcv
          width: 1
          inst_name: spi_host1
          index: -1
        }
        {
          name: racl_error
          desc: RACL error log information of this module.
          struct: racl_error_log
          package: top_racl_pkg
          type: uni
          act: req
          width: 1
          inst_name: spi_host1
          index: -1
        }
        {
          name: tl
          struct: tl
          package: tlul_pkg
          type: req_rsp
          act: rsp
          width: 1
          inst_name: spi_host1
          default: ""
          end_idx: -1
          top_signame: spi_host1_tl
          index: -1
        }
      ]
      base_addrs:
      {
        null:
        {
          hart: 0x40310000
        }
      }
      generate_dif: true
      domain:
      [
        "0"
      ]
    }
    {
      name: usbdev
      type: usbdev
      clock_srcs:
      {
        clk_i: usb
        clk_aon_i: aon
      }
      clock_group: peri
      reset_connections:
      {
        rst_ni:
        {
          name: usb
          domain: "0"
        }
        rst_aon_ni:
        {
          name: usb_aon
          domain: "0"
        }
      }
      param_decl:
      {
        RcvrWakeTimeUs: "100"
      }
      clock_connections:
      {
        clk_i: clkmgr_aon_clocks.clk_usb_peri
        clk_aon_i: clkmgr_aon_clocks.clk_aon_peri
      }
      memory: {}
      param_list:
      [
        {
          name: Stub
          desc: Stub out the core of entropy_src logic
          type: bit
          default: "0"
          local: "false"
          expose: "true"
          name_top: UsbdevStub
        }
        {
          name: RcvrWakeTimeUs
          desc: Maximum number of microseconds for the differential receiver to become operational
          type: int
          default: "100"
          local: "false"
          expose: "true"
          name_top: UsbdevRcvrWakeTimeUs
        }
      ]
      inter_signal_list:
      [
        {
          name: usb_rx_d
          desc: USB RX data from an external differential receiver, if available
          struct: logic
          type: uni
          act: rcv
          width: 1
          inst_name: usbdev
          default: ""
          package: ""
          external: true
          top_signame: usbdev_usb_rx_d
          conn_type: false
          index: -1
        }
        {
          name: usb_tx_d
          desc: USB transmit data value (not used if usb_tx_se0 is set)
          struct: logic
          type: uni
          act: req
          width: 1
          inst_name: usbdev
          default: ""
          package: ""
          external: true
          top_signame: usbdev_usb_tx_d
          conn_type: false
          index: -1
        }
        {
          name: usb_tx_se0
          desc: Force transmission of a USB single-ended zero (i.e. both D+ and D- are low) regardless of usb_tx_d
          struct: logic
          type: uni
          act: req
          width: 1
          inst_name: usbdev
          default: ""
          package: ""
          external: true
          top_signame: usbdev_usb_tx_se0
          conn_type: false
          index: -1
        }
        {
          name: usb_tx_use_d_se0
          desc: Use the usb_tx_d and usb_tx_se0 TX interface, instead of usb_dp_o and usb_dn_o
          struct: logic
          type: uni
          act: req
          width: 1
          inst_name: usbdev
          default: ""
          package: ""
          external: true
          top_signame: usbdev_usb_tx_use_d_se0
          conn_type: false
          index: -1
        }
        {
          name: usb_dp_pullup
          desc: USB D+ pullup control
          struct: logic
          type: uni
          act: req
          width: 1
          inst_name: usbdev
          default: ""
          package: ""
          end_idx: -1
          top_type: broadcast
          top_signame: usbdev_usb_dp_pullup
          index: -1
        }
        {
          name: usb_dn_pullup
          desc: USB D- pullup control
          struct: logic
          type: uni
          act: req
          width: 1
          inst_name: usbdev
          default: ""
          package: ""
          end_idx: -1
          top_type: broadcast
          top_signame: usbdev_usb_dn_pullup
          index: -1
        }
        {
          name: usb_rx_enable
          desc: USB differential receiver enable
          struct: logic
          type: uni
          act: req
          width: 1
          inst_name: usbdev
          default: ""
          package: ""
          external: true
          top_signame: usbdev_usb_rx_enable
          conn_type: false
          index: -1
        }
        {
          name: usb_ref_val
          desc: This indicates that USB timing reference signal 'usb_ref_pulse' is valid
          struct: logic
          type: uni
          act: req
          width: 1
          inst_name: usbdev
          default: ""
          package: ""
          external: true
          top_signame: usbdev_usb_ref_val
          conn_type: false
          index: -1
        }
        {
          name: usb_ref_pulse
          desc: USB timing reference signal. This signal pulses for a single 48MHz clock every 1ms USB frame
          struct: logic
          type: uni
          act: req
          width: 1
          inst_name: usbdev
          default: ""
          package: ""
          external: true
          top_signame: usbdev_usb_ref_pulse
          conn_type: false
          index: -1
        }
        {
          name: usb_aon_suspend_req
          desc: Request to activate the AON/Wake module and take control of the USB pullups
          struct: logic
          type: uni
          act: req
          width: 1
          inst_name: usbdev
          default: ""
          package: ""
          end_idx: -1
          top_type: broadcast
          top_signame: usbdev_usb_aon_suspend_req
          index: -1
        }
        {
          name: usb_aon_wake_ack
          desc: Acknowledge a wake signal from the AON/Wake and relinquish control of the USB pullups
          struct: logic
          type: uni
          act: req
          width: 1
          inst_name: usbdev
          default: ""
          package: ""
          end_idx: -1
          top_type: broadcast
          top_signame: usbdev_usb_aon_wake_ack
          index: -1
        }
        {
          name: usb_aon_bus_reset
          desc: Indicates that the reason for waking was that a USB Bus Reset occurred
          struct: logic
          type: uni
          act: rcv
          width: 1
          inst_name: usbdev
          default: ""
          package: ""
          end_idx: -1
          top_type: broadcast
          top_signame: usbdev_usb_aon_bus_reset
          index: -1
        }
        {
          name: usb_aon_sense_lost
          desc: Indicates that the reason for waking was that the VBUS/SENSE signal became deasserted
          struct: logic
          type: uni
          act: rcv
          width: 1
          inst_name: usbdev
          default: ""
          package: ""
          end_idx: -1
          top_type: broadcast
          top_signame: usbdev_usb_aon_sense_lost
          index: -1
        }
        {
          name: usb_aon_bus_not_idle
          desc: Indicates that the reason for waking was that the USB is in a non-idle state
          struct: logic
          type: uni
          act: rcv
          width: 1
          inst_name: usbdev
          default: ""
          package: ""
          end_idx: -1
          top_type: broadcast
          top_signame: usbdev_usb_aon_bus_not_idle
          index: -1
        }
        {
          name: usb_aon_wake_detect_active
          desc: Indicates that the external AON/Wake module is active and controlling the USB pullups
          struct: logic
          type: uni
          act: rcv
          width: 1
          inst_name: usbdev
          default: ""
          package: ""
          top_signame: pinmux_aon_usbdev_wake_detect_active
          index: -1
        }
        {
          name: ram_cfg
          struct: ram_1p_cfg
          package: prim_ram_1p_pkg
          type: uni
          act: rcv
          width: 1
          inst_name: usbdev
          default: ""
          top_signame: ast_usb_ram_1p_cfg
          index: -1
        }
        {
          name: ram_cfg_rsp
          struct: ram_1p_cfg_rsp
          package: prim_ram_1p_pkg
          type: uni
          act: req
          width: 1
          inst_name: usbdev
          index: -1
        }
        {
          name: tl
          struct: tl
          package: tlul_pkg
          type: req_rsp
          act: rsp
          width: 1
          inst_name: usbdev
          default: ""
          end_idx: -1
          top_signame: usbdev_tl
          index: -1
        }
      ]
      base_addrs:
      {
        null:
        {
          hart: 0x40320000
        }
      }
      generate_dif: true
      domain:
      [
        "0"
      ]
    }
    {
      name: pwrmgr_aon
      type: pwrmgr
      template_type: pwrmgr
      clock_group: powerup
      clock_srcs:
      {
        clk_i: io_div4
        clk_slow_i: aon
        clk_lc_i: io_div4
        clk_esc_i:
        {
          clock: io_div4
          group: secure
        }
      }
      reset_connections:
      {
        rst_ni:
        {
          name: por_io_div4
          domain: Aon
        }
        rst_main_ni:
        {
          name: por_aon
          domain: "0"
        }
        rst_lc_ni:
        {
          name: lc_io_div4
          domain: Aon
        }
        rst_esc_ni:
        {
          name: lc_io_div4
          domain: Aon
        }
        rst_slow_ni:
        {
          name: por_aon
          domain: Aon
        }
      }
      domain:
      [
        Aon
        "0"
      ]
      param_decl:
      {
        EscNumSeverities: AlertHandlerEscNumSeverities
        EscPingCountWidth: AlertHandlerEscPingCountWidth
      }
      attr: ipgen
      clock_connections:
      {
        clk_i: clkmgr_aon_clocks.clk_io_div4_powerup
        clk_slow_i: clkmgr_aon_clocks.clk_aon_powerup
        clk_lc_i: clkmgr_aon_clocks.clk_io_div4_powerup
        clk_esc_i: clkmgr_aon_clocks.clk_io_div4_secure
      }
      memory: {}
      param_list:
      [
        {
          name: EscNumSeverities
          desc: Number of escalation severities
          type: int
          default: AlertHandlerEscNumSeverities
          local: "false"
          expose: "false"
          name_top: PwrmgrAonEscNumSeverities
        }
        {
          name: EscPingCountWidth
          desc: Width of ping count for the escalation receiver
          type: int
          default: AlertHandlerEscPingCountWidth
          local: "false"
          expose: "false"
          name_top: PwrmgrAonEscPingCountWidth
        }
      ]
      inter_signal_list:
      [
        {
          name: pwr_ast
          struct: pwr_ast
          package: pwrmgr_pkg
          type: req_rsp
          act: req
          width: 1
          inst_name: pwrmgr_aon
          default: ""
          external: true
          top_signame: pwrmgr_ast
          conn_type: false
          index: -1
        }
        {
          name: pwr_rst
          struct: pwr_rst
          package: pwrmgr_pkg
          type: req_rsp
          act: req
          width: 1
          inst_name: pwrmgr_aon
          default: ""
          end_idx: -1
          top_signame: pwrmgr_aon_pwr_rst
          index: -1
        }
        {
          name: pwr_clk
          struct: pwr_clk
          package: pwrmgr_pkg
          type: req_rsp
          act: req
          width: 1
          inst_name: pwrmgr_aon
          default: ""
          end_idx: -1
          top_signame: pwrmgr_aon_pwr_clk
          index: -1
        }
        {
          name: pwr_otp
          struct: pwr_otp
          package: pwrmgr_pkg
          type: req_rsp
          act: req
          width: 1
          inst_name: pwrmgr_aon
          default: ""
          end_idx: -1
          top_signame: pwrmgr_aon_pwr_otp
          index: -1
        }
        {
          name: pwr_lc
          struct: pwr_lc
          package: lc_ctrl_pkg
          type: req_rsp
          act: req
          width: 1
          inst_name: pwrmgr_aon
          default: ""
          end_idx: -1
          top_signame: pwrmgr_aon_pwr_lc
          index: -1
        }
        {
          name: pwr_flash
          struct: pwr_flash
          package: pwrmgr_pkg
          type: uni
          act: rcv
          width: 1
          inst_name: pwrmgr_aon
          default: ""
          end_idx: -1
          top_type: broadcast
          top_signame: pwrmgr_aon_pwr_flash
          index: -1
        }
        {
          name: esc_rst_tx
          struct: esc_tx
          package: prim_esc_pkg
          type: uni
          act: rcv
          width: 1
          inst_name: pwrmgr_aon
          default: ""
          top_signame: alert_handler_esc_tx
          index: 3
        }
        {
          name: esc_rst_rx
          struct: esc_rx
          package: prim_esc_pkg
          type: uni
          act: req
          width: 1
          inst_name: pwrmgr_aon
          default: ""
          top_signame: alert_handler_esc_rx
          index: 3
        }
        {
          name: pwr_cpu
          struct: cpu_pwrmgr
          package: rv_core_ibex_pkg
          type: uni
          act: rcv
          width: 1
          inst_name: pwrmgr_aon
          default: ""
          top_signame: rv_core_ibex_pwrmgr
          index: -1
        }
        {
          name: wakeups
          struct: logic
          type: uni
          act: rcv
          width: 6
          inst_name: pwrmgr_aon
          default: ""
          package: ""
          end_idx: -1
          top_type: one-to-N
          top_signame: pwrmgr_aon_wakeups
          index: -1
        }
        {
          name: rstreqs
          struct: logic
          type: uni
          act: rcv
          width: 2
          inst_name: pwrmgr_aon
          default: ""
          package: ""
          end_idx: -1
          top_type: one-to-N
          top_signame: pwrmgr_aon_rstreqs
          index: -1
        }
        {
          name: ndmreset_req
          struct: logic
          type: uni
          act: rcv
          width: 1
          inst_name: pwrmgr_aon
          default: ""
          package: ""
          top_signame: rv_dm_ndmreset_req
          index: -1
        }
        {
          name: strap
          struct: logic
          type: uni
          act: req
          width: 1
          inst_name: pwrmgr_aon
          default: ""
          package: ""
          end_idx: -1
          top_type: broadcast
          top_signame: pwrmgr_aon_strap
          index: -1
        }
        {
          name: low_power
          struct: logic
          type: uni
          act: req
          width: 1
          inst_name: pwrmgr_aon
          default: ""
          package: ""
          end_idx: -1
          top_type: broadcast
          top_signame: pwrmgr_aon_low_power
          index: -1
        }
        {
          name: rom_ctrl
          struct: pwrmgr_data
          package: rom_ctrl_pkg
          type: uni
          act: rcv
          width: 1
          default: rom_ctrl_pkg::PWRMGR_DATA_DEFAULT
          inst_name: pwrmgr_aon
          top_signame: rom_ctrl_pwrmgr_data
          index: -1
        }
        {
          name: fetch_en
          struct: lc_tx
          package: lc_ctrl_pkg
          type: uni
          act: req
          width: 1
          inst_name: pwrmgr_aon
          default: ""
          end_idx: -1
          top_type: broadcast
          top_signame: pwrmgr_aon_fetch_en
          index: -1
        }
        {
          name: lc_dft_en
          struct: lc_tx
          package: lc_ctrl_pkg
          type: uni
          act: rcv
          width: 1
          inst_name: pwrmgr_aon
          default: ""
          top_signame: lc_ctrl_lc_dft_en
          index: -1
        }
        {
          name: lc_hw_debug_en
          struct: lc_tx
          package: lc_ctrl_pkg
          type: uni
          act: rcv
          width: 1
          inst_name: pwrmgr_aon
          default: ""
          top_signame: lc_ctrl_lc_hw_debug_en
          index: -1
        }
        {
          name: sw_rst_req
          struct: mubi4
          package: prim_mubi_pkg
          type: uni
          act: rcv
          width: 1
          inst_name: pwrmgr_aon
          default: ""
          top_signame: rstmgr_aon_sw_rst_req
          index: -1
        }
        {
          name: tl
          struct: tl
          package: tlul_pkg
          type: req_rsp
          act: rsp
          width: 1
          inst_name: pwrmgr_aon
          default: ""
          end_idx: -1
          top_signame: pwrmgr_aon_tl
          index: -1
        }
      ]
      base_addrs:
      {
        null:
        {
          hart: 0x40400000
        }
      }
      generate_dif: true
    }
    {
      name: rstmgr_aon
      type: rstmgr
      template_type: rstmgr
      clock_srcs:
      {
        clk_i:
        {
          clock: io_div4
          group: powerup
        }
        clk_por_i: io_div4
        clk_aon_i: aon
        clk_main_i: main
        clk_io_i: io
        clk_usb_i: usb
        clk_io_div2_i: io_div2
        clk_io_div4_i: io_div4
      }
      clock_group: powerup
      reset_connections:
      {
        rst_ni:
        {
          name: lc_io_div4
          domain: Aon
        }
        rst_por_ni:
        {
          name: por_io_div4
          domain: Aon
        }
      }
      domain:
      [
        Aon
        "0"
      ]
      attr: ipgen
      clock_connections:
      {
        clk_i: clkmgr_aon_clocks.clk_io_div4_powerup
        clk_por_i: clkmgr_aon_clocks.clk_io_div4_powerup
        clk_aon_i: clkmgr_aon_clocks.clk_aon_powerup
        clk_main_i: clkmgr_aon_clocks.clk_main_powerup
        clk_io_i: clkmgr_aon_clocks.clk_io_powerup
        clk_usb_i: clkmgr_aon_clocks.clk_usb_powerup
        clk_io_div2_i: clkmgr_aon_clocks.clk_io_div2_powerup
        clk_io_div4_i: clkmgr_aon_clocks.clk_io_div4_powerup
      }
      param_decl: {}
      memory: {}
      param_list:
      [
        {
          name: SecCheck
          desc:
            '''
            When 1, enable rstmgr reset consistency checks.
            When 0, there are no consistency checks.
            '''
          type: bit
          default: 1'b1
          local: "false"
          expose: "true"
          name_top: SecRstmgrAonCheck
        }
        {
          name: SecMaxSyncDelay
          desc: The maximum synchronization delay for parent / child reset checks.
          type: int
          default: "2"
          local: "false"
          expose: "true"
          name_top: SecRstmgrAonMaxSyncDelay
        }
      ]
      inter_signal_list:
      [
        {
          name: por_n
          desc:
            '''
            Root power on reset signals from ast.
            There is one root reset signal for each core power domain.
            '''
          struct: logic
          type: uni
          act: rcv
          width: 2
          inst_name: rstmgr_aon
          default: ""
          package: ""
          external: true
          top_signame: por_n
          conn_type: false
          index: -1
        }
        {
          name: pwr
          desc:
            '''
            Reset request signals from power manager.
            Power manager can request for specific domains of the lc/sys reset tree to assert.
            '''
          struct: pwr_rst
          type: req_rsp
          act: rsp
          width: 1
          inst_name: rstmgr_aon
          default: ""
          package: pwrmgr_pkg
          top_signame: pwrmgr_aon_pwr_rst
          index: -1
        }
        {
          name: resets
          desc: Leaf resets fed to the system.
          struct: rstmgr_out
          package: rstmgr_pkg
          type: uni
          act: req
          width: 1
          inst_name: rstmgr_aon
          default: ""
          top_signame: rstmgr_aon_resets
          index: -1
        }
        {
          name: rst_en
          desc: Low-power-group outputs used by alert handler.
          struct: rstmgr_rst_en
          package: rstmgr_pkg
          type: uni
          act: req
          width: 1
          inst_name: rstmgr_aon
          default: ""
          top_signame: rstmgr_aon_rst_en
          index: -1
        }
        {
          name: alert_dump
          desc: Alert handler crash dump information.
          struct: alert_crashdump
          package: alert_handler_pkg
          type: uni
          act: rcv
          width: 1
          inst_name: rstmgr_aon
          default: ""
          top_signame: alert_handler_crashdump
          index: -1
        }
        {
          name: cpu_dump
          desc: Main processing element crash dump information.
          struct: cpu_crash_dump
          package: rv_core_ibex_pkg
          type: uni
          act: rcv
          width: 1
          inst_name: rstmgr_aon
          default: ""
          top_signame: rv_core_ibex_crash_dump
          index: -1
        }
        {
          name: sw_rst_req
          desc: Software requested system reset to pwrmgr.
          struct: mubi4
          package: prim_mubi_pkg
          type: uni
          act: req
          width: 1
          inst_name: rstmgr_aon
          default: ""
          end_idx: -1
          top_type: broadcast
          top_signame: rstmgr_aon_sw_rst_req
          index: -1
        }
        {
          name: tl
          struct: tl
          package: tlul_pkg
          type: req_rsp
          act: rsp
          width: 1
          inst_name: rstmgr_aon
          default: ""
          end_idx: -1
          top_signame: rstmgr_aon_tl
          index: -1
        }
      ]
      base_addrs:
      {
        null:
        {
          hart: 0x40410000
        }
      }
      generate_dif: true
    }
    {
      name: clkmgr_aon
      type: clkmgr
      template_type: clkmgr
      clock_srcs:
      {
        clk_i: io_div4
        clk_main_i:
        {
          group: ast
          clock: main
        }
        clk_io_i:
        {
          group: ast
          clock: io
        }
        clk_usb_i:
        {
          group: ast
          clock: usb
        }
        clk_aon_i:
        {
          group: ast
          clock: aon
        }
      }
      clock_group: powerup
      reset_connections:
      {
        rst_ni:
        {
          name: lc_io_div4
          domain: Aon
        }
        rst_aon_ni:
        {
          name: lc_aon
          domain: Aon
        }
        rst_io_ni:
        {
          name: lc_io
          domain: Aon
        }
        rst_io_div2_ni:
        {
          name: lc_io_div2
          domain: Aon
        }
        rst_io_div4_ni:
        {
          name: lc_io_div4
          domain: Aon
        }
        rst_main_ni:
        {
          name: lc
          domain: Aon
        }
        rst_usb_ni:
        {
          name: lc_usb
          domain: Aon
        }
        rst_root_ni:
        {
          name: por_io_div4
          domain: Aon
        }
        rst_root_io_ni:
        {
          name: por_io
          domain: Aon
        }
        rst_root_io_div2_ni:
        {
          name: por_io_div2
          domain: Aon
        }
        rst_root_io_div4_ni:
        {
          name: por_io_div4
          domain: Aon
        }
        rst_root_main_ni:
        {
          name: por
          domain: Aon
        }
        rst_root_usb_ni:
        {
          name: por_usb
          domain: Aon
        }
      }
      domain:
      [
        Aon
      ]
      attr: ipgen
      clock_connections:
      {
        clk_i: clkmgr_aon_clocks.clk_io_div4_powerup
        clk_main_i: clk_main_i
        clk_io_i: clk_io_i
        clk_usb_i: clk_usb_i
        clk_aon_i: clk_aon_i
      }
      param_decl: {}
      param_list: []
      inter_signal_list:
      [
        {
          name: clocks
          struct: clkmgr_out
          package: clkmgr_pkg
          type: uni
          act: req
          width: 1
          inst_name: clkmgr_aon
          default: ""
          top_signame: clkmgr_aon_clocks
          index: -1
        }
        {
          name: cg_en
          struct: clkmgr_cg_en
          package: clkmgr_pkg
          type: uni
          act: req
          width: 1
          inst_name: clkmgr_aon
          default: ""
          top_signame: clkmgr_aon_cg_en
          index: -1
        }
        {
          name: lc_hw_debug_en
          struct: lc_tx
          package: lc_ctrl_pkg
          type: uni
          act: rcv
          width: 1
          inst_name: clkmgr_aon
          default: ""
          top_signame: lc_ctrl_lc_hw_debug_en
          index: -1
        }
        {
          name: io_clk_byp_req
          struct: mubi4
          package: prim_mubi_pkg
          type: uni
          act: req
          width: 1
          inst_name: clkmgr_aon
          default: ""
          external: true
          top_signame: io_clk_byp_req
          conn_type: false
          index: -1
        }
        {
          name: io_clk_byp_ack
          struct: mubi4
          package: prim_mubi_pkg
          type: uni
          act: rcv
          width: 1
          inst_name: clkmgr_aon
          default: ""
          external: true
          top_signame: io_clk_byp_ack
          conn_type: false
          index: -1
        }
        {
          name: all_clk_byp_req
          struct: mubi4
          package: prim_mubi_pkg
          type: uni
          act: req
          width: 1
          inst_name: clkmgr_aon
          default: ""
          external: true
          top_signame: all_clk_byp_req
          conn_type: false
          index: -1
        }
        {
          name: all_clk_byp_ack
          struct: mubi4
          package: prim_mubi_pkg
          type: uni
          act: rcv
          width: 1
          inst_name: clkmgr_aon
          default: ""
          external: true
          top_signame: all_clk_byp_ack
          conn_type: false
          index: -1
        }
        {
          name: hi_speed_sel
          struct: mubi4
          package: prim_mubi_pkg
          type: uni
          act: req
          width: 1
          inst_name: clkmgr_aon
          default: ""
          external: true
          top_signame: hi_speed_sel
          conn_type: false
          index: -1
        }
        {
          name: div_step_down_req
          struct: mubi4
          package: prim_mubi_pkg
          type: uni
          act: rcv
          width: 1
          inst_name: clkmgr_aon
          default: ""
          external: true
          top_signame: div_step_down_req
          conn_type: false
          index: -1
        }
        {
          name: lc_clk_byp_req
          struct: lc_tx
          package: lc_ctrl_pkg
          type: uni
          act: rcv
          width: 1
          inst_name: clkmgr_aon
          default: ""
          top_signame: lc_ctrl_lc_clk_byp_req
          index: -1
        }
        {
          name: lc_clk_byp_ack
          struct: lc_tx
          package: lc_ctrl_pkg
          type: uni
          act: req
          width: 1
          inst_name: clkmgr_aon
          default: ""
          top_signame: lc_ctrl_lc_clk_byp_ack
          index: -1
        }
        {
          name: jitter_en
          struct: mubi4
          package: prim_mubi_pkg
          type: uni
          act: req
          width: 1
          inst_name: clkmgr_aon
          default: ""
          external: true
          top_signame: clk_main_jitter_en
          conn_type: false
          index: -1
        }
        {
          name: pwr
          struct: pwr_clk
          type: req_rsp
          act: rsp
          width: 1
          inst_name: clkmgr_aon
          default: ""
          package: pwrmgr_pkg
          top_signame: pwrmgr_aon_pwr_clk
          index: -1
        }
        {
          name: idle
          struct: mubi4
          package: prim_mubi_pkg
          type: uni
          act: rcv
          width: 4
          inst_name: clkmgr_aon
          default: ""
          end_idx: -1
          top_type: one-to-N
          top_signame: clkmgr_aon_idle
          index: -1
        }
        {
          name: calib_rdy
          desc: Indicates clocks are calibrated and frequencies accurate
          struct: mubi4
          package: prim_mubi_pkg
          type: uni
          act: rcv
          width: 1
          default: prim_mubi_pkg::MuBi4True
          inst_name: clkmgr_aon
          external: true
          top_signame: calib_rdy
          conn_type: false
          index: -1
        }
        {
          name: tl
          struct: tl
          package: tlul_pkg
          type: req_rsp
          act: rsp
          width: 1
          inst_name: clkmgr_aon
          default: ""
          end_idx: -1
          top_signame: clkmgr_aon_tl
          index: -1
        }
      ]
      base_addrs:
      {
        null:
        {
          hart: 0x40420000
        }
      }
      generate_dif: true
    }
    {
      name: sysrst_ctrl_aon
      type: sysrst_ctrl
      clock_srcs:
      {
        clk_i: io_div4
        clk_aon_i: aon
      }
      clock_group: secure
      reset_connections:
      {
        rst_ni:
        {
          name: lc_io_div4
          domain: Aon
        }
        rst_aon_ni:
        {
          name: lc_aon
          domain: Aon
        }
      }
      domain:
      [
        Aon
      ]
      clock_connections:
      {
        clk_i: clkmgr_aon_clocks.clk_io_div4_secure
        clk_aon_i: clkmgr_aon_clocks.clk_aon_secure
      }
      param_decl: {}
      param_list: []
      inter_signal_list:
      [
        {
          name: wkup_req
          struct: logic
          type: uni
          act: req
          width: 1
          inst_name: sysrst_ctrl_aon
          default: ""
          package: ""
          top_signame: pwrmgr_aon_wakeups
          index: 0
        }
        {
          name: rst_req
          struct: logic
          type: uni
          act: req
          width: 1
          inst_name: sysrst_ctrl_aon
          default: ""
          package: ""
          top_signame: pwrmgr_aon_rstreqs
          index: 0
        }
        {
          name: tl
          struct: tl
          package: tlul_pkg
          type: req_rsp
          act: rsp
          width: 1
          inst_name: sysrst_ctrl_aon
          default: ""
          end_idx: -1
          top_signame: sysrst_ctrl_aon_tl
          index: -1
        }
      ]
      base_addrs:
      {
        null:
        {
          hart: 0x40430000
        }
      }
      generate_dif: true
    }
    {
      name: adc_ctrl_aon
      type: adc_ctrl
      clock_srcs:
      {
        clk_i: io_div4
        clk_aon_i: aon
      }
      clock_group: peri
      reset_connections:
      {
        rst_ni:
        {
          name: lc_io_div4
          domain: Aon
        }
        rst_aon_ni:
        {
          name: lc_aon
          domain: Aon
        }
      }
      domain:
      [
        Aon
      ]
      clock_connections:
      {
        clk_i: clkmgr_aon_clocks.clk_io_div4_peri
        clk_aon_i: clkmgr_aon_clocks.clk_aon_peri
      }
      param_decl: {}
      param_list: []
      inter_signal_list:
      [
        {
          name: adc
          struct: adc_ast
          package: ast_pkg
          type: req_rsp
          act: req
          width: 1
          inst_name: adc_ctrl_aon
          default: ""
          external: true
          top_signame: adc
          conn_type: false
          index: -1
        }
        {
          name: wkup_req
          struct: logic
          type: uni
          act: req
          width: 1
          inst_name: adc_ctrl_aon
          default: ""
          package: ""
          top_signame: pwrmgr_aon_wakeups
          index: 1
        }
        {
          name: tl
          struct: tl
          package: tlul_pkg
          type: req_rsp
          act: rsp
          width: 1
          inst_name: adc_ctrl_aon
          default: ""
          end_idx: -1
          top_signame: adc_ctrl_aon_tl
          index: -1
        }
      ]
      base_addrs:
      {
        null:
        {
          hart: 0x40440000
        }
      }
      generate_dif: true
    }
    {
      name: pwm_aon
      type: pwm
      template_type: pwm
      clock_srcs:
      {
        clk_i: io_div4
        clk_core_i: aon
      }
      clock_group: peri
      reset_connections:
      {
        rst_ni:
        {
          name: lc_io_div4
          domain: Aon
        }
        rst_core_ni:
        {
          name: lc_aon
          domain: Aon
        }
      }
      domain:
      [
        Aon
      ]
      attr: ipgen
      clock_connections:
      {
        clk_i: clkmgr_aon_clocks.clk_io_div4_peri
        clk_core_i: clkmgr_aon_clocks.clk_aon_peri
      }
      param_decl: {}
      param_list: []
      inter_signal_list:
      [
        {
          name: racl_policies
          desc:
            '''
            Incoming RACL policy vector from a racl_ctrl instance.
            The policy selection vector (parameter) selects the policy for each register.
            '''
          struct: racl_policy_vec
          package: top_racl_pkg
          type: uni
          act: rcv
          width: 1
          inst_name: pwm_aon
          index: -1
        }
        {
          name: racl_error
          desc: RACL error log information of this module.
          struct: racl_error_log
          package: top_racl_pkg
          type: uni
          act: req
          width: 1
          inst_name: pwm_aon
          index: -1
        }
        {
          name: tl
          struct: tl
          package: tlul_pkg
          type: req_rsp
          act: rsp
          width: 1
          inst_name: pwm_aon
          default: ""
          end_idx: -1
          top_signame: pwm_aon_tl
          index: -1
        }
      ]
      base_addrs:
      {
        null:
        {
          hart: 0x40450000
        }
      }
      generate_dif: true
    }
    {
      name: pinmux_aon
      type: pinmux
      template_type: pinmux
      clock_srcs:
      {
        clk_i: io_div4
        clk_aon_i: aon
      }
      clock_group: powerup
      reset_connections:
      {
        rst_ni:
        {
          name: lc_io_div4
          domain: Aon
        }
        rst_aon_ni:
        {
          name: lc_aon
          domain: Aon
        }
        rst_sys_ni:
        {
          name: sys_io_div4
          domain: Aon
        }
      }
      domain:
      [
        Aon
      ]
      attr: ipgen
      param_decl:
      {
        SecVolatileRawUnlockEn: top_pkg::SecVolatileRawUnlockEn
      }
      clock_connections:
      {
        clk_i: clkmgr_aon_clocks.clk_io_div4_powerup
        clk_aon_i: clkmgr_aon_clocks.clk_aon_powerup
      }
      memory: {}
      param_list:
      [
        {
          name: SecVolatileRawUnlockEn
          desc:
            '''
            Disable (0) or enable (1) volatile RAW UNLOCK capability.
            If enabled, the strap_en_override_i input can be used to re-sample the straps at runtime.

            IMPORTANT NOTE: This should only be used in test chips. The parameter must be set
            to 0 in production tapeouts since this weakens the security posture of the RAW
            UNLOCK mechanism.
            '''
          type: bit
          default: top_pkg::SecVolatileRawUnlockEn
          local: "false"
          expose: "true"
          name_top: SecPinmuxAonVolatileRawUnlockEn
        }
        {
          name: TargetCfg
          desc: Target specific pinmux configuration.
          type: pinmux_pkg::target_cfg_t
          default: pinmux_pkg::DefaultTargetCfg
          local: "false"
          expose: "true"
          name_top: PinmuxAonTargetCfg
        }
      ]
      inter_signal_list:
      [
        {
          name: lc_hw_debug_en
          desc: Debug enable qualifier coming from life cycle controller, used for HW strap qualification.
          struct: lc_tx
          package: lc_ctrl_pkg
          type: uni
          act: rcv
          width: 1
          default: lc_ctrl_pkg::Off
          inst_name: pinmux_aon
          top_signame: lc_ctrl_lc_hw_debug_en
          index: -1
        }
        {
          name: lc_dft_en
          desc: Test enable qualifier coming from life cycle controller, used for HW strap qualification.
          struct: lc_tx
          package: lc_ctrl_pkg
          type: uni
          act: rcv
          width: 1
          default: lc_ctrl_pkg::Off
          inst_name: pinmux_aon
          top_signame: lc_ctrl_lc_dft_en
          index: -1
        }
        {
          name: lc_escalate_en
          desc:
            '''
            Escalation enable signal coming from life cycle controller, used for invalidating
            the latched lc_hw_debug_en state inside the strap sampling logic.
            '''
          struct: lc_tx
          package: lc_ctrl_pkg
          type: uni
          act: rcv
          width: 1
          default: lc_ctrl_pkg::Off
          inst_name: pinmux_aon
          top_signame: lc_ctrl_lc_escalate_en
          index: -1
        }
        {
          name: lc_check_byp_en
          desc:
            '''
            Check bypass enable signal coming from life cycle controller, used for invalidating
            the latched lc_hw_debug_en state inside the strap sampling logic. This signal is asserted
            whenever the life cycle controller performs a life cycle transition. Its main use is
            to skip any background checks inside the life cycle partition of the OTP controller while
            a life cycle transition is in progress.
            '''
          struct: lc_tx
          package: lc_ctrl_pkg
          type: uni
          act: rcv
          width: 1
          default: lc_ctrl_pkg::Off
          inst_name: pinmux_aon
          top_signame: lc_ctrl_lc_check_byp_en
          index: -1
        }
        {
          name: pinmux_hw_debug_en
          desc:
            '''
            This is the latched version of lc_hw_debug_en_i. We use it exclusively to gate the JTAG
            signals and TAP side of the RV_DM so that RV_DM can remain live during an NDM reset cycle.
            '''
          struct: lc_tx
          package: lc_ctrl_pkg
          type: uni
          act: req
          width: 1
          default: lc_ctrl_pkg::Off
          inst_name: pinmux_aon
          end_idx: -1
          top_type: broadcast
          top_signame: pinmux_aon_pinmux_hw_debug_en
          index: -1
        }
        {
          name: lc_jtag
          desc: Qualified JTAG signals for life cycle controller TAP.
          struct: jtag
          package: jtag_pkg
          type: req_rsp
          act: req
          width: 1
          inst_name: pinmux_aon
          default: ""
          end_idx: -1
          top_signame: pinmux_aon_lc_jtag
          index: -1
        }
        {
          name: rv_jtag
          desc: Qualified JTAG signals for RISC-V processor TAP.
          struct: jtag
          package: jtag_pkg
          type: req_rsp
          act: req
          width: 1
          inst_name: pinmux_aon
          default: ""
          end_idx: -1
          top_signame: pinmux_aon_rv_jtag
          index: -1
        }
        {
          name: dft_jtag
          desc: Qualified JTAG signals for DFT TAP.
          struct: jtag
          package: jtag_pkg
          type: req_rsp
          act: req
          width: 1
          inst_name: pinmux_aon
          default: ""
          top_signame: pinmux_aon_dft_jtag
          index: -1
        }
        {
          name: dft_strap_test
          desc: Sampled DFT strap values, going to the DFT TAP.
          struct: dft_strap_test_req
          package: pinmux_pkg
          type: uni
          act: req
          width: 1
          default: "'0"
          inst_name: pinmux_aon
          external: true
          top_signame: dft_strap_test
          conn_type: false
          index: -1
        }
        {
          name: dft_hold_tap_sel
          desc: TAP selection hold indication, asserted by the DFT TAP during boundary scan.
          struct: logic
          type: uni
          act: rcv
          width: 1
          default: "'0"
          inst_name: pinmux_aon
          package: ""
          external: true
          top_signame: dft_hold_tap_sel
          conn_type: false
          index: -1
        }
        {
          name: sleep_en
          desc: Level signal that is asserted when the power manager enters sleep.
          struct: logic
          type: uni
          act: rcv
          width: 1
          default: 1'b0
          inst_name: pinmux_aon
          package: ""
          top_signame: pwrmgr_aon_low_power
          index: -1
        }
        {
          name: strap_en
          desc: This signal is pulsed high by the power manager after reset in order to sample the HW straps.
          struct: logic
          type: uni
          act: rcv
          width: 1
          default: 1'b0
          inst_name: pinmux_aon
          package: ""
          top_signame: pwrmgr_aon_strap
          index: -1
        }
        {
          name: strap_en_override
          desc:
            '''
            This signal transitions from 0 -> 1 by the lc_ctrl manager after volatile RAW_UNLOCK in order to re-sample the HW straps.
            The signal must stay at 1 until reset.
            Note that this is only used in test chips when SecVolatileRawUnlockEn = 1.
            Otherwise this signal is unused.
            '''
          struct: logic
          type: uni
          act: rcv
          width: 1
          default: 1'b0
          inst_name: pinmux_aon
          package: ""
          top_signame: lc_ctrl_strap_en_override
          index: -1
        }
        {
          name: pin_wkup_req
          desc: Wakeup request from wakeup detectors, to the power manager, running on the AON clock.
          struct: logic
          type: uni
          act: req
          width: 1
          default: 1'b0
          inst_name: pinmux_aon
          package: ""
          top_signame: pwrmgr_aon_wakeups
          index: 2
        }
        {
          name: usbdev_dppullup_en
          desc: Pullup enable signal coming from the USB IP.
          struct: logic
          type: uni
          act: rcv
          width: 1
          inst_name: pinmux_aon
          default: ""
          package: ""
          top_signame: usbdev_usb_dp_pullup
          index: -1
        }
        {
          name: usbdev_dnpullup_en
          desc: Pullup enable signal coming from the USB IP.
          struct: logic
          type: uni
          act: rcv
          width: 1
          inst_name: pinmux_aon
          default: ""
          package: ""
          top_signame: usbdev_usb_dn_pullup
          index: -1
        }
        {
          name: usb_dppullup_en
          desc: " Pullup enable signal going to USB PHY, needs to be maintained in low-power mode."
          struct: logic
          type: uni
          act: req
          width: 1
          default: 1'b0
          inst_name: pinmux_aon
          package: ""
          external: true
          top_signame: usb_dp_pullup_en
          conn_type: false
          index: -1
        }
        {
          name: usb_dnpullup_en
          desc: Pullup enable signal going to USB PHY, needs to be maintained in low-power mode.
          struct: logic
          type: uni
          act: req
          width: 1
          default: 1'b0
          inst_name: pinmux_aon
          package: ""
          external: true
          top_signame: usb_dn_pullup_en
          conn_type: false
          index: -1
        }
        {
          name: usb_wkup_req
          desc: Wakeup request from USB wakeup detector, going to the power manager, running on the AON clock.
          struct: logic
          type: uni
          act: req
          width: 1
          default: 1'b0
          inst_name: pinmux_aon
          package: ""
          top_signame: pwrmgr_aon_wakeups
          index: 3
        }
        {
          name: usbdev_suspend_req
          desc: Indicates whether USB is in suspended state, coming from the USB device.
          struct: logic
          type: uni
          act: rcv
          width: 1
          inst_name: pinmux_aon
          default: ""
          package: ""
          top_signame: usbdev_usb_aon_suspend_req
          index: -1
        }
        {
          name: usbdev_wake_ack
          desc: Acknowledges the USB wakeup request, coming from the USB device.
          struct: logic
          type: uni
          act: rcv
          width: 1
          inst_name: pinmux_aon
          default: ""
          package: ""
          top_signame: usbdev_usb_aon_wake_ack
          index: -1
        }
        {
          name: usbdev_bus_not_idle
          desc: Event signal that indicates that the USB was not idle while monitoring.
          struct: logic
          type: uni
          act: req
          width: 1
          default: 1'b0
          inst_name: pinmux_aon
          package: ""
          top_signame: usbdev_usb_aon_bus_not_idle
          index: -1
        }
        {
          name: usbdev_bus_reset
          desc: Event signal that indicates that the USB issued a Bus Reset while monitoring.
          struct: logic
          type: uni
          act: req
          width: 1
          default: 1'b0
          inst_name: pinmux_aon
          package: ""
          top_signame: usbdev_usb_aon_bus_reset
          index: -1
        }
        {
          name: usbdev_sense_lost
          desc: Event signal that indicates that USB SENSE signal was lost while monitoring.
          struct: logic
          type: uni
          act: req
          width: 1
          default: 1'b0
          inst_name: pinmux_aon
          package: ""
          top_signame: usbdev_usb_aon_sense_lost
          index: -1
        }
        {
          name: usbdev_wake_detect_active
          desc: State debug information.
          struct: logic
          type: uni
          act: req
          width: 1
          default: 1'b0
          inst_name: pinmux_aon
          package: ""
          end_idx: -1
          top_type: broadcast
          top_signame: pinmux_aon_usbdev_wake_detect_active
          index: -1
        }
        {
          name: tl
          struct: tl
          package: tlul_pkg
          type: req_rsp
          act: rsp
          width: 1
          inst_name: pinmux_aon
          default: ""
          end_idx: -1
          top_signame: pinmux_aon_tl
          index: -1
        }
      ]
      base_addrs:
      {
        null:
        {
          hart: 0x40460000
        }
      }
      generate_dif: true
    }
    {
      name: aon_timer_aon
      type: aon_timer
      clock_srcs:
      {
        clk_i: io_div4
        clk_aon_i: aon
      }
      clock_group: timers
      reset_connections:
      {
        rst_ni:
        {
          name: lc_io_div4
          domain: Aon
        }
        rst_aon_ni:
        {
          name: lc_aon
          domain: Aon
        }
      }
      domain:
      [
        Aon
      ]
      clock_connections:
      {
        clk_i: clkmgr_aon_clocks.clk_io_div4_timers
        clk_aon_i: clkmgr_aon_clocks.clk_aon_timers
      }
      param_decl: {}
      param_list: []
      inter_signal_list:
      [
        {
          name: nmi_wdog_timer_bark
          struct: logic
          type: uni
          act: req
          width: 1
          default: 1'b0
          inst_name: aon_timer_aon
          package: ""
          end_idx: -1
          top_type: broadcast
          top_signame: aon_timer_aon_nmi_wdog_timer_bark
          index: -1
        }
        {
          name: wkup_req
          struct: logic
          type: uni
          act: req
          width: 1
          default: 1'b0
          inst_name: aon_timer_aon
          package: ""
          top_signame: pwrmgr_aon_wakeups
          index: 4
        }
        {
          name: aon_timer_rst_req
          struct: logic
          type: uni
          act: req
          width: 1
          default: 1'b0
          inst_name: aon_timer_aon
          package: ""
          top_signame: pwrmgr_aon_rstreqs
          index: 1
        }
        {
          name: lc_escalate_en
          struct: lc_tx
          package: lc_ctrl_pkg
          type: uni
          act: rcv
          width: 1
          default: lc_ctrl_pkg::Off
          inst_name: aon_timer_aon
          top_signame: lc_ctrl_lc_escalate_en
          index: -1
        }
        {
          name: sleep_mode
          struct: logic
          type: uni
          act: rcv
          width: 1
          inst_name: aon_timer_aon
          default: ""
          package: ""
          top_signame: pwrmgr_aon_low_power
          index: -1
        }
        {
          name: racl_policies
          desc:
            '''
            Incoming RACL policy vector from a racl_ctrl instance.
            The policy selection vector (parameter) selects the policy for each register.
            '''
          struct: racl_policy_vec
          package: top_racl_pkg
          type: uni
          act: rcv
          width: 1
          inst_name: aon_timer_aon
          index: -1
        }
        {
          name: racl_error
          desc: RACL error log information of this module.
          struct: racl_error_log
          package: top_racl_pkg
          type: uni
          act: req
          width: 1
          inst_name: aon_timer_aon
          index: -1
        }
        {
          name: tl
          struct: tl
          package: tlul_pkg
          type: req_rsp
          act: rsp
          width: 1
          inst_name: aon_timer_aon
          default: ""
          end_idx: -1
          top_signame: aon_timer_aon_tl
          index: -1
        }
      ]
      base_addrs:
      {
        null:
        {
          hart: 0x40470000
        }
      }
      generate_dif: true
    }
    {
      name: ast
      type: ast
      clock_srcs:
      {
        clk_ast_tlul_i:
        {
          clock: io_div4
          group: infra
        }
        clk_ast_adc_i:
        {
          clock: aon
          group: peri
        }
        clk_ast_alert_i:
        {
          clock: io_div4
          group: secure
        }
        clk_ast_es_i:
        {
          clock: main
          group: secure
        }
        clk_ast_rng_i:
        {
          clock: main
          group: secure
        }
        clk_ast_usb_i:
        {
          clock: usb
          group: peri
        }
      }
      clock_group: secure
      reset_connections:
      {
        rst_ast_tlul_ni:
        {
          name: lc_io_div4
          domain: "0"
        }
        rst_ast_adc_ni:
        {
          name: lc_aon
          domain: Aon
        }
        rst_ast_alert_ni:
        {
          name: lc_io_div4
          domain: "0"
        }
        rst_ast_es_ni:
        {
          name: lc
          domain: "0"
        }
        rst_ast_rng_ni:
        {
          name: lc
          domain: "0"
        }
        rst_ast_usb_ni:
        {
          name: usb
          domain: "0"
        }
      }
      domain:
      [
        Aon
        "0"
      ]
      attr: reggen_only
      clock_connections:
      {
        clk_ast_tlul_i: clkmgr_aon_clocks.clk_io_div4_infra
        clk_ast_adc_i: clkmgr_aon_clocks.clk_aon_peri
        clk_ast_alert_i: clkmgr_aon_clocks.clk_io_div4_secure
        clk_ast_es_i: clkmgr_aon_clocks.clk_main_secure
        clk_ast_rng_i: clkmgr_aon_clocks.clk_main_secure
        clk_ast_usb_i: clkmgr_aon_clocks.clk_usb_peri
      }
      param_decl: {}
      param_list: []
      inter_signal_list:
      [
        {
          name: tl
          struct: tl
          package: tlul_pkg
          type: req_rsp
          act: rsp
          width: 1
          inst_name: ast
          index: -1
        }
      ]
      base_addrs:
      {
        null:
        {
          hart: 0x40480000
        }
      }
      generate_dif: true
    }
    {
      name: sensor_ctrl_aon
      type: sensor_ctrl
      clock_srcs:
      {
        clk_i: io_div4
        clk_aon_i: aon
      }
      clock_group: secure
      reset_connections:
      {
        rst_ni:
        {
          name: lc_io_div4
          domain: Aon
        }
        rst_aon_ni:
        {
          name: lc_aon
          domain: Aon
        }
      }
      domain:
      [
        Aon
      ]
      attr: reggen_top
      clock_connections:
      {
        clk_i: clkmgr_aon_clocks.clk_io_div4_secure
        clk_aon_i: clkmgr_aon_clocks.clk_aon_secure
      }
      param_decl: {}
      param_list: []
      inter_signal_list:
      [
        {
          name: ast_alert
          struct: ast_alert
          package: ast_pkg
          type: req_rsp
          act: rsp
          width: 1
          inst_name: sensor_ctrl_aon
          default: ""
          external: true
          top_signame: sensor_ctrl_ast_alert
          conn_type: false
          index: -1
        }
        {
          name: ast_status
          struct: ast_status
          package: ast_pkg
          type: uni
          act: rcv
          width: 1
          inst_name: sensor_ctrl_aon
          default: ""
          external: true
          top_signame: sensor_ctrl_ast_status
          conn_type: false
          index: -1
        }
        {
          name: ast_init_done
          struct: mubi4
          package: prim_mubi_pkg
          type: uni
          act: rcv
          width: 1
          default: prim_mubi_pkg::MuBi4True
          inst_name: sensor_ctrl_aon
          external: true
          top_signame: ast_init_done
          conn_type: false
          index: -1
        }
        {
          name: ast2pinmux
          struct: logic
          type: uni
          act: rcv
          width: 9
          inst_name: sensor_ctrl_aon
          default: ""
          package: ""
          external: true
          top_signame: ast2pinmux
          conn_type: false
          index: -1
        }
        {
          name: wkup_req
          struct: logic
          type: uni
          act: req
          width: 1
          inst_name: sensor_ctrl_aon
          default: ""
          package: ""
          top_signame: pwrmgr_aon_wakeups
          index: 5
        }
        {
          name: manual_pad_attr
          struct: pad_attr
          package: prim_pad_wrapper_pkg
          type: uni
          act: req
          width: 4
          default: "'0"
          inst_name: sensor_ctrl_aon
          external: true
          top_signame: sensor_ctrl_manual_pad_attr
          conn_type: false
          index: -1
        }
        {
          name: tl
          struct: tl
          package: tlul_pkg
          type: req_rsp
          act: rsp
          width: 1
          inst_name: sensor_ctrl_aon
          default: ""
          end_idx: -1
          top_signame: sensor_ctrl_aon_tl
          index: -1
        }
      ]
      base_addrs:
      {
        null:
        {
          hart: 0x40490000
        }
      }
      generate_dif: true
    }
    {
      name: sram_ctrl_ret_aon
      type: sram_ctrl
      clock_srcs:
      {
        clk_i: io_div4
        clk_otp_i: io_div4
      }
      clock_group: infra
      reset_connections:
      {
        rst_ni:
        {
          name: lc_io_div4
          domain: Aon
        }
        rst_otp_ni:
        {
          name: lc_io_div4
          domain: Aon
        }
      }
      domain:
      [
        Aon
      ]
      param_decl:
      {
        InstrExec: "0"
        InstSize: "4096"
      }
      base_addrs:
      {
        regs:
        {
          hart: 0x40500000
        }
        ram:
        {
          hart: 0x40600000
        }
      }
      memory:
      {
        ram:
        {
          label: ram_ret_aon
          swaccess: rw
          data_intg_passthru: "true"
          exec: True
          byte_write: True
          size: 0x1000
        }
      }
      clock_connections:
      {
        clk_i: clkmgr_aon_clocks.clk_io_div4_infra
        clk_otp_i: clkmgr_aon_clocks.clk_io_div4_infra
      }
      param_list:
      [
        {
          name: RndCnstSramKey
          desc: Compile-time random reset value for SRAM scrambling key.
          type: otp_ctrl_pkg::sram_key_t
          randcount: 128
          randtype: data
          name_top: RndCnstSramCtrlRetAonSramKey
          default: 0x46e4fecfda2375a6147421d8cb69d4f3
          randwidth: 128
        }
        {
          name: RndCnstSramNonce
          desc: Compile-time random reset value for SRAM scrambling nonce.
          type: otp_ctrl_pkg::sram_nonce_t
          randcount: 128
          randtype: data
          name_top: RndCnstSramCtrlRetAonSramNonce
          default: 0xa15faf834cad515d76bd37c7bec5f33f
          randwidth: 128
        }
        {
          name: RndCnstLfsrSeed
          desc: Compile-time random bits for initial LFSR seed
          type: sram_ctrl_pkg::lfsr_seed_t
          randcount: 32
          randtype: data
          name_top: RndCnstSramCtrlRetAonLfsrSeed
          default: 0xdca11a72
          randwidth: 32
        }
        {
          name: RndCnstLfsrPerm
          desc: Compile-time random permutation for LFSR output
          type: sram_ctrl_pkg::lfsr_perm_t
          randcount: 32
          randtype: perm
          name_top: RndCnstSramCtrlRetAonLfsrPerm
          default: 0x848bcb54640ebabb89f357fcc4a3386c5c73501b
          randwidth: 160
        }
        {
          name: MemSizeRam
          desc: Memory size of the RAM (in bytes).
          type: int
          name_top: MemSizeSramCtrlRetAonRam
          default: 4096
        }
        {
          name: InstSize
          desc: Memory size of a single RAM tile (in bytes).
          type: int
          default: "4096"
          local: "false"
          expose: "true"
          name_top: SramCtrlRetAonInstSize
        }
        {
          name: NumRamInst
          desc: Number of internal RAM instances. Must be the same as ceil(MemSizeRam / InstSize) .
          type: int
          default: 1
          local: "false"
          expose: "true"
          name_top: SramCtrlRetAonNumRamInst
        }
        {
          name: InstrExec
          desc: Support execution from SRAM
          type: bit
          default: "0"
          local: "false"
          expose: "true"
          name_top: SramCtrlRetAonInstrExec
        }
        {
          name: NumPrinceRoundsHalf
          desc: Number of PRINCE half rounds for the SRAM scrambling feature
          type: int
          default: "3"
          local: "false"
          expose: "true"
          name_top: SramCtrlRetAonNumPrinceRoundsHalf
        }
        {
          name: Outstanding
          desc: Number of outstanding TLUL transactions
          type: int
          default: "2"
          local: "true"
          expose: "true"
          name_top: SramCtrlRetAonOutstanding
        }
        {
          name: EccCorrection
          desc: Enable single-bit error correction and error logging
          type: bit
          default: "0"
          local: "false"
          expose: "true"
          name_top: SramCtrlRetAonEccCorrection
        }
      ]
      inter_signal_list:
      [
        {
          name: sram_otp_key
          struct: sram_otp_key
          package: otp_ctrl_pkg
          type: req_rsp
          act: req
          width: 1
          inst_name: sram_ctrl_ret_aon
          default: ""
          top_signame: otp_ctrl_sram_otp_key
          index: 1
        }
        {
          name: cfg
          struct: ram_1p_cfg
          package: prim_ram_1p_pkg
          type: uni
          act: rcv
          width:
          {
            name: NumRamInst
            desc: Number of internal RAM instances. Must be the same as ceil(MemSizeRam / InstSize) .
            param_type: int
            unpacked_dimensions: null
            default: 1
            local: false
            expose: true
            name_top: SramCtrlRetAonNumRamInst
          }
          default: "'0"
          inst_name: sram_ctrl_ret_aon
          external: true
          top_signame: sram_ctrl_ret_aon_cfg
          conn_type: false
          index: -1
        }
        {
          name: cfg_rsp
          struct: ram_1p_cfg_rsp
          package: prim_ram_1p_pkg
          type: uni
          act: req
          width:
          {
            name: NumRamInst
            desc: Number of internal RAM instances. Must be the same as ceil(MemSizeRam / InstSize) .
            param_type: int
            unpacked_dimensions: null
            default: 1
            local: false
            expose: true
            name_top: SramCtrlRetAonNumRamInst
          }
          default: "'0"
          inst_name: sram_ctrl_ret_aon
          index: -1
        }
        {
          name: lc_escalate_en
          struct: lc_tx
          package: lc_ctrl_pkg
          type: uni
          act: rcv
          width: 1
          default: lc_ctrl_pkg::Off
          inst_name: sram_ctrl_ret_aon
          top_signame: lc_ctrl_lc_escalate_en
          index: -1
        }
        {
          name: lc_hw_debug_en
          struct: lc_tx
          package: lc_ctrl_pkg
          type: uni
          act: rcv
          width: 1
          default: lc_ctrl_pkg::Off
          inst_name: sram_ctrl_ret_aon
          index: -1
        }
        {
          name: otp_en_sram_ifetch
          struct: mubi8
          package: prim_mubi_pkg
          type: uni
          act: rcv
          width: 1
          default: prim_mubi_pkg::MuBi8False
          inst_name: sram_ctrl_ret_aon
          index: -1
        }
        {
          name: racl_policies
          desc:
            '''
            Incoming RACL policy vector from a racl_ctrl instance.
            The policy selection vector (parameter) selects the policy for each register.
            '''
          struct: racl_policy_vec
          package: top_racl_pkg
          type: uni
          act: rcv
          width: 1
          inst_name: sram_ctrl_ret_aon
          index: -1
        }
        {
          name: racl_error
          desc: RACL error log information of this module.
          struct: racl_error_log
          package: top_racl_pkg
          type: uni
          act: req
          width: 1
          inst_name: sram_ctrl_ret_aon
          index: -1
        }
        {
          name: sram_rerror
          desc: SRAM read error indicating correctable and uncorrectable ECC errors.
          struct: sram_error_t
          package: sram_ctrl_pkg
          type: uni
          act: req
          width: 1
          inst_name: sram_ctrl_ret_aon
          index: -1
        }
        {
          name: regs_tl
          struct: tl
          package: tlul_pkg
          type: req_rsp
          act: rsp
          width: 1
          inst_name: sram_ctrl_ret_aon
          default: ""
          end_idx: -1
          top_signame: sram_ctrl_ret_aon_regs_tl
          index: -1
        }
        {
          name: ram_tl
          struct: tl
          package: tlul_pkg
          type: req_rsp
          act: rsp
          width: 1
          inst_name: sram_ctrl_ret_aon
          default: ""
          end_idx: -1
          top_signame: sram_ctrl_ret_aon_ram_tl
          index: -1
        }
      ]
      generate_dif: true
    }
    {
      name: flash_ctrl
      type: flash_ctrl
      template_type: flash_ctrl
      clock_srcs:
      {
        clk_i: main
        clk_otp_i: io_div4
      }
      clock_group: infra
      reset_connections:
      {
        rst_ni:
        {
          name: lc
          domain: "0"
        }
        rst_otp_ni:
        {
          name: lc_io_div4
          domain: "0"
        }
      }
      base_addrs:
      {
        core:
        {
          hart: 0x41000000
        }
        prim:
        {
          hart: 0x41008000
        }
        mem:
        {
          hart: 0x20000000
        }
      }
      param_decl:
      {
        ProgFifoDepth: "4"
      }
      memory:
      {
        mem:
        {
          label: eflash
          swaccess: ro
          data_intg_passthru: "true"
          exec: True
          byte_write: False
          config:
          {
            banks: 2
            pages_per_bank: 256
            program_resolution: 8
            pgm_resolution_bytes: 64
            bytes_per_page: 2048
            bytes_per_bank: 524288
            size: 0x100000
          }
          size: 0x100000
        }
      }
      attr: ipgen
      clock_connections:
      {
        clk_i: clkmgr_aon_clocks.clk_main_infra
        clk_otp_i: clkmgr_aon_clocks.clk_io_div4_infra
      }
      param_list:
      [
        {
          name: RndCnstAddrKey
          desc: Compile-time random bits for default address key
          type: flash_ctrl_pkg::flash_key_t
          randcount: 128
          randtype: data
          name_top: RndCnstFlashCtrlAddrKey
          default: 0xcd066336e9b0bdf6a55f0d23bb7dc0d
          randwidth: 128
        }
        {
          name: RndCnstDataKey
          desc: Compile-time random bits for default data key
          type: flash_ctrl_pkg::flash_key_t
          randcount: 128
          randtype: data
          name_top: RndCnstFlashCtrlDataKey
          default: 0xc524d3b0554603562188552794dd2beb
          randwidth: 128
        }
        {
          name: RndCnstAllSeeds
          desc: Compile-time random bits for default seeds
          type: flash_ctrl_top_specific_pkg::all_seeds_t
          randcount: 512
          randtype: data
          name_top: RndCnstFlashCtrlAllSeeds
          default: 0xf67f318b5a490e55f7d8b8325652a92482cc34468c37bfee731a0ab430181cde15f40d83472dd252e38f2c5e24d201bdb435d5cff95c40a1643cc8f540230522
          randwidth: 512
        }
        {
          name: RndCnstLfsrSeed
          desc: Compile-time random bits for initial LFSR seed
          type: flash_ctrl_top_specific_pkg::lfsr_seed_t
          randcount: 32
          randtype: data
          name_top: RndCnstFlashCtrlLfsrSeed
          default: 0xd33a4ea4
          randwidth: 32
        }
        {
          name: RndCnstLfsrPerm
          desc: Compile-time random permutation for LFSR output
          type: flash_ctrl_top_specific_pkg::lfsr_perm_t
          randcount: 32
          randtype: perm
          name_top: RndCnstFlashCtrlLfsrPerm
          default: 0xb16325f54d0ed9e31c04c3eb9d5f88127f41cdd0
          randwidth: 160
        }
        {
          name: SecScrambleEn
          desc: Compile-time option to enable flash scrambling
          type: bit
          default: "1"
          local: "false"
          expose: "true"
          name_top: SecFlashCtrlScrambleEn
        }
        {
          name: ProgFifoDepth
          desc: Depth of program fifo
          type: int
          default: "4"
          local: "false"
          expose: "true"
          name_top: FlashCtrlProgFifoDepth
        }
        {
          name: RdFifoDepth
          desc: Depth of read fifo
          type: int
          default: "16"
          local: "false"
          expose: "true"
          name_top: FlashCtrlRdFifoDepth
        }
      ]
      inter_signal_list:
      [
        {
          name: otp
          struct: flash_otp_key
          package: otp_ctrl_pkg
          type: req_rsp
          act: req
          width: 1
          inst_name: flash_ctrl
          default: ""
          end_idx: -1
          top_signame: flash_ctrl_otp
          index: -1
        }
        {
          name: lc_nvm_debug_en
          struct: lc_tx
          package: lc_ctrl_pkg
          type: uni
          act: rcv
          width: 1
          inst_name: flash_ctrl
          default: ""
          top_signame: lc_ctrl_lc_nvm_debug_en
          index: -1
        }
        {
          name: flash_bist_enable
          struct: mubi4
          package: prim_mubi_pkg
          type: uni
          act: rcv
          width: 1
          inst_name: flash_ctrl
          default: ""
          external: true
          top_signame: flash_bist_enable
          conn_type: false
          index: -1
        }
        {
          name: flash_power_down_h
          struct: logic
          type: uni
          act: rcv
          width: 1
          inst_name: flash_ctrl
          default: ""
          package: ""
          external: true
          top_signame: flash_power_down_h
          conn_type: false
          index: -1
        }
        {
          name: flash_power_ready_h
          struct: logic
          type: uni
          act: rcv
          width: 1
          inst_name: flash_ctrl
          default: ""
          package: ""
          external: true
          top_signame: flash_power_ready_h
          conn_type: false
          index: -1
        }
        {
          name: flash_test_mode_a
          struct: ""
          type: io
          act: none
          width: 2
          inst_name: flash_ctrl
          default: ""
          package: ""
          external: true
          top_signame: flash_test_mode_a
          conn_type: false
          index: -1
        }
        {
          name: flash_test_voltage_h
          struct: ""
          type: io
          act: none
          width: 1
          inst_name: flash_ctrl
          default: ""
          package: ""
          external: true
          top_signame: flash_test_voltage_h
          conn_type: false
          index: -1
        }
        {
          name: lc_creator_seed_sw_rw_en
          struct: lc_tx
          package: lc_ctrl_pkg
          type: uni
          act: rcv
          width: 1
          inst_name: flash_ctrl
          default: ""
          top_signame: lc_ctrl_lc_creator_seed_sw_rw_en
          index: -1
        }
        {
          name: lc_owner_seed_sw_rw_en
          struct: lc_tx
          package: lc_ctrl_pkg
          type: uni
          act: rcv
          width: 1
          inst_name: flash_ctrl
          default: ""
          top_signame: lc_ctrl_lc_owner_seed_sw_rw_en
          index: -1
        }
        {
          name: lc_iso_part_sw_rd_en
          struct: lc_tx
          package: lc_ctrl_pkg
          type: uni
          act: rcv
          width: 1
          inst_name: flash_ctrl
          default: ""
          top_signame: lc_ctrl_lc_iso_part_sw_rd_en
          index: -1
        }
        {
          name: lc_iso_part_sw_wr_en
          struct: lc_tx
          package: lc_ctrl_pkg
          type: uni
          act: rcv
          width: 1
          inst_name: flash_ctrl
          default: ""
          top_signame: lc_ctrl_lc_iso_part_sw_wr_en
          index: -1
        }
        {
          name: lc_seed_hw_rd_en
          struct: lc_tx
          package: lc_ctrl_pkg
          type: uni
          act: rcv
          width: 1
          inst_name: flash_ctrl
          default: ""
          top_signame: lc_ctrl_lc_seed_hw_rd_en
          index: -1
        }
        {
          name: lc_escalate_en
          struct: lc_tx
          package: lc_ctrl_pkg
          type: uni
          act: rcv
          width: 1
          inst_name: flash_ctrl
          default: ""
          top_signame: lc_ctrl_lc_escalate_en
          index: -1
        }
        {
          name: rma_req
          struct: lc_tx
          package: lc_ctrl_pkg
          type: uni
          act: rcv
          width: 1
          inst_name: flash_ctrl
          default: ""
          top_signame: lc_ctrl_lc_flash_rma_req
          index: -1
        }
        {
          name: rma_ack
          struct: lc_tx
          package: lc_ctrl_pkg
          type: uni
          act: req
          width: 1
          inst_name: flash_ctrl
          default: ""
          top_signame: lc_ctrl_lc_flash_rma_ack
          index: 0
        }
        {
          name: rma_seed
          struct: lc_flash_rma_seed
          package: lc_ctrl_pkg
          type: uni
          act: rcv
          width: 1
          inst_name: flash_ctrl
          default: ""
          end_idx: -1
          top_type: broadcast
          top_signame: flash_ctrl_rma_seed
          index: -1
        }
        {
          name: pwrmgr
          struct: pwr_flash
          package: pwrmgr_pkg
          type: uni
          act: req
          width: 1
          inst_name: flash_ctrl
          default: ""
          top_signame: pwrmgr_aon_pwr_flash
          index: -1
        }
        {
          name: keymgr
          struct: keymgr_flash
          package: flash_ctrl_pkg
          type: uni
          act: req
          width: 1
          inst_name: flash_ctrl
          default: ""
          end_idx: -1
          top_type: broadcast
          top_signame: flash_ctrl_keymgr
          index: -1
        }
        {
          name: obs_ctrl
          struct: ast_obs_ctrl
          package: ast_pkg
          type: uni
          act: rcv
          width: 1
          inst_name: flash_ctrl
          default: ""
          top_signame: ast_obs_ctrl
          index: -1
        }
        {
          name: fla_obs
          struct: logic
          type: uni
          act: req
          width: 8
          inst_name: flash_ctrl
          default: ""
          package: ""
          external: true
          top_signame: flash_obs
          conn_type: false
          index: -1
        }
        {
          name: core_tl
          struct: tl
          package: tlul_pkg
          type: req_rsp
          act: rsp
          width: 1
          inst_name: flash_ctrl
          default: ""
          end_idx: -1
          top_signame: flash_ctrl_core_tl
          index: -1
        }
        {
          name: prim_tl
          struct: tl
          package: tlul_pkg
          type: req_rsp
          act: rsp
          width: 1
          inst_name: flash_ctrl
          default: ""
          end_idx: -1
          top_signame: flash_ctrl_prim_tl
          index: -1
        }
        {
          name: mem_tl
          struct: tl
          package: tlul_pkg
          type: req_rsp
          act: rsp
          width: 1
          inst_name: flash_ctrl
          default: ""
          end_idx: -1
          top_signame: flash_ctrl_mem_tl
          index: -1
        }
      ]
      generate_dif: true
      domain:
      [
        "0"
      ]
    }
    {
      name: rv_dm
      type: rv_dm
      clock_srcs:
      {
        clk_i: main
        clk_lc_i: main
      }
      clock_group: infra
      reset_connections:
      {
        rst_ni:
        {
          name: sys
          domain: "0"
        }
        rst_lc_ni:
        {
          name: lc
          domain: "0"
        }
      }
      param_decl:
      {
        IdcodeValue: jtag_id_pkg::RV_DM_JTAG_IDCODE
      }
      base_addrs:
      {
        mem:
        {
          hart: 0x00010000
        }
        regs:
        {
          hart: 0x41200000
        }
        dbg:
        {
          hart: 0x00001000
        }
      }
      generate_dif: false
      clock_connections:
      {
        clk_i: clkmgr_aon_clocks.clk_main_infra
        clk_lc_i: clkmgr_aon_clocks.clk_main_infra
      }
      memory: {}
      param_list:
      [
        {
          name: IdcodeValue
          desc: RISC-V debug module JTAG ID code.
          type: logic [31:0]
          default: jtag_id_pkg::RV_DM_JTAG_IDCODE
          local: "false"
          expose: "true"
          name_top: RvDmIdcodeValue
        }
        {
          name: UseDmiInterface
          desc: When 1, a TLUL-based DMI interface is used. When 0, a JTAG TAP is used.
          type: bit
          default: "0"
          local: "false"
          expose: "true"
          name_top: RvDmUseDmiInterface
        }
        {
          name: SecVolatileRawUnlockEn
          desc:
            '''
            Disable (0) or enable (1) volatile RAW UNLOCK capability.
            If enabled, the strap_en_override_i input can be used to re-sample the straps at runtime.
            IMPORTANT NOTE: This should only be used in test chips. The parameter must be set
            to 0 in production tapeouts since this weakens the security posture of the RAW
            UNLOCK mechanism.
            '''
          type: bit
          default: 1'b0
          local: "false"
          expose: "true"
          name_top: SecRvDmVolatileRawUnlockEn
        }
        {
          name: TlulHostUserRsvdBits
          desc: TLUL user bits sent on outgoing transfers.
          type: logic [tlul_pkg::RsvdWidth-1:0]
          default: "'0"
          local: "false"
          expose: "true"
          name_top: RvDmTlulHostUserRsvdBits
        }
      ]
      inter_signal_list:
      [
        {
          name: next_dm_addr
          desc:
            '''
            32bit word address of the next debug module.
            Set to 0x0 if this is the last debug module in the chain.
            '''
          struct: next_dm_addr
          package: rv_dm_pkg
          type: uni
          act: rcv
          width: 1
          default: "'0"
          inst_name: rv_dm
          index: -1
        }
        {
          name: jtag
          desc: JTAG signals for the RISC-V TAP.
          struct: jtag
          package: jtag_pkg
          type: req_rsp
          act: rsp
          width: 1
          inst_name: rv_dm
          default: ""
          top_signame: pinmux_aon_rv_jtag
          index: -1
        }
        {
          name: lc_hw_debug_en
          desc:
            '''
            Multibit life cycle hardware debug enable signal coming from life cycle controller,
            asserted when the hardware debug mechanisms are enabled in the system.
            '''
          struct: lc_tx
          package: lc_ctrl_pkg
          type: uni
          act: rcv
          width: 1
          default: lc_ctrl_pkg::Off
          inst_name: rv_dm
          top_signame: lc_ctrl_lc_hw_debug_en
          index: -1
        }
        {
          name: lc_dft_en
          desc:
            '''
            Multibit life cycle hardware debug enable signal coming from life cycle controller,
            asserted when the DFT mechanisms are enabled in the system.
            '''
          struct: lc_tx
          package: lc_ctrl_pkg
          type: uni
          act: rcv
          width: 1
          default: lc_ctrl_pkg::Off
          inst_name: rv_dm
          top_signame: lc_ctrl_lc_dft_en
          index: -1
        }
        {
          name: pinmux_hw_debug_en
          desc:
            '''
            Multibit life cycle hardware debug enable signal coming from pinmux.
            This is a latched version of the lc_hw_debug_en signal and is only used to
            gate the JTAG / TAP side of the RV_DM. It is used to keep a debug session live
            while the rest of the system undergoes an NDM reset.
            '''
          struct: lc_tx
          package: lc_ctrl_pkg
          type: uni
          act: rcv
          width: 1
          default: lc_ctrl_pkg::Off
          inst_name: rv_dm
          top_signame: pinmux_aon_pinmux_hw_debug_en
          index: -1
        }
        {
          name: otp_dis_rv_dm_late_debug
          struct: mubi8
          package: prim_mubi_pkg
          type: uni
          act: rcv
          width: 1
          default: prim_mubi_pkg::MuBi8False
          inst_name: rv_dm
          top_signame: rv_dm_otp_dis_rv_dm_late_debug
          index: -1
        }
        {
          name: unavailable
          desc:
            '''
            This signal indicates to the debug module that the main processor is not available
            for debug (e.g. due to a low-power state).
            '''
          struct: logic
          type: uni
          act: rcv
          width: 1
          default: 1'b0
          inst_name: rv_dm
          index: -1
        }
        {
          name: ndmreset_req
          desc: Non-debug module reset request going to the system reset infrastructure.
          struct: logic
          type: uni
          act: req
          width: 1
          inst_name: rv_dm
          default: ""
          package: ""
          end_idx: -1
          top_type: broadcast
          top_signame: rv_dm_ndmreset_req
          index: -1
        }
        {
          name: dmactive
          desc:
            '''
            This signal indicates whether the debug module is active and can be used to prevent
            power down of the core and bus-attached peripherals.
            '''
          struct: logic
          type: uni
          act: req
          width: 1
          inst_name: rv_dm
          index: -1
        }
        {
          name: debug_req
          desc: This is the debug request interrupt going to the main processor.
          struct: logic [rv_dm_reg_pkg::NrHarts-1:0]
          type: uni
          act: req
          width: 1
          inst_name: rv_dm
          default: ""
          package: ""
          end_idx: -1
          top_type: broadcast
          top_signame: rv_dm_debug_req
          index: -1
        }
        {
          name: lc_escalate_en
          desc:
            '''
            Escalation enable signal coming from life cycle controller, used for invalidating
            the latched lc_hw_debug_en state inside the strap sampling logic.
            '''
          struct: lc_tx
          package: lc_ctrl_pkg
          type: uni
          act: rcv
          width: 1
          default: lc_ctrl_pkg::Off
          inst_name: rv_dm
          index: -1
        }
        {
          name: lc_check_byp_en
          desc:
            '''
            Check bypass enable signal coming from life cycle controller, used for invalidating
            the latched lc_hw_debug_en state inside the strap sampling logic. This signal is asserted
            whenever the life cycle controller performs a life cycle transition. Its main use is
            to skip any background checks inside the life cycle partition of the OTP controller while
            a life cycle transition is in progress.
            '''
          struct: lc_tx
          package: lc_ctrl_pkg
          type: uni
          act: rcv
          width: 1
          default: lc_ctrl_pkg::Off
          inst_name: rv_dm
          index: -1
        }
        {
          name: strap_en
          desc: This signal is pulsed high by the power manager after reset in order to sample the HW straps.
          struct: logic
          type: uni
          act: rcv
          width: 1
          default: 1'b0
          inst_name: rv_dm
          index: -1
        }
        {
          name: strap_en_override
          desc:
            '''
            This signal transitions from 0 -> 1 by the lc_ctrl manager after volatile RAW_UNLOCK in order to re-sample the HW straps.
            The signal must stay at 1 until reset.
            Note that this is only used in test chips when SecVolatileRawUnlockEn = 1.
            Otherwise this signal is unused.
            '''
          struct: logic
          type: uni
          act: rcv
          width: 1
          default: 1'b0
          inst_name: rv_dm
          index: -1
        }
        {
          name: racl_policies
          desc:
            '''
            Incoming RACL policy vector from a racl_ctrl instance.
            The policy selection vector (parameter) selects the policy for each register.
            '''
          struct: racl_policy_vec
          package: top_racl_pkg
          type: uni
          act: rcv
          width: 1
          inst_name: rv_dm
          index: -1
        }
        {
          name: racl_error
          desc: RACL error log information of this module.
          struct: racl_error_log
          package: top_racl_pkg
          type: uni
          act: req
          width: 1
          inst_name: rv_dm
          index: -1
        }
        {
          name: sba_tl_h
          struct: tl
          package: tlul_pkg
          type: req_rsp
          act: req
          width: 1
          inst_name: rv_dm
          default: ""
          top_signame: main_tl_rv_dm__sba
          index: -1
        }
        {
          name: regs_tl_d
          struct: tl
          package: tlul_pkg
          type: req_rsp
          act: rsp
          width: 1
          inst_name: rv_dm
          default: ""
          end_idx: -1
          top_signame: rv_dm_regs_tl_d
          index: -1
        }
        {
          name: mem_tl_d
          struct: tl
          package: tlul_pkg
          type: req_rsp
          act: rsp
          width: 1
          inst_name: rv_dm
          default: ""
          end_idx: -1
          top_signame: rv_dm_mem_tl_d
          index: -1
        }
        {
          name: dbg_tl_d
          struct: tl
          package: tlul_pkg
          type: req_rsp
          act: rsp
          width: 1
          inst_name: rv_dm
          index: -1
        }
      ]
      domain:
      [
        "0"
      ]
    }
    {
      name: rv_plic
      type: rv_plic
      template_type: rv_plic
      clock_srcs:
      {
        clk_i: main
      }
      clock_group: secure
      reset_connections:
      {
        rst_ni:
        {
          name: lc
          domain: "0"
        }
      }
      attr: ipgen
      clock_connections:
      {
        clk_i: clkmgr_aon_clocks.clk_main_secure
      }
      param_decl: {}
      param_list: []
      inter_signal_list:
      [
        {
          name: irq
          struct: logic
          type: uni
          act: req
          width: 1
          inst_name: rv_plic
          default: ""
          package: ""
          end_idx: -1
          top_type: broadcast
          top_signame: rv_plic_irq
          index: -1
        }
        {
          name: irq_id
          struct: logic
          type: uni
          act: req
          width: 1
          inst_name: rv_plic
          index: -1
        }
        {
          name: msip
          struct: logic
          type: uni
          act: req
          width: 1
          inst_name: rv_plic
          default: ""
          package: ""
          end_idx: -1
          top_type: broadcast
          top_signame: rv_plic_msip
          index: -1
        }
        {
          name: tl
          struct: tl
          package: tlul_pkg
          type: req_rsp
          act: rsp
          width: 1
          inst_name: rv_plic
          default: ""
          end_idx: -1
          top_signame: rv_plic_tl
          index: -1
        }
      ]
      base_addrs:
      {
        null:
        {
          hart: 0x48000000
        }
      }
      generate_dif: true
      domain:
      [
        "0"
      ]
    }
    {
      name: aes
      type: aes
      clock_srcs:
      {
        clk_i: main
        clk_edn_i: main
      }
      clock_group: trans
      reset_connections:
      {
        rst_ni:
        {
          name: lc
          domain: "0"
        }
        rst_edn_ni:
        {
          name: lc
          domain: "0"
        }
      }
      param_decl:
      {
        SecMasking: "1"
        SecSBoxImpl: aes_pkg::SBoxImplDom
      }
      clock_connections:
      {
        clk_i: clkmgr_aon_clocks.clk_main_aes
        clk_edn_i: clkmgr_aon_clocks.clk_main_aes
      }
      memory: {}
      param_list:
      [
        {
          name: AES192Enable
          desc: Disable (0) or enable (1) support for 192-bit key lengths (AES-192).
          type: bit
          default: 1'b1
          local: "false"
          expose: "false"
          name_top: AesAES192Enable
        }
        {
          name: SecMasking
          desc:
            '''
            Disable (0) or enable (1) first-order masking of the AES cipher core.
            Masking requires the use of a masked S-Box, see SecSBoxImpl parameter.
            '''
          type: bit
          default: "1"
          local: "false"
          expose: "true"
          name_top: SecAesMasking
        }
        {
          name: SecSBoxImpl
          desc: Selection of the S-Box implementation. See aes_pkg.sv.
          type: aes_pkg::sbox_impl_e
          default: aes_pkg::SBoxImplDom
          local: "false"
          expose: "true"
          name_top: SecAesSBoxImpl
        }
        {
          name: SecStartTriggerDelay
          desc:
            '''
            Manual start trigger delay, useful for SCA measurements.
            A value of e.g. 40 allows the processor to go into sleep before AES starts operation.
            '''
          type: int unsigned
          default: "0"
          local: "false"
          expose: "true"
          name_top: SecAesStartTriggerDelay
        }
        {
          name: SecAllowForcingMasks
          desc:
            '''
            Forbid (0) or allow (1) forcing the masking PRNG output to a constant value via FORCE_MASKS bit in the Auxiliary Control Register.
            Useful for SCA measurements.
            Meaningful only if masking is enabled.
            '''
          type: bit
          default: 1'b0
          local: "false"
          expose: "true"
          name_top: SecAesAllowForcingMasks
        }
        {
          name: SecSkipPRNGReseeding
          desc:
            '''
            Perform (0) or skip (1) PRNG reseeding requests, useful for SCA measurements only.
            The current SCA setup doesn't provide sufficient resources to implement the infrastructure required for PRNG reseeding (CSRNG, EDN).
            To enable SCA resistance evaluations, we need to skip reseeding requests on the SCA platform.
            '''
          type: bit
          default: 1'b0
          local: "false"
          expose: "true"
          name_top: SecAesSkipPRNGReseeding
        }
        {
          name: RndCnstClearingLfsrSeed
          desc: Default seed of the PRNG used for register clearing.
          type: aes_pkg::clearing_lfsr_seed_t
          randcount: 64
          randtype: data
          name_top: RndCnstAesClearingLfsrSeed
          default: 0x4922f7dc57cc668c
          randwidth: 64
        }
        {
          name: RndCnstClearingLfsrPerm
          desc: Permutation applied to the LFSR of the PRNG used for clearing.
          type: aes_pkg::clearing_lfsr_perm_t
          randcount: 64
          randtype: perm
          name_top: RndCnstAesClearingLfsrPerm
          default: 0x5d2732570001b22c5987ad3e90b08f80ae6f3b8babff36ea27b45fd9341af677b50c416d365623747a77a08306526f16
          randwidth: 384
        }
        {
          name: RndCnstClearingSharePerm
          desc: Permutation applied to the clearing PRNG output for clearing the second share of registers.
          type: aes_pkg::clearing_lfsr_perm_t
          randcount: 64
          randtype: perm
          name_top: RndCnstAesClearingSharePerm
          default: 0x386fa8411f6af130d92e9b5c863cb0c54916b17226009147bf88b694ab9e9dadf513b3606dd7c2d2b63fccc04f495eb9
          randwidth: 384
        }
        {
          name: RndCnstMaskingLfsrSeed
          desc: Default seed of the PRNG used for masking.
          type: aes_pkg::masking_lfsr_seed_t
          randcount: 288
          randtype: data
          name_top: RndCnstAesMaskingLfsrSeed
          default: 0x4660c443df8e6e3a14e92af0b0266dcd3de77d58929920453cedc4bb4632d2ee9d3b62da
          randwidth: 288
        }
        {
          name: RndCnstMaskingLfsrPerm
          desc: Permutation applied to the output of the PRNG used for masking.
          type: aes_pkg::masking_lfsr_perm_t
          randcount: 160
          randtype: perm
          name_top: RndCnstAesMaskingLfsrPerm
          default: 0x486579742011b2324800a7a7215902b345b2662581c0c510f680b9d4a1e389c1f6d5f070247307332431d33173620926778039e8c3d4d8f6b843b55897d0e967631747c19692e7e29915e631a8a4c3e2c5d9a4535853c139454496f834077226656166493600961055228755a2153952a442539795988128b3f5c829970379b7b8e816e117110184e4f146a2798506c3a008d4106088746652d0d2f9f4b7f48
          randwidth: 1280
        }
      ]
      inter_signal_list:
      [
        {
          name: idle
          struct: mubi4
          package: prim_mubi_pkg
          type: uni
          act: req
          width: 1
          inst_name: aes
          default: ""
          top_signame: clkmgr_aon_idle
          index: 0
        }
        {
          name: lc_escalate_en
          struct: lc_tx
          package: lc_ctrl_pkg
          type: uni
          act: rcv
          width: 1
          default: lc_ctrl_pkg::Off
          inst_name: aes
          top_signame: lc_ctrl_lc_escalate_en
          index: -1
        }
        {
          name: edn
          struct: edn
          package: edn_pkg
          type: req_rsp
          act: req
          width: 1
          inst_name: aes
          default: ""
          top_signame: edn0_edn
          index: 5
        }
        {
          name: keymgr_key
          struct: hw_key_req
          package: keymgr_pkg
          type: uni
          act: rcv
          width: 1
          inst_name: aes
          default: ""
          top_signame: keymgr_aes_key
          index: -1
        }
        {
          name: tl
          struct: tl
          package: tlul_pkg
          type: req_rsp
          act: rsp
          width: 1
          inst_name: aes
          default: ""
          end_idx: -1
          top_signame: aes_tl
          index: -1
        }
      ]
      base_addrs:
      {
        null:
        {
          hart: 0x41100000
        }
      }
      generate_dif: true
      domain:
      [
        "0"
      ]
    }
    {
      name: hmac
      type: hmac
      clock_srcs:
      {
        clk_i: main
      }
      clock_group: trans
      reset_connections:
      {
        rst_ni:
        {
          name: lc
          domain: "0"
        }
      }
      clock_connections:
      {
        clk_i: clkmgr_aon_clocks.clk_main_hmac
      }
      param_decl: {}
      param_list: []
      inter_signal_list:
      [
        {
          name: idle
          struct: mubi4
          package: prim_mubi_pkg
          type: uni
          act: req
          width: 1
          inst_name: hmac
          default: ""
          top_signame: clkmgr_aon_idle
          index: 1
        }
        {
          name: tl
          struct: tl
          package: tlul_pkg
          type: req_rsp
          act: rsp
          width: 1
          inst_name: hmac
          default: ""
          end_idx: -1
          top_signame: hmac_tl
          index: -1
        }
      ]
      base_addrs:
      {
        null:
        {
          hart: 0x41110000
        }
      }
      generate_dif: true
      domain:
      [
        "0"
      ]
    }
    {
      name: kmac
      type: kmac
      param_decl:
      {
        EnMasking: "1"
      }
      clock_srcs:
      {
        clk_i: main
        clk_edn_i: main
      }
      clock_group: trans
      reset_connections:
      {
        rst_ni:
        {
          name: lc
          domain: "0"
        }
        rst_edn_ni:
        {
          name: lc
          domain: "0"
        }
      }
      clock_connections:
      {
        clk_i: clkmgr_aon_clocks.clk_main_kmac
        clk_edn_i: clkmgr_aon_clocks.clk_main_kmac
      }
      memory: {}
      param_list:
      [
        {
          name: EnMasking
          desc: Disable(0) or enable(1) first-order masking of Keccak round.
          type: bit
          default: "1"
          local: "false"
          expose: "true"
          name_top: KmacEnMasking
        }
        {
          name: SwKeyMasked
          desc:
            '''
            Disable(0) or enable(1) software key masking in case masking is disabled (EnMasking == 0).
            If masking is enabled, this parameter has no effect.
            Mainly useful for software interface compatibility between the masked and unmasked design.
            Mostly relevant for SCA measurements.
            '''
          type: bit
          default: "0"
          local: "false"
          expose: "true"
          name_top: KmacSwKeyMasked
        }
        {
          name: SecCmdDelay
          desc:
            '''
            Command delay, useful for SCA measurements only.
            A value of e.g. 40 allows the processor to go into sleep before KMAC starts operation.
            If a value greater than 0 is chosen, software can pass two commands in series.
            The second command is buffered internally and will be presented to the hardware SecCmdDelay number of cycles after the first one.
            '''
          type: int
          default: "0"
          local: "false"
          expose: "true"
          name_top: SecKmacCmdDelay
        }
        {
          name: SecIdleAcceptSwMsg
          desc:
            '''
            If enabled (1), software writes to the message FIFO before having received a START command are not ignored.
            Disabled (0) by default.
            Useful for SCA measurements only.
            '''
          type: bit
          default: "0"
          local: "false"
          expose: "true"
          name_top: SecKmacIdleAcceptSwMsg
        }
        {
          name: NumAppIntf
          desc: Number of application interfaces
          type: int
          default: 3
          local: "false"
          expose: "true"
          name_top: KmacNumAppIntf
        }
        {
          name: AppCfg
          desc:
            '''
            Application interface configuration.
            Top-level connection to the application interface must follow this definition.
            '''
          type: kmac_pkg::app_config_t
          unpacked_dimensions: "[KmacNumAppIntf]"
          default: "'{kmac_pkg::AppCfgKeyMgr, kmac_pkg::AppCfgLcCtrl, kmac_pkg::AppCfgRomCtrl}"
          local: "false"
          expose: "true"
          name_top: KmacAppCfg
        }
        {
          name: RndCnstLfsrSeed
          desc: Compile-time random data for PRNG default seed
          type: kmac_pkg::lfsr_seed_t
          randcount: 288
          randtype: data
          name_top: RndCnstKmacLfsrSeed
          default: 0x4fe255b13d5003ae3828ee1a34f865c10b37a68df5d1293205f54724a965ab81ca6c3169
          randwidth: 288
        }
        {
          name: RndCnstLfsrPerm
          desc: Compile-time random permutation for PRNG output
          type: kmac_pkg::lfsr_perm_t
          randcount: 800
          randtype: perm
          name_top: RndCnstKmacLfsrPerm
          default: 0xa111496869a41cc0bf1badf1c3c4f89d1806dd5434eeb721ab6cb04035b8112ff4494614f0e622acb24f636e878961b92d2026e1fbdae2341255b2288ee7921d6585df741eb12b0b0b1098a4d6125f1e9ab15a59f1b72ee1e9017063e9591888de690e31af9c7b76325a4629cd5651e198cea1068d10041735c00635435bc83ac150bd20c49265abdf4c1c931ddb53198f332d531c355668b6599c60466439d111b02965fe516d33e9cd27d72a889517dde26ab54641c8f700a7ad78fe54611b3408a2c7d5747daa4a2770e1f530ceca6c29108a1b42bdaa5867240aa251a5448001acc4aa0b488361ccb32d4e409538c66884b490486f8336b64c9ee0d05544e517dab42303f71ad883a673fe354f5396edcb84496ba94f42ae09126f91579089d7924bdc35272fd93508542f8e55499775a3476d2c89e2c73d74a756a168b2474882999fac8211c97e2954c6a1046d15372ac57c8fc3d27da991cacc18554571d5c00f8e78c21340ecd121903f94819ec70c5766f0e2174030aa7a902725c050053052adba8aed46528d8192e32eb86746b2e41f69860871ed9baf783540098a87ad3b7e66bbe41eb9dfc904162e98b932db8d8745e987049af3d55da1830986df9b4da738ddbcc24a053404d36a0dc30444c848fb42e2e3387b7406d2a6e1136a470ae480d1bb99beb2094c06260566608e5bb3c0b1b0c08502c81c1b20aaa45d636b6cbc58339197b970ca1ba398106f42481526fe678519a47945a8f6300f7567c9280c216c09c03b6159bc417d434d837e188aa989a2764005e2770b85b14801a9c22ba24647160e0c2aa3961ffa44a7219b12e1f00e98922b185f2bf6555cb96206e5666467f90ae3804afb490c7f65d885ac4ae22589054d4ea561e8b39e11f5e5a80f93c0523c9c43b60213910c49235116da2aca3cc78c75a707711455e0a540947ab9825dc2eefb60c65666641866c105a10a0e82121d95ee93be485688e28db0a707c3994bb5b0f2dda24c4392d911bc108c32bb7910faa070b46ae4196027294579d3934eba69bfc0c405fec67ecee68c5b6683c5c6bc18ed91a1b6324debf21a538e11fc028b6f2316387768e15a15a4a710644a765d45dc5c3668052a8250526988f7321ef5e2e8534c4124d23f42b2d306b686a77cbc3083d7ccd5948326968c02092aad642b4070dcb1282c24e9e24dd6b93a1e266fa3525378eec660aab0c8f7693eb04e37a84f59ef111e7e2ba7504309192ed3a4d67e317305d889260a7d6e6084b039296f49e22d5b09d73bf5ec64a7ba16977164f1da556825e74aa75a2507a58a7e805234cf98f135d53c0118eb7a0f1647e6902e79c898e8438dd33841ae82a5fa655f4fc2d8162fbd6a5ab4718f0a44c31a82020372ef8a4454be78
          randwidth: 8000
        }
        {
          name: RndCnstBufferLfsrSeed
          desc: Compile-time random data for PRNG buffer default seed
          type: kmac_pkg::buffer_lfsr_seed_t
          randcount: 800
          randtype: data
          name_top: RndCnstKmacBufferLfsrSeed
          default: 0xb6396fce53002a2961ac84bdda1315add2f8a394a094c63c8af070919cd8b168cab6a734a2a92b34ba17c531911e20c1a496592784ac089e72877bdaf9f7954486164b58ea68f9b7f647cdafc1c9a905a7aa52efed17f8efa13e9543502f28c02c460aa8
          randwidth: 800
        }
        {
          name: RndCnstMsgPerm
          desc: Compile-time random permutation for LFSR Message output
          type: kmac_pkg::msg_perm_t
          randcount: 64
          randtype: perm
          name_top: RndCnstKmacMsgPerm
          default: 0x8cc0f8c760851b07167c7d4a3d3a9910042f637e4d24b960f95691cfa5de9e44a287b22cf4ea3f53c6c1af2b66b9da74
          randwidth: 384
        }
      ]
      inter_signal_list:
      [
        {
          name: keymgr_key
          struct: hw_key_req
          package: keymgr_pkg
          type: uni
          act: rcv
          width: 1
          inst_name: kmac
          default: ""
          top_signame: keymgr_kmac_key
          index: -1
        }
        {
          name: app
          struct: app
          package: kmac_pkg
          type: req_rsp
          act: rsp
          width:
          {
            name: NumAppIntf
            desc: Number of application interfaces
            param_type: int
            unpacked_dimensions: null
            default: 3
            local: false
            expose: true
            name_top: KmacNumAppIntf
          }
          inst_name: kmac
          default: ""
          end_idx: -1
          top_type: one-to-N
          top_signame: kmac_app
          index: -1
        }
        {
          name: entropy
          struct: edn
          package: edn_pkg
          type: req_rsp
          act: req
          width: 1
          inst_name: kmac
          default: ""
          top_signame: edn0_edn
          index: 3
        }
        {
          name: idle
          struct: mubi4
          package: prim_mubi_pkg
          type: uni
          act: req
          width: 1
          inst_name: kmac
          default: ""
          top_signame: clkmgr_aon_idle
          index: 2
        }
        {
          name: en_masking
          struct: logic
          type: uni
          act: req
          width: 1
          inst_name: kmac
          default: ""
          package: ""
          end_idx: -1
          top_type: broadcast
          top_signame: kmac_en_masking
          index: -1
        }
        {
          name: lc_escalate_en
          struct: lc_tx
          package: lc_ctrl_pkg
          type: uni
          act: rcv
          width: 1
          default: lc_ctrl_pkg::Off
          inst_name: kmac
          top_signame: lc_ctrl_lc_escalate_en
          index: -1
        }
        {
          name: tl
          struct: tl
          package: tlul_pkg
          type: req_rsp
          act: rsp
          width: 1
          inst_name: kmac
          default: ""
          end_idx: -1
          top_signame: kmac_tl
          index: -1
        }
      ]
      base_addrs:
      {
        null:
        {
          hart: 0x41120000
        }
      }
      generate_dif: true
      domain:
      [
        "0"
      ]
    }
    {
      name: otbn
      type: otbn
      clock_srcs:
      {
        clk_i:
        {
          clock: main
          group: trans
        }
        clk_edn_i:
        {
          clock: main
          group: secure
        }
        clk_otp_i:
        {
          clock: io_div4
          group: secure
        }
      }
      clock_group: trans
      reset_connections:
      {
        rst_ni:
        {
          name: lc
          domain: "0"
        }
        rst_edn_ni:
        {
          name: lc
          domain: "0"
        }
        rst_otp_ni:
        {
          name: lc_io_div4
          domain: "0"
        }
      }
      clock_connections:
      {
        clk_i: clkmgr_aon_clocks.clk_main_otbn
        clk_edn_i: clkmgr_aon_clocks.clk_main_secure
        clk_otp_i: clkmgr_aon_clocks.clk_io_div4_secure
      }
      param_decl: {}
      memory: {}
      param_list:
      [
        {
          name: Stub
          desc: Stub out the core of Otbn logic
          type: bit
          default: "0"
          local: "false"
          expose: "true"
          name_top: OtbnStub
        }
        {
          name: RegFile
          desc: Selection of the register file implementation. See otbn_pkg.sv.
          type: otbn_pkg::regfile_e
          default: otbn_pkg::RegFileFF
          local: "false"
          expose: "true"
          name_top: OtbnRegFile
        }
        {
          name: RndCnstUrndPrngSeed
          desc: Default seed of the PRNG used for URND.
          type: otbn_pkg::urnd_prng_seed_t
          randcount: 256
          randtype: data
          name_top: RndCnstOtbnUrndPrngSeed
          default: 0x88d40ccad7575333e5e48f00bbc1f91e5eea7ad029c213141ee86e77b99bf0a1
          randwidth: 256
        }
        {
          name: SecMuteUrnd
          desc:
            '''
            If enabled (1), URND is advanced only when data is needed.
            Disabled (0) by default.
            Useful for SCA measurements only.
            '''
          type: bit
          default: "0"
          local: "false"
          expose: "true"
          name_top: SecOtbnMuteUrnd
        }
        {
          name: SecSkipUrndReseedAtStart
          desc:
            '''
            If enabled (1), URND reseed is skipped at the start of an operation.
            Disabled (0) by default.
            Useful for SCA measurements only.
            '''
          type: bit
          default: "0"
          local: "false"
          expose: "true"
          name_top: SecOtbnSkipUrndReseedAtStart
        }
        {
          name: RndCnstOtbnKey
          desc: Compile-time random reset value for IMem/DMem scrambling key.
          type: otp_ctrl_pkg::otbn_key_t
          randcount: 128
          randtype: data
          name_top: RndCnstOtbnOtbnKey
          default: 0xbcd67fb8941c331a44277bc08f711d2d
          randwidth: 128
        }
        {
          name: RndCnstOtbnNonce
          desc: Compile-time random reset value for IMem/DMem scrambling nonce.
          type: otp_ctrl_pkg::otbn_nonce_t
          randcount: 64
          randtype: data
          name_top: RndCnstOtbnOtbnNonce
          default: 0x33e72bc40a36399d
          randwidth: 64
        }
      ]
      inter_signal_list:
      [
        {
          name: otbn_otp_key
          struct: otbn_otp_key
          package: otp_ctrl_pkg
          type: req_rsp
          act: req
          width: 1
          default: "'0"
          inst_name: otbn
          top_signame: otp_ctrl_otbn_otp_key
          index: -1
        }
        {
          name: edn_rnd
          struct: edn
          package: edn_pkg
          type: req_rsp
          act: req
          width: 1
          inst_name: otbn
          default: ""
          top_signame: edn1_edn
          index: 0
        }
        {
          name: edn_urnd
          struct: edn
          package: edn_pkg
          type: req_rsp
          act: req
          width: 1
          inst_name: otbn
          default: ""
          top_signame: edn0_edn
          index: 6
        }
        {
          name: idle
          struct: mubi4
          package: prim_mubi_pkg
          type: uni
          act: req
          width: 1
          inst_name: otbn
          default: ""
          top_signame: clkmgr_aon_idle
          index: 3
        }
        {
          name: ram_cfg_imem
          struct: ram_1p_cfg
          package: prim_ram_1p_pkg
          type: uni
          act: rcv
          width: 1
          inst_name: otbn
          default: ""
          top_signame: ast_ram_1p_cfg
          index: -1
        }
        {
          name: ram_cfg_dmem
          struct: ram_1p_cfg
          package: prim_ram_1p_pkg
          type: uni
          act: rcv
          width: 1
          inst_name: otbn
          default: ""
          top_signame: ast_ram_1p_cfg
          index: -1
        }
        {
          name: ram_cfg_rsp_imem
          struct: ram_1p_cfg_rsp
          package: prim_ram_1p_pkg
          type: uni
          act: req
          width: 1
          inst_name: otbn
          index: -1
        }
        {
          name: ram_cfg_rsp_dmem
          struct: ram_1p_cfg_rsp
          package: prim_ram_1p_pkg
          type: uni
          act: req
          width: 1
          inst_name: otbn
          index: -1
        }
        {
          name: lc_escalate_en
          struct: lc_tx
          package: lc_ctrl_pkg
          type: uni
          act: rcv
          width: 1
          default: lc_ctrl_pkg::Off
          inst_name: otbn
          top_signame: lc_ctrl_lc_escalate_en
          index: -1
        }
        {
          name: lc_rma_req
          struct: lc_tx
          package: lc_ctrl_pkg
          type: uni
          act: rcv
          width: 1
          default: lc_ctrl_pkg::Off
          inst_name: otbn
          top_signame: lc_ctrl_lc_flash_rma_req
          index: -1
        }
        {
          name: lc_rma_ack
          struct: lc_tx
          package: lc_ctrl_pkg
          type: uni
          act: req
          width: 1
          default: lc_ctrl_pkg::Off
          inst_name: otbn
          top_signame: lc_ctrl_lc_flash_rma_ack
          index: 1
        }
        {
          name: keymgr_key
          struct: otbn_key_req
          package: keymgr_pkg
          type: uni
          act: rcv
          width: 1
          inst_name: otbn
          default: ""
          top_signame: keymgr_otbn_key
          index: -1
        }
        {
          name: tl
          struct: tl
          package: tlul_pkg
          type: req_rsp
          act: rsp
          width: 1
          inst_name: otbn
          default: ""
          end_idx: -1
          top_signame: otbn_tl
          index: -1
        }
      ]
      base_addrs:
      {
        null:
        {
          hart: 0x41130000
        }
      }
      generate_dif: true
      domain:
      [
        "0"
      ]
    }
    {
      name: keymgr
      type: keymgr
      clock_srcs:
      {
        clk_i: main
        clk_edn_i: main
      }
      clock_group: secure
      reset_connections:
      {
        rst_ni:
        {
          name: lc
          domain: "0"
        }
        rst_edn_ni:
        {
          name: lc
          domain: "0"
        }
      }
      clock_connections:
      {
        clk_i: clkmgr_aon_clocks.clk_main_secure
        clk_edn_i: clkmgr_aon_clocks.clk_main_secure
      }
      param_decl: {}
      memory: {}
      param_list:
      [
        {
          name: UseOtpSeedsInsteadOfFlash
          desc:
            '''
            Flag indicating whether to use the creator / owner seeds provided
            via otp_key_i instead of the ones provided in flash_i. This option
            can be used in integrations where that do not have an embedded flash
            controller (in which case flash_i should just be tied off).
            '''
          type: bit
          default: "0"
          local: "false"
          expose: "true"
          name_top: KeymgrUseOtpSeedsInsteadOfFlash
        }
        {
          name: KmacEnMasking
          desc: Flag indicating with kmac masking is enabled
          type: bit
          default: "1"
          local: "false"
          expose: "true"
          name_top: KeymgrKmacEnMasking
        }
        {
          name: RndCnstLfsrSeed
          desc: Compile-time random bits for initial LFSR seed
          type: keymgr_pkg::lfsr_seed_t
          randcount: 64
          randtype: data
          name_top: RndCnstKeymgrLfsrSeed
          default: 0x8364dcd59508d525
          randwidth: 64
        }
        {
          name: RndCnstLfsrPerm
          desc: Compile-time random permutation for LFSR output
          type: keymgr_pkg::lfsr_perm_t
          randcount: 64
          randtype: perm
          name_top: RndCnstKeymgrLfsrPerm
          default: 0x30dc4f457678d15f06b4a0334e7243865c2c7e9e8553242ebe8efd482dea6c863976269e9ab1fed5c13f396da42e08c1
          randwidth: 384
        }
        {
          name: RndCnstRandPerm
          desc: Compile-time random permutation for entropy used in share overriding
          type: keymgr_pkg::rand_perm_t
          randcount: 32
          randtype: perm
          name_top: RndCnstKeymgrRandPerm
          default: 0xa1eddaca974af0044d9e1c6af0b1699295ff74c
          randwidth: 160
        }
        {
          name: RndCnstRevisionSeed
          desc: Compile-time random bits for revision seed
          type: keymgr_pkg::seed_t
          randcount: 256
          randtype: data
          name_top: RndCnstKeymgrRevisionSeed
          default: 0xcb1b851078c2a5f18eee28d0b562043b7312efad871f92e7527da865d661281f
          randwidth: 256
        }
        {
          name: RndCnstCreatorIdentitySeed
          desc: Compile-time random bits for creator identity seed
          type: keymgr_pkg::seed_t
          randcount: 256
          randtype: data
          name_top: RndCnstKeymgrCreatorIdentitySeed
          default: 0xe98dfcd72e3c6d150a85d63009596f7966c5c68caedde4ab7c65fb8d59618284
          randwidth: 256
        }
        {
          name: RndCnstOwnerIntIdentitySeed
          desc: Compile-time random bits for owner intermediate identity seed
          type: keymgr_pkg::seed_t
          randcount: 256
          randtype: data
          name_top: RndCnstKeymgrOwnerIntIdentitySeed
          default: 0x64d7194e4707ada81f8a6db14ca845beee60798289ad4fb0df1768296390152
          randwidth: 256
        }
        {
          name: RndCnstOwnerIdentitySeed
          desc: Compile-time random bits for owner identity seed
          type: keymgr_pkg::seed_t
          randcount: 256
          randtype: data
          name_top: RndCnstKeymgrOwnerIdentitySeed
          default: 0x700e078ec5a951b627cf2ccd155d84fdaced736e93362c8da83c5f4dd2093e4d
          randwidth: 256
        }
        {
          name: RndCnstSoftOutputSeed
          desc: Compile-time random bits for software generation seed
          type: keymgr_pkg::seed_t
          randcount: 256
          randtype: data
          name_top: RndCnstKeymgrSoftOutputSeed
          default: 0x2a70dd99dcf4ccac341a2f1a2704f5e21287fa168af251b370d034cda6051526
          randwidth: 256
        }
        {
          name: RndCnstHardOutputSeed
          desc: Compile-time random bits for hardware generation seed
          type: keymgr_pkg::seed_t
          randcount: 256
          randtype: data
          name_top: RndCnstKeymgrHardOutputSeed
          default: 0x62f4d11b3245d5943ea5fd2e4bea016b7911deaf01df742547371445d6e39551
          randwidth: 256
        }
        {
          name: RndCnstAesSeed
          desc: Compile-time random bits for generation seed when aes destination selected
          type: keymgr_pkg::seed_t
          randcount: 256
          randtype: data
          name_top: RndCnstKeymgrAesSeed
          default: 0x45e3074d9ca9e8a4ef06a6f14a5c8fcac0d6396e606a620a9ffb23756bda420a
          randwidth: 256
        }
        {
          name: RndCnstKmacSeed
          desc: Compile-time random bits for generation seed when kmac destination selected
          type: keymgr_pkg::seed_t
          randcount: 256
          randtype: data
          name_top: RndCnstKeymgrKmacSeed
          default: 0x9e7bd1a7c41e3a37b747d3d7b758b37d1d1ca19a079c48d7d4e67100a6aaebe4
          randwidth: 256
        }
        {
          name: RndCnstOtbnSeed
          desc: Compile-time random bits for generation seed when otbn destination selected
          type: keymgr_pkg::seed_t
          randcount: 256
          randtype: data
          name_top: RndCnstKeymgrOtbnSeed
          default: 0x5b6f09aefb72895ec90d876315db9ad8bbe63ecace31278da3acfc873ec5a228
          randwidth: 256
        }
        {
          name: RndCnstCdi
          desc: Compile-time random bits for generation seed when no CDI is selected
          type: keymgr_pkg::seed_t
          randcount: 256
          randtype: data
          name_top: RndCnstKeymgrCdi
          default: 0x29bd781efe2b4b06f4b349e0372b7394d415d937f3578cc1200dd1fb1d0ecf94
          randwidth: 256
        }
        {
          name: RndCnstNoneSeed
          desc: Compile-time random bits for generation seed when no destination selected
          type: keymgr_pkg::seed_t
          randcount: 256
          randtype: data
          name_top: RndCnstKeymgrNoneSeed
          default: 0x8594bc831c3e0e1f33c998cabd61dac609b5dd0e0c602aef2e932b1fb8fb631d
          randwidth: 256
        }
      ]
      inter_signal_list:
      [
        {
          name: edn
          struct: edn
          package: edn_pkg
          type: req_rsp
          act: req
          width: 1
          inst_name: keymgr
          default: ""
          top_signame: edn0_edn
          index: 0
        }
        {
          name: aes_key
          struct: hw_key_req
          package: keymgr_pkg
          type: uni
          act: req
          width: 1
          inst_name: keymgr
          default: ""
          end_idx: -1
          top_type: broadcast
          top_signame: keymgr_aes_key
          index: -1
        }
        {
          name: kmac_key
          struct: hw_key_req
          package: keymgr_pkg
          type: uni
          act: req
          width: 1
          inst_name: keymgr
          default: ""
          end_idx: -1
          top_type: broadcast
          top_signame: keymgr_kmac_key
          index: -1
        }
        {
          name: otbn_key
          struct: otbn_key_req
          package: keymgr_pkg
          type: uni
          act: req
          width: 1
          inst_name: keymgr
          default: ""
          end_idx: -1
          top_type: broadcast
          top_signame: keymgr_otbn_key
          index: -1
        }
        {
          name: kmac_data
          struct: app
          package: kmac_pkg
          type: req_rsp
          act: req
          width: 1
          inst_name: keymgr
          default: ""
          top_signame: kmac_app
          index: 0
        }
        {
          name: otp_key
          struct: otp_keymgr_key
          package: otp_ctrl_pkg
          type: uni
          act: rcv
          width: 1
          inst_name: keymgr
          default: ""
          top_signame: otp_ctrl_otp_keymgr_key
          index: -1
        }
        {
          name: otp_device_id
          struct: otp_device_id
          package: otp_ctrl_pkg
          type: uni
          act: rcv
          width: 1
          inst_name: keymgr
          default: ""
          top_signame: keymgr_otp_device_id
          index: -1
        }
        {
          name: flash
          struct: keymgr_flash
          package: flash_ctrl_pkg
          type: uni
          act: rcv
          width: 1
          inst_name: keymgr
          default: ""
          top_signame: flash_ctrl_keymgr
          index: -1
        }
        {
          name: lc_keymgr_en
          struct: lc_tx
          package: lc_ctrl_pkg
          type: uni
          act: rcv
          width: 1
          default: lc_ctrl_pkg::On
          inst_name: keymgr
          top_signame: lc_ctrl_lc_keymgr_en
          index: -1
        }
        {
          name: lc_keymgr_div
          struct: lc_keymgr_div
          package: lc_ctrl_pkg
          type: uni
          act: rcv
          width: 1
          inst_name: keymgr
          default: ""
          top_signame: lc_ctrl_lc_keymgr_div
          index: -1
        }
        {
          name: rom_digest
          struct: keymgr_data
          package: rom_ctrl_pkg
          type: uni
          act: rcv
          width: 1
          inst_name: keymgr
          default: ""
          top_signame: rom_ctrl_keymgr_data
          index: -1
        }
        {
          name: kmac_en_masking
          struct: logic
          type: uni
          act: rcv
          width: 1
          inst_name: keymgr
          default: ""
          package: ""
          top_signame: kmac_en_masking
          index: -1
        }
        {
          name: tl
          struct: tl
          package: tlul_pkg
          type: req_rsp
          act: rsp
          width: 1
          inst_name: keymgr
          default: ""
          end_idx: -1
          top_signame: keymgr_tl
          index: -1
        }
      ]
      base_addrs:
      {
        null:
        {
          hart: 0x41140000
        }
      }
      generate_dif: true
      domain:
      [
        "0"
      ]
    }
    {
      name: csrng
      type: csrng
      clock_srcs:
      {
        clk_i: main
      }
      clock_group: secure
      reset_connections:
      {
        rst_ni:
        {
          name: lc
          domain: "0"
        }
      }
      clock_connections:
      {
        clk_i: clkmgr_aon_clocks.clk_main_secure
      }
      param_decl: {}
      memory: {}
      param_list:
      [
        {
          name: RndCnstCsKeymgrDivNonProduction
          desc: Compile-time random bits for csrng state group diversification value
          type: csrng_pkg::cs_keymgr_div_t
          randcount: 384
          randtype: data
          name_top: RndCnstCsrngCsKeymgrDivNonProduction
          default: 0xd82de6c9adde7bfb79fb9cc4c0b2d1aed6700a44ea3e7e0610a663d52b082b9aef0e426df4866fe88a8baa3b3b2f5e39
          randwidth: 384
        }
        {
          name: RndCnstCsKeymgrDivProduction
          desc: Compile-time random bits for csrng state group diversification value
          type: csrng_pkg::cs_keymgr_div_t
          randcount: 384
          randtype: data
          name_top: RndCnstCsrngCsKeymgrDivProduction
          default: 0x17a7a7d4b5e53c38b3cedc40946cf3635f0c112f435205ef40d4b50cbd86b4932d75cebe7060738efa2035418082cfe9
          randwidth: 384
        }
        {
          name: SBoxImpl
          desc: Selection of the S-Box implementation. See aes_pkg.sv.
          type: aes_pkg::sbox_impl_e
          default: aes_pkg::SBoxImplCanright
          local: "false"
          expose: "true"
          name_top: CsrngSBoxImpl
        }
      ]
      inter_signal_list:
      [
        {
          name: csrng_cmd
          struct: csrng
          package: csrng_pkg
          type: req_rsp
          act: rsp
          width: 2
          inst_name: csrng
          default: ""
          end_idx: -1
          top_type: one-to-N
          top_signame: csrng_csrng_cmd
          index: -1
        }
        {
          name: entropy_src_hw_if
          struct: entropy_src_hw_if
          package: entropy_src_pkg
          type: req_rsp
          act: req
          width: 1
          inst_name: csrng
          default: ""
          end_idx: -1
          top_signame: csrng_entropy_src_hw_if
          index: -1
        }
        {
          name: cs_aes_halt
          desc:
            '''
            Coordinate activity between CSRNG's AES and Entropy Source's SHA3.
            When CSRNG gets a request and its AES is not active, it acknowledges and until the request has dropped neither runs its AES nor drops the acknowledge.
            '''
          struct: cs_aes_halt
          package: entropy_src_pkg
          type: req_rsp
          act: rsp
          width: 1
          inst_name: csrng
          default: ""
          end_idx: -1
          top_signame: csrng_cs_aes_halt
          index: -1
        }
        {
          name: otp_en_csrng_sw_app_read
          struct: mubi8
          package: prim_mubi_pkg
          type: uni
          act: rcv
          width: 1
          default: prim_mubi_pkg::MuBi8True
          inst_name: csrng
          top_signame: csrng_otp_en_csrng_sw_app_read
          index: -1
        }
        {
          name: lc_hw_debug_en
          struct: lc_tx
          package: lc_ctrl_pkg
          type: uni
          act: rcv
          width: 1
          default: lc_ctrl_pkg::Off
          inst_name: csrng
          top_signame: lc_ctrl_lc_hw_debug_en
          index: -1
        }
        {
          name: tl
          struct: tl
          package: tlul_pkg
          type: req_rsp
          act: rsp
          width: 1
          inst_name: csrng
          default: ""
          end_idx: -1
          top_signame: csrng_tl
          index: -1
        }
      ]
      base_addrs:
      {
        null:
        {
          hart: 0x41150000
        }
      }
      generate_dif: true
      domain:
      [
        "0"
      ]
    }
    {
      name: entropy_src
      type: entropy_src
      clock_srcs:
      {
        clk_i: main
      }
      clock_group: secure
      reset_connections:
      {
        rst_ni:
        {
          name: lc
          domain: "0"
        }
      }
      clock_connections:
      {
        clk_i: clkmgr_aon_clocks.clk_main_secure
      }
      param_decl: {}
      memory: {}
      param_list:
      [
        {
          name: EsFifoDepth
          desc: Number of 384-bit entries in the esfinal FIFO
          type: int
          default: "3"
          local: "false"
          expose: "true"
          name_top: EntropySrcEsFifoDepth
        }
        {
          name: DistrFifoDepth
          desc: Number of 32-bit entries in the distr FIFO
          type: int unsigned
          default: "2"
          local: "false"
          expose: "true"
          name_top: EntropySrcDistrFifoDepth
        }
        {
          name: Stub
          desc: Stub out the core of entropy_src logic
          type: bit
          default: "0"
          local: "false"
          expose: "true"
          name_top: EntropySrcStub
        }
      ]
      inter_signal_list:
      [
        {
          name: entropy_src_hw_if
          struct: entropy_src_hw_if
          package: entropy_src_pkg
          type: req_rsp
          act: rsp
          width: 1
          inst_name: entropy_src
          default: ""
          top_signame: csrng_entropy_src_hw_if
          index: -1
        }
        {
          name: cs_aes_halt
          desc:
            '''
            Coordinate activity between CSRNG's AES and Entropy Source's SHA3.
            The idea is that Entropy Source requests CSRNG's AES to halt and waits for CSRNG to acknowledge before it starts its SHA3.
            While SHA3 runs, Entropy Source keeps the request high.
            CSRNG may not drop the acknowledge before Entropy Source drops the request.
            '''
          struct: cs_aes_halt
          package: entropy_src_pkg
          type: req_rsp
          act: req
          width: 1
          inst_name: entropy_src
          default: ""
          top_signame: csrng_cs_aes_halt
          index: -1
        }
        {
          name: entropy_src_rng
          struct: entropy_src_rng
          package: entropy_src_pkg
          type: req_rsp
          act: req
          width: 1
          inst_name: entropy_src
          default: ""
          external: true
          top_signame: es_rng
          conn_type: false
          index: -1
        }
        {
          name: entropy_src_xht
          struct: entropy_src_xht
          package: entropy_src_pkg
          type: req_rsp
          act: req
          width: 1
          inst_name: entropy_src
          index: -1
        }
        {
          name: otp_en_entropy_src_fw_read
          struct: mubi8
          package: prim_mubi_pkg
          type: uni
          act: rcv
          width: 1
          default: prim_mubi_pkg::MuBi8True
          inst_name: entropy_src
          index: -1
        }
        {
          name: otp_en_entropy_src_fw_over
          struct: mubi8
          package: prim_mubi_pkg
          type: uni
          act: rcv
          width: 1
          default: prim_mubi_pkg::MuBi8True
          inst_name: entropy_src
          index: -1
        }
        {
          name: rng_fips
          struct: logic
          type: uni
          act: req
          width: 1
          inst_name: entropy_src
          default: ""
          package: ""
          external: true
          top_signame: es_rng_fips
          conn_type: false
          index: -1
        }
        {
          name: tl
          struct: tl
          package: tlul_pkg
          type: req_rsp
          act: rsp
          width: 1
          inst_name: entropy_src
          default: ""
          end_idx: -1
          top_signame: entropy_src_tl
          index: -1
        }
      ]
      base_addrs:
      {
        null:
        {
          hart: 0x41160000
        }
      }
      generate_dif: true
      domain:
      [
        "0"
      ]
    }
    {
      name: edn0
      type: edn
      clock_srcs:
      {
        clk_i: main
      }
      clock_group: secure
      reset_connections:
      {
        rst_ni:
        {
          name: lc
          domain: "0"
        }
      }
      clock_connections:
      {
        clk_i: clkmgr_aon_clocks.clk_main_secure
      }
      param_decl: {}
      param_list: []
      inter_signal_list:
      [
        {
          name: csrng_cmd
          desc: EDN supports a signal CSRNG application interface.
          struct: csrng
          package: csrng_pkg
          type: req_rsp
          act: req
          width: 1
          inst_name: edn0
          default: ""
          top_signame: csrng_csrng_cmd
          index: 0
        }
        {
          name: edn
          desc:
            '''
            The collection of peripheral ports supported by edn. The width (4)
            indicates the number of peripheral ports on a single instance.
            Due to limitations in the parametrization of top-level interconnects
            this value is not currently parameterizable.  However, the number
            of peripheral ports may change in a future revision.
            '''
          struct: edn
          package: edn_pkg
          type: req_rsp
          act: rsp
          width: 8
          default: "'0"
          inst_name: edn0
          end_idx: -1
          top_type: one-to-N
          top_signame: edn0_edn
          index: -1
        }
        {
          name: tl
          struct: tl
          package: tlul_pkg
          type: req_rsp
          act: rsp
          width: 1
          inst_name: edn0
          default: ""
          end_idx: -1
          top_signame: edn0_tl
          index: -1
        }
      ]
      base_addrs:
      {
        null:
        {
          hart: 0x41170000
        }
      }
      generate_dif: true
      domain:
      [
        "0"
      ]
    }
    {
      name: edn1
      type: edn
      clock_srcs:
      {
        clk_i: main
      }
      clock_group: secure
      reset_connections:
      {
        rst_ni:
        {
          name: lc
          domain: "0"
        }
      }
      clock_connections:
      {
        clk_i: clkmgr_aon_clocks.clk_main_secure
      }
      param_decl: {}
      param_list: []
      inter_signal_list:
      [
        {
          name: csrng_cmd
          desc: EDN supports a signal CSRNG application interface.
          struct: csrng
          package: csrng_pkg
          type: req_rsp
          act: req
          width: 1
          inst_name: edn1
          default: ""
          top_signame: csrng_csrng_cmd
          index: 1
        }
        {
          name: edn
          desc:
            '''
            The collection of peripheral ports supported by edn. The width (4)
            indicates the number of peripheral ports on a single instance.
            Due to limitations in the parametrization of top-level interconnects
            this value is not currently parameterizable.  However, the number
            of peripheral ports may change in a future revision.
            '''
          struct: edn
          package: edn_pkg
          type: req_rsp
          act: rsp
          width: 8
          default: "'0"
          inst_name: edn1
          end_idx: 1
          top_type: partial-one-to-N
          top_signame: edn1_edn
          index: -1
        }
        {
          name: tl
          struct: tl
          package: tlul_pkg
          type: req_rsp
          act: rsp
          width: 1
          inst_name: edn1
          default: ""
          end_idx: -1
          top_signame: edn1_tl
          index: -1
        }
      ]
      base_addrs:
      {
        null:
        {
          hart: 0x41180000
        }
      }
      generate_dif: true
      domain:
      [
        "0"
      ]
    }
    {
      name: sram_ctrl_main
      type: sram_ctrl
      clock_srcs:
      {
        clk_i: main
        clk_otp_i: io_div4
      }
      clock_group: infra
      reset_connections:
      {
        rst_ni:
        {
          name: lc
          domain: "0"
        }
        rst_otp_ni:
        {
          name: lc_io_div4
          domain: "0"
        }
      }
      param_decl:
      {
        InstrExec: "1"
        NumPrinceRoundsHalf: "2"
        InstSize: "131072"
      }
      base_addrs:
      {
        regs:
        {
          hart: 0x411C0000
        }
        ram:
        {
          hart: 0x10000000
        }
      }
      memory:
      {
        ram:
        {
          label: ram_main
          swaccess: rw
          data_intg_passthru: "true"
          exec: True
          byte_write: True
          size: 0x20000
        }
      }
      clock_connections:
      {
        clk_i: clkmgr_aon_clocks.clk_main_infra
        clk_otp_i: clkmgr_aon_clocks.clk_io_div4_infra
      }
      param_list:
      [
        {
          name: RndCnstSramKey
          desc: Compile-time random reset value for SRAM scrambling key.
          type: otp_ctrl_pkg::sram_key_t
          randcount: 128
          randtype: data
          name_top: RndCnstSramCtrlMainSramKey
          default: 0x6e5cc1280fbe2f2e323688bcc7ecbb1a
          randwidth: 128
        }
        {
          name: RndCnstSramNonce
          desc: Compile-time random reset value for SRAM scrambling nonce.
          type: otp_ctrl_pkg::sram_nonce_t
          randcount: 128
          randtype: data
          name_top: RndCnstSramCtrlMainSramNonce
          default: 0x7db7be4ccaf27d6eb83fd28156d9cb50
          randwidth: 128
        }
        {
          name: RndCnstLfsrSeed
          desc: Compile-time random bits for initial LFSR seed
          type: sram_ctrl_pkg::lfsr_seed_t
          randcount: 32
          randtype: data
          name_top: RndCnstSramCtrlMainLfsrSeed
          default: 0x75d6af4
          randwidth: 32
        }
        {
          name: RndCnstLfsrPerm
          desc: Compile-time random permutation for LFSR output
          type: sram_ctrl_pkg::lfsr_perm_t
          randcount: 32
          randtype: perm
          name_top: RndCnstSramCtrlMainLfsrPerm
          default: 0xad901d2e6dcc8e0a0b857260cde3fd229f11fae6
          randwidth: 160
        }
        {
          name: MemSizeRam
          desc: Memory size of the RAM (in bytes).
          type: int
          name_top: MemSizeSramCtrlMainRam
          default: 131072
        }
        {
          name: InstSize
          desc: Memory size of a single RAM tile (in bytes).
          type: int
          default: "131072"
          local: "false"
          expose: "true"
          name_top: SramCtrlMainInstSize
        }
        {
          name: NumRamInst
          desc: Number of internal RAM instances. Must be the same as ceil(MemSizeRam / InstSize) .
          type: int
          default: 1
          local: "false"
          expose: "true"
          name_top: SramCtrlMainNumRamInst
        }
        {
          name: InstrExec
          desc: Support execution from SRAM
          type: bit
          default: "1"
          local: "false"
          expose: "true"
          name_top: SramCtrlMainInstrExec
        }
        {
          name: NumPrinceRoundsHalf
          desc: Number of PRINCE half rounds for the SRAM scrambling feature
          type: int
          default: "2"
          local: "false"
          expose: "true"
          name_top: SramCtrlMainNumPrinceRoundsHalf
        }
        {
          name: Outstanding
          desc: Number of outstanding TLUL transactions
          type: int
          default: "2"
          local: "true"
          expose: "true"
          name_top: SramCtrlMainOutstanding
        }
        {
          name: EccCorrection
          desc: Enable single-bit error correction and error logging
          type: bit
          default: "0"
          local: "false"
          expose: "true"
          name_top: SramCtrlMainEccCorrection
        }
      ]
      inter_signal_list:
      [
        {
          name: sram_otp_key
          struct: sram_otp_key
          package: otp_ctrl_pkg
          type: req_rsp
          act: req
          width: 1
          inst_name: sram_ctrl_main
          default: ""
          top_signame: otp_ctrl_sram_otp_key
          index: 0
        }
        {
          name: cfg
          struct: ram_1p_cfg
          package: prim_ram_1p_pkg
          type: uni
          act: rcv
          width:
          {
            name: NumRamInst
            desc: Number of internal RAM instances. Must be the same as ceil(MemSizeRam / InstSize) .
            param_type: int
            unpacked_dimensions: null
            default: 1
            local: false
            expose: true
            name_top: SramCtrlMainNumRamInst
          }
          default: "'0"
          inst_name: sram_ctrl_main
          external: true
          top_signame: sram_ctrl_main_cfg
          conn_type: false
          index: -1
        }
        {
          name: cfg_rsp
          struct: ram_1p_cfg_rsp
          package: prim_ram_1p_pkg
          type: uni
          act: req
          width:
          {
            name: NumRamInst
            desc: Number of internal RAM instances. Must be the same as ceil(MemSizeRam / InstSize) .
            param_type: int
            unpacked_dimensions: null
            default: 1
            local: false
            expose: true
            name_top: SramCtrlMainNumRamInst
          }
          default: "'0"
          inst_name: sram_ctrl_main
          index: -1
        }
        {
          name: lc_escalate_en
          struct: lc_tx
          package: lc_ctrl_pkg
          type: uni
          act: rcv
          width: 1
          default: lc_ctrl_pkg::Off
          inst_name: sram_ctrl_main
          top_signame: lc_ctrl_lc_escalate_en
          index: -1
        }
        {
          name: lc_hw_debug_en
          struct: lc_tx
          package: lc_ctrl_pkg
          type: uni
          act: rcv
          width: 1
          default: lc_ctrl_pkg::Off
          inst_name: sram_ctrl_main
          top_signame: lc_ctrl_lc_hw_debug_en
          index: -1
        }
        {
          name: otp_en_sram_ifetch
          struct: mubi8
          package: prim_mubi_pkg
          type: uni
          act: rcv
          width: 1
          default: prim_mubi_pkg::MuBi8False
          inst_name: sram_ctrl_main
          top_signame: sram_ctrl_main_otp_en_sram_ifetch
          index: -1
        }
        {
          name: racl_policies
          desc:
            '''
            Incoming RACL policy vector from a racl_ctrl instance.
            The policy selection vector (parameter) selects the policy for each register.
            '''
          struct: racl_policy_vec
          package: top_racl_pkg
          type: uni
          act: rcv
          width: 1
          inst_name: sram_ctrl_main
          index: -1
        }
        {
          name: racl_error
          desc: RACL error log information of this module.
          struct: racl_error_log
          package: top_racl_pkg
          type: uni
          act: req
          width: 1
          inst_name: sram_ctrl_main
          index: -1
        }
        {
          name: sram_rerror
          desc: SRAM read error indicating correctable and uncorrectable ECC errors.
          struct: sram_error_t
          package: sram_ctrl_pkg
          type: uni
          act: req
          width: 1
          inst_name: sram_ctrl_main
          index: -1
        }
        {
          name: regs_tl
          struct: tl
          package: tlul_pkg
          type: req_rsp
          act: rsp
          width: 1
          inst_name: sram_ctrl_main
          default: ""
          end_idx: -1
          top_signame: sram_ctrl_main_regs_tl
          index: -1
        }
        {
          name: ram_tl
          struct: tl
          package: tlul_pkg
          type: req_rsp
          act: rsp
          width: 1
          inst_name: sram_ctrl_main
          default: ""
          end_idx: -1
          top_signame: sram_ctrl_main_ram_tl
          index: -1
        }
      ]
      generate_dif: true
      domain:
      [
        "0"
      ]
    }
    {
      name: rom_ctrl
      type: rom_ctrl
      clock_srcs:
      {
        clk_i: main
      }
      clock_group: infra
      reset_connections:
      {
        rst_ni:
        {
          name: lc
          domain: "0"
        }
      }
      base_addrs:
      {
        rom:
        {
          hart: 0x00008000
        }
        regs:
        {
          hart: 0x411e0000
        }
      }
      memory:
      {
        rom:
        {
          label: rom
          swaccess: ro
          data_intg_passthru: True
          exec: True
          byte_write: False
          size: 0x8000
        }
      }
      param_decl:
      {
        SecDisableScrambling: 1'b0
      }
      clock_connections:
      {
        clk_i: clkmgr_aon_clocks.clk_main_infra
      }
      param_list:
      [
        {
          name: BootRomInitFile
          desc: Contents of ROM
          type: ""
          default: '''""'''
          local: "false"
          expose: "true"
          name_top: RomCtrlBootRomInitFile
        }
        {
          name: RndCnstScrNonce
          desc: Fixed nonce used for address / data scrambling
          type: bit [63:0]
          randcount: 64
          randtype: data
          name_top: RndCnstRomCtrlScrNonce
          default: 0x2e6a22f5ad2e7591
          randwidth: 64
        }
        {
          name: RndCnstScrKey
          desc: Randomised constant used as a scrambling key for ROM data
          type: bit [127:0]
          randcount: 128
          randtype: data
          name_top: RndCnstRomCtrlScrKey
          default: 0xecad6cca220de3c0051a862508d4ce00
          randwidth: 128
        }
        {
          name: SecDisableScrambling
          desc:
            '''
            Disable scrambling and checking in rom_ctrl, turning the block into a
            simple ROM wrapper. This isn't intended for real chips, but is useful
            for small FPGA targets where there's not space for the PRINCE
            primitives.
            '''
          type: bit
          default: 1'b0
          local: "false"
          expose: "true"
          name_top: SecRomCtrlDisableScrambling
        }
        {
          name: MemSizeRom
          desc: Memory size of the ROM (in bytes).
          type: int
          name_top: MemSizeRomCtrlRom
          default: 32768
        }
      ]
      inter_signal_list:
      [
        {
          name: rom_cfg
          struct: rom_cfg
          package: prim_rom_pkg
          type: uni
          act: rcv
          width: 1
          inst_name: rom_ctrl
          default: ""
          top_signame: ast_rom_cfg
          index: -1
        }
        {
          name: pwrmgr_data
          struct: pwrmgr_data
          package: rom_ctrl_pkg
          type: uni
          act: req
          width: 1
          inst_name: rom_ctrl
          default: ""
          end_idx: -1
          top_type: broadcast
          top_signame: rom_ctrl_pwrmgr_data
          index: -1
        }
        {
          name: keymgr_data
          struct: keymgr_data
          package: rom_ctrl_pkg
          type: uni
          act: req
          width: 1
          inst_name: rom_ctrl
          default: ""
          end_idx: -1
          top_type: broadcast
          top_signame: rom_ctrl_keymgr_data
          index: -1
        }
        {
          name: kmac_data
          struct: app
          package: kmac_pkg
          type: req_rsp
          act: req
          width: 1
          inst_name: rom_ctrl
          default: ""
          top_signame: kmac_app
          index: 2
        }
        {
          name: regs_tl
          struct: tl
          package: tlul_pkg
          type: req_rsp
          act: rsp
          width: 1
          inst_name: rom_ctrl
          default: ""
          end_idx: -1
          top_signame: rom_ctrl_regs_tl
          index: -1
        }
        {
          name: rom_tl
          struct: tl
          package: tlul_pkg
          type: req_rsp
          act: rsp
          width: 1
          inst_name: rom_ctrl
          default: ""
          end_idx: -1
          top_signame: rom_ctrl_rom_tl
          index: -1
        }
      ]
      generate_dif: true
      domain:
      [
        "0"
      ]
    }
    {
      name: rv_core_ibex
      type: rv_core_ibex
      template_type: rv_core_ibex
      attr: ipgen
      ipgen_param:
      {
        NumRegions: 2
      }
      param_decl:
      {
        PMPEnable: "1"
        PMPGranularity: "0"
        PMPNumRegions: "16"
        MHPMCounterNum: "2"
        MHPMCounterWidth: "32"
        PMPRstCfg: ibex_pmp_reset_pkg::PmpCfgRst
        PMPRstAddr: ibex_pmp_reset_pkg::PmpAddrRst
        PMPRstMsecCfg: ibex_pmp_reset_pkg::PmpMseccfgRst
        RV32E: "0"
        RV32M: ibex_pkg::RV32MSingleCycle
        RV32B: ibex_pkg::RV32BOTEarlGrey
        RegFile: ibex_pkg::RegFileFF
        BranchTargetALU: "1"
        WritebackStage: "1"
        ICache: "1"
        ICacheECC: "1"
        ICacheScramble: "1"
        BranchPredictor: "0"
        DbgTriggerEn: "1"
        DbgHwBreakNum: "4"
        SecureIbex: "1"
        DmBaseAddr: tl_main_pkg::ADDR_SPACE_RV_DM__MEM
        DmAddrMask: tl_main_pkg::ADDR_MASK_RV_DM__MEM
        DmHaltAddr: tl_main_pkg::ADDR_SPACE_RV_DM__MEM + dm::HaltAddress[31:0]
        DmExceptionAddr: tl_main_pkg::ADDR_SPACE_RV_DM__MEM + dm::ExceptionAddress[31:0]
        PipeLine: "0"
        NEscalationSeverities: AlertHandlerEscNumSeverities
        WidthPingCounter: AlertHandlerEscPingCountWidth
      }
      clock_srcs:
      {
        clk_i: main
        clk_edn_i: main
        clk_esc_i:
        {
          clock: io_div4
          group: secure
        }
        clk_otp_i:
        {
          clock: io_div4
          group: secure
        }
      }
      clock_group: infra
      reset_connections:
      {
        rst_ni:
        {
          name: lc
          domain: "0"
        }
        rst_edn_ni:
        {
          name: lc
          domain: "0"
        }
        rst_esc_ni:
        {
          name: lc_io_div4
          domain: "0"
        }
        rst_otp_ni:
        {
          name: lc_io_div4
          domain: "0"
        }
      }
      clock_connections:
      {
        clk_i: clkmgr_aon_clocks.clk_main_infra
        clk_edn_i: clkmgr_aon_clocks.clk_main_infra
        clk_esc_i: clkmgr_aon_clocks.clk_io_div4_secure
        clk_otp_i: clkmgr_aon_clocks.clk_io_div4_secure
      }
      memory: {}
      param_list:
      [
        {
          name: RndCnstLfsrSeed
          desc: Default seed of the PRNG used for random instructions.
          type: ibex_pkg::lfsr_seed_t
          randcount: 32
          randtype: data
          name_top: RndCnstRvCoreIbexLfsrSeed
          default: 0x15f93767
          randwidth: 32
        }
        {
          name: RndCnstLfsrPerm
          desc: Permutation applied to the LFSR of the PRNG used for random instructions.
          type: ibex_pkg::lfsr_perm_t
          randcount: 32
          randtype: perm
          name_top: RndCnstRvCoreIbexLfsrPerm
          default: 0x439bd600f9899f5f7d258135bb4b145ab8198ae3
          randwidth: 160
        }
        {
          name: RndCnstIbexKeyDefault
          desc: Default icache scrambling key
          type: logic [ibex_pkg::SCRAMBLE_KEY_W-1:0]
          randcount: 128
          randtype: data
          name_top: RndCnstRvCoreIbexIbexKeyDefault
          default: 0x380023c25c3deaf38d871a3c5213602c
          randwidth: 128
        }
        {
          name: RndCnstIbexNonceDefault
          desc: Default icache scrambling nonce
          type: logic [ibex_pkg::SCRAMBLE_NONCE_W-1:0]
          randcount: 64
          randtype: data
          name_top: RndCnstRvCoreIbexIbexNonceDefault
          default: 0x32e73d3051db61b7
          randwidth: 64
        }
        {
          name: NEscalationSeverities
          desc: Number of escalation severities
          type: int unsigned
          default: AlertHandlerEscNumSeverities
          local: "false"
          expose: "false"
          name_top: RvCoreIbexNEscalationSeverities
        }
        {
          name: WidthPingCounter
          desc: Width of the ping counter
          type: int unsigned
          default: AlertHandlerEscPingCountWidth
          local: "false"
          expose: "false"
          name_top: RvCoreIbexWidthPingCounter
        }
        {
          name: PMPEnable
          desc: Enable PMP
          type: bit
          default: "1"
          local: "false"
          expose: "true"
          name_top: RvCoreIbexPMPEnable
        }
        {
          name: PMPGranularity
          desc: PMP Granularity
          type: int unsigned
          default: "0"
          local: "false"
          expose: "true"
          name_top: RvCoreIbexPMPGranularity
        }
        {
          name: PMPNumRegions
          desc: PMP number of regions
          type: int unsigned
          default: "16"
          local: "false"
          expose: "true"
          name_top: RvCoreIbexPMPNumRegions
        }
        {
          name: MHPMCounterNum
          desc: "Number of the MHPM counter "
          type: int unsigned
          default: "2"
          local: "false"
          expose: "true"
          name_top: RvCoreIbexMHPMCounterNum
        }
        {
          name: MHPMCounterWidth
          desc: "Width of the MHPM Counter "
          type: int unsigned
          default: "32"
          local: "false"
          expose: "true"
          name_top: RvCoreIbexMHPMCounterWidth
        }
        {
          name: PMPRstCfg
          desc: Reset value of PMP config CSRs
          type: ibex_pkg::pmp_cfg_t
          unpacked_dimensions: "[16]"
          default: ibex_pmp_reset_pkg::PmpCfgRst
          local: "false"
          expose: "true"
          name_top: RvCoreIbexPMPRstCfg
        }
        {
          name: PMPRstAddr
          desc: Reset value of PMP address CSRs
          type: logic [33:0]
          unpacked_dimensions: "[16]"
          default: ibex_pmp_reset_pkg::PmpAddrRst
          local: "false"
          expose: "true"
          name_top: RvCoreIbexPMPRstAddr
        }
        {
          name: PMPRstMsecCfg
          desc: Reset value of MSECCFG CSR
          type: ibex_pkg::pmp_mseccfg_t
          default: ibex_pmp_reset_pkg::PmpMseccfgRst
          local: "false"
          expose: "true"
          name_top: RvCoreIbexPMPRstMsecCfg
        }
        {
          name: RV32E
          desc: RV32E
          type: bit
          default: "0"
          local: "false"
          expose: "true"
          name_top: RvCoreIbexRV32E
        }
        {
          name: RV32M
          desc: RV32M
          type: ibex_pkg::rv32m_e
          default: ibex_pkg::RV32MSingleCycle
          local: "false"
          expose: "true"
          name_top: RvCoreIbexRV32M
        }
        {
          name: RV32B
          desc: RV32B
          type: ibex_pkg::rv32b_e
          default: ibex_pkg::RV32BOTEarlGrey
          local: "false"
          expose: "true"
          name_top: RvCoreIbexRV32B
        }
        {
          name: RegFile
          desc: Reg file
          type: ibex_pkg::regfile_e
          default: ibex_pkg::RegFileFF
          local: "false"
          expose: "true"
          name_top: RvCoreIbexRegFile
        }
        {
          name: BranchTargetALU
          desc: Branch target ALU
          type: bit
          default: "1"
          local: "false"
          expose: "true"
          name_top: RvCoreIbexBranchTargetALU
        }
        {
          name: WritebackStage
          desc: Write back stage
          type: bit
          default: "1"
          local: "false"
          expose: "true"
          name_top: RvCoreIbexWritebackStage
        }
        {
          name: ICache
          desc: Instruction cache
          type: bit
          default: "1"
          local: "false"
          expose: "true"
          name_top: RvCoreIbexICache
        }
        {
          name: ICacheECC
          desc: Instruction cache ECC
          type: bit
          default: "1"
          local: "false"
          expose: "true"
          name_top: RvCoreIbexICacheECC
        }
        {
          name: ICacheScramble
          desc: Scramble instruction cach
          type: bit
          default: "1"
          local: "false"
          expose: "true"
          name_top: RvCoreIbexICacheScramble
        }
        {
          name: ICacheNWays
          desc: Number of instruction cache ways
          type: int unsigned
          default: 2
          local: "false"
          expose: "true"
          name_top: RvCoreIbexICacheNWays
        }
        {
          name: BranchPredictor
          desc: Branch predictor
          type: bit
          default: "0"
          local: "false"
          expose: "true"
          name_top: RvCoreIbexBranchPredictor
        }
        {
          name: DbgTriggerEn
          desc: Enable degug trigger
          type: bit
          default: "1"
          local: "false"
          expose: "true"
          name_top: RvCoreIbexDbgTriggerEn
        }
        {
          name: DbgHwBreakNum
          desc: Number of debug hardware break
          type: int
          default: "4"
          local: "false"
          expose: "true"
          name_top: RvCoreIbexDbgHwBreakNum
        }
        {
          name: SecureIbex
          desc: "Width of the MHPM Counter "
          type: bit
          default: "1"
          local: "false"
          expose: "true"
          name_top: RvCoreIbexSecureIbex
        }
        {
          name: DmBaseAddr
          desc: Base address of Debug Module
          type: int unsigned
          default: tl_main_pkg::ADDR_SPACE_RV_DM__MEM
          local: "false"
          expose: "true"
          name_top: RvCoreIbexDmBaseAddr
        }
        {
          name: DmAddrMask
          desc: Adress mask of Debug Module
          type: int unsigned
          default: tl_main_pkg::ADDR_MASK_RV_DM__MEM
          local: "false"
          expose: "true"
          name_top: RvCoreIbexDmAddrMask
        }
        {
          name: DmHaltAddr
          desc: Halt address
          type: int unsigned
          default: tl_main_pkg::ADDR_SPACE_RV_DM__MEM + dm::HaltAddress[31:0]
          local: "false"
          expose: "true"
          name_top: RvCoreIbexDmHaltAddr
        }
        {
          name: DmExceptionAddr
          desc: Exception address
          type: int unsigned
          default: tl_main_pkg::ADDR_SPACE_RV_DM__MEM + dm::ExceptionAddress[31:0]
          local: "false"
          expose: "true"
          name_top: RvCoreIbexDmExceptionAddr
        }
        {
          name: PipeLine
          desc: Pipe line
          type: bit
          default: "0"
          local: "false"
          expose: "true"
          name_top: RvCoreIbexPipeLine
        }
        {
          name: TlulHostUserRsvdBits
          desc: TLUL user bits sent on outgoing transfers.
          type: logic [tlul_pkg::RsvdWidth-1:0]
          default: "'0"
          local: "false"
          expose: "true"
          name_top: RvCoreIbexTlulHostUserRsvdBits
        }
        {
          name: CsrMvendorId
          desc:
            '''
            mvendorid: encoding of manufacturer/provider
            0 indicates this field is not implemented.
            Ibex implementors may wish to set their own JEDEC ID here.
            '''
          type: logic [31:0]
          default: "'0"
          local: "false"
          expose: "true"
          name_top: RvCoreIbexCsrMvendorId
        }
        {
          name: CsrMimpId
          desc:
            '''
            mimpid: encoding of processor implementation version
            0 indicates this field is not implemented.
            Ibex implementors may wish to indicate an RTL/netlist version here using their own unique encoding (e.g. 32 bits of the git hash of the implemented commit).
            '''
          type: logic [31:0]
          default: "'0"
          local: "false"
          expose: "true"
          name_top: RvCoreIbexCsrMimpId
        }
      ]
      inter_signal_list:
      [
        {
          name: rst_cpu_n
          struct: logic
          type: uni
          act: req
          width: 1
          inst_name: rv_core_ibex
          index: -1
        }
        {
          name: ram_cfg_icache_tag
          struct: ram_1p_cfg
          package: prim_ram_1p_pkg
          type: uni
          act: rcv
          width: 1
          inst_name: rv_core_ibex
          default: ""
          top_signame: ast_ram_1p_cfg
          index: -1
        }
        {
          name: ram_cfg_rsp_icache_tag
          struct: ram_1p_cfg_rsp
          package: prim_ram_1p_pkg
          type: uni
          act: req
          width:
          {
            name: ICacheNWays
            desc: Number of instruction cache ways
            param_type: int unsigned
            unpacked_dimensions: null
            default: 2
            local: false
            expose: true
            name_top: RvCoreIbexICacheNWays
          }
          inst_name: rv_core_ibex
          index: -1
        }
        {
          name: ram_cfg_icache_data
          struct: ram_1p_cfg
          package: prim_ram_1p_pkg
          type: uni
          act: rcv
          width: 1
          inst_name: rv_core_ibex
          default: ""
          top_signame: ast_ram_1p_cfg
          index: -1
        }
        {
          name: ram_cfg_rsp_icache_data
          struct: ram_1p_cfg_rsp
          package: prim_ram_1p_pkg
          type: uni
          act: req
          width:
          {
            name: ICacheNWays
            desc: Number of instruction cache ways
            param_type: int unsigned
            unpacked_dimensions: null
            default: 2
            local: false
            expose: true
            name_top: RvCoreIbexICacheNWays
          }
          inst_name: rv_core_ibex
          index: -1
        }
        {
          name: hart_id
          struct: logic
          type: uni
          act: rcv
          width: 32
          inst_name: rv_core_ibex
          default: ""
          package: ""
          top_signame: rv_core_ibex_hart_id
          index: -1
        }
        {
          name: boot_addr
          struct: logic
          type: uni
          act: rcv
          width: 32
          inst_name: rv_core_ibex
          default: ""
          package: ""
          top_signame: rv_core_ibex_boot_addr
          index: -1
        }
        {
          name: irq_software
          struct: logic
          type: uni
          act: rcv
          width: 1
          inst_name: rv_core_ibex
          default: ""
          package: ""
          top_signame: rv_plic_msip
          index: -1
        }
        {
          name: irq_timer
          struct: logic
          type: uni
          act: rcv
          width: 1
          inst_name: rv_core_ibex
          default: ""
          package: ""
          top_signame: rv_core_ibex_irq_timer
          index: -1
        }
        {
          name: irq_external
          struct: logic
          type: uni
          act: rcv
          width: 1
          inst_name: rv_core_ibex
          default: ""
          package: ""
          top_signame: rv_plic_irq
          index: -1
        }
        {
          name: esc_tx
          struct: esc_tx
          package: prim_esc_pkg
          type: uni
          act: rcv
          width: 1
          inst_name: rv_core_ibex
          default: ""
          top_signame: alert_handler_esc_tx
          index: 0
        }
        {
          name: esc_rx
          struct: esc_rx
          package: prim_esc_pkg
          type: uni
          act: req
          width: 1
          inst_name: rv_core_ibex
          default: ""
          top_signame: alert_handler_esc_rx
          index: 0
        }
        {
          name: debug_req
          struct: logic
          type: uni
          act: rcv
          width: 1
          inst_name: rv_core_ibex
          default: ""
          package: ""
          top_signame: rv_dm_debug_req
          index: -1
        }
        {
          name: crash_dump
          struct: cpu_crash_dump
          package: rv_core_ibex_pkg
          type: uni
          act: req
          width: 1
          inst_name: rv_core_ibex
          default: ""
          end_idx: -1
          top_type: broadcast
          top_signame: rv_core_ibex_crash_dump
          index: -1
        }
        {
          name: lc_cpu_en
          struct: lc_tx
          package: lc_ctrl_pkg
          type: uni
          act: rcv
          width: 1
          inst_name: rv_core_ibex
          default: ""
          top_signame: lc_ctrl_lc_cpu_en
          index: -1
        }
        {
          name: pwrmgr_cpu_en
          struct: lc_tx
          package: lc_ctrl_pkg
          type: uni
          act: rcv
          width: 1
          inst_name: rv_core_ibex
          default: ""
          top_signame: pwrmgr_aon_fetch_en
          index: -1
        }
        {
          name: pwrmgr
          struct: cpu_pwrmgr
          package: rv_core_ibex_pkg
          type: uni
          act: req
          width: 1
          inst_name: rv_core_ibex
          default: ""
          end_idx: -1
          top_type: broadcast
          top_signame: rv_core_ibex_pwrmgr
          index: -1
        }
        {
          name: nmi_wdog
          struct: logic
          type: uni
          act: rcv
          width: 1
          inst_name: rv_core_ibex
          default: ""
          package: ""
          top_signame: aon_timer_aon_nmi_wdog_timer_bark
          index: -1
        }
        {
          name: edn
          struct: edn
          package: edn_pkg
          type: req_rsp
          act: req
          width: 1
          inst_name: rv_core_ibex
          default: ""
          top_signame: edn0_edn
          index: 7
        }
        {
          name: icache_otp_key
          struct: sram_otp_key
          package: otp_ctrl_pkg
          type: req_rsp
          act: req
          width: 1
          inst_name: rv_core_ibex
          default: ""
          top_signame: otp_ctrl_sram_otp_key
          index: 2
        }
        {
          name: fpga_info
          struct: logic
          type: uni
          act: rcv
          width: 32
          inst_name: rv_core_ibex
          default: ""
          package: ""
          external: true
          top_signame: fpga_info
          conn_type: false
          index: -1
        }
        {
          name: corei_tl_h
          struct: tl
          package: tlul_pkg
          type: req_rsp
          act: req
          width: 1
          inst_name: rv_core_ibex
          default: ""
          top_signame: main_tl_rv_core_ibex__corei
          index: -1
        }
        {
          name: cored_tl_h
          struct: tl
          package: tlul_pkg
          type: req_rsp
          act: req
          width: 1
          inst_name: rv_core_ibex
          default: ""
          top_signame: main_tl_rv_core_ibex__cored
          index: -1
        }
        {
          name: cfg_tl_d
          struct: tl
          package: tlul_pkg
          type: req_rsp
          act: rsp
          width: 1
          inst_name: rv_core_ibex
          default: ""
          end_idx: -1
          top_signame: rv_core_ibex_cfg_tl_d
          index: -1
        }
      ]
      base_addrs:
      {
        cfg:
        {
          hart: 0x411F0000
        }
      }
      generate_dif: true
      domain:
      [
        "0"
      ]
    }
  ]
  memory: []
  port:
  [
    {
      name: ast
      inter_signal_list:
      [
        {
          struct: edn
          type: req_rsp
          name: edn
          act: rsp
          package: edn_pkg
          inst_name: ast
          width: 1
          default: ""
          top_signame: edn0_edn
          index: 2
          external: true
          conn_type: true
        }
        {
          struct: lc_tx
          type: uni
          name: lc_dft_en
          act: req
          package: lc_ctrl_pkg
          inst_name: ast
          width: 1
          default: ""
          top_signame: lc_ctrl_lc_dft_en
          index: -1
          external: true
          conn_type: true
        }
        {
          struct: ram_1p_cfg
          package: prim_ram_1p_pkg
          type: uni
          name: ram_1p_cfg
          act: rcv
          inst_name: ast
          width: 1
          default: ""
          end_idx: -1
          top_type: broadcast
          top_signame: ast_ram_1p_cfg
          index: -1
          external: true
          conn_type: true
        }
        {
          struct: ram_2p_cfg
          package: prim_ram_2p_pkg
          type: uni
          name: spi_ram_2p_cfg
          act: rcv
          inst_name: ast
          width: 1
          default: ""
          end_idx: -1
          top_type: broadcast
          top_signame: ast_spi_ram_2p_cfg
          index: -1
          external: true
          conn_type: true
        }
        {
          struct: ram_1p_cfg
          package: prim_ram_1p_pkg
          type: uni
          name: usb_ram_1p_cfg
          act: rcv
          inst_name: ast
          width: 1
          default: ""
          end_idx: -1
          top_type: broadcast
          top_signame: ast_usb_ram_1p_cfg
          index: -1
          external: true
          conn_type: true
        }
        {
          struct: rom_cfg
          package: prim_rom_pkg
          type: uni
          name: rom_cfg
          act: rcv
          inst_name: ast
          width: 1
          default: ""
          end_idx: -1
          top_type: broadcast
          top_signame: ast_rom_cfg
          index: -1
          external: true
          conn_type: true
        }
        {
          struct: ast_obs_ctrl
          type: uni
          name: obs_ctrl
          act: rcv
          package: ast_pkg
          inst_name: ast
          width: 1
          default: ""
          end_idx: -1
          top_type: broadcast
          top_signame: ast_obs_ctrl
          index: -1
          external: true
          conn_type: true
        }
      ]
    }
  ]
  inter_module:
  {
    connect:
    {
      ast.obs_ctrl:
      [
        flash_ctrl.obs_ctrl
        otp_macro.obs_ctrl
      ]
      ast.ram_1p_cfg:
      [
        otbn.ram_cfg_imem
        otbn.ram_cfg_dmem
        i2c0.ram_cfg
        i2c1.ram_cfg
        i2c2.ram_cfg
        rv_core_ibex.ram_cfg_icache_tag
        rv_core_ibex.ram_cfg_icache_data
      ]
      ast.spi_ram_2p_cfg:
      [
        spi_device.ram_cfg_sys2spi
        spi_device.ram_cfg_spi2sys
      ]
      ast.usb_ram_1p_cfg:
      [
        usbdev.ram_cfg
      ]
      ast.rom_cfg:
      [
        rom_ctrl.rom_cfg
      ]
      alert_handler.crashdump:
      [
        rstmgr_aon.alert_dump
      ]
      alert_handler.esc_rx:
      [
        rv_core_ibex.esc_rx
        lc_ctrl.esc_scrap_state0_rx
        lc_ctrl.esc_scrap_state1_rx
        pwrmgr_aon.esc_rst_rx
      ]
      alert_handler.esc_tx:
      [
        rv_core_ibex.esc_tx
        lc_ctrl.esc_scrap_state0_tx
        lc_ctrl.esc_scrap_state1_tx
        pwrmgr_aon.esc_rst_tx
      ]
      aon_timer_aon.nmi_wdog_timer_bark:
      [
        rv_core_ibex.nmi_wdog
      ]
      csrng.csrng_cmd:
      [
        edn0.csrng_cmd
        edn1.csrng_cmd
      ]
      csrng.entropy_src_hw_if:
      [
        entropy_src.entropy_src_hw_if
      ]
      csrng.cs_aes_halt:
      [
        entropy_src.cs_aes_halt
      ]
      flash_ctrl.keymgr:
      [
        keymgr.flash
      ]
      flash_ctrl.otp:
      [
        otp_ctrl.flash_otp_key
      ]
      flash_ctrl.rma_seed:
      [
        lc_ctrl.lc_flash_rma_seed
      ]
      otp_ctrl.sram_otp_key:
      [
        sram_ctrl_main.sram_otp_key
        sram_ctrl_ret_aon.sram_otp_key
        rv_core_ibex.icache_otp_key
      ]
      pwrmgr_aon.pwr_flash:
      [
        flash_ctrl.pwrmgr
      ]
      pwrmgr_aon.pwr_rst:
      [
        rstmgr_aon.pwr
      ]
      pwrmgr_aon.pwr_clk:
      [
        clkmgr_aon.pwr
      ]
      pwrmgr_aon.pwr_otp:
      [
        otp_ctrl.pwr_otp
      ]
      pwrmgr_aon.pwr_lc:
      [
        lc_ctrl.pwr_lc
      ]
      pwrmgr_aon.strap:
      [
        pinmux_aon.strap_en
      ]
      pwrmgr_aon.low_power:
      [
        pinmux_aon.sleep_en
        aon_timer_aon.sleep_mode
      ]
      pwrmgr_aon.fetch_en:
      [
        rv_core_ibex.pwrmgr_cpu_en
      ]
      rom_ctrl.pwrmgr_data:
      [
        pwrmgr_aon.rom_ctrl
      ]
      rom_ctrl.keymgr_data:
      [
        keymgr.rom_digest
      ]
      lc_ctrl.lc_flash_rma_req:
      [
        flash_ctrl.rma_req
        otbn.lc_rma_req
      ]
      lc_ctrl.lc_flash_rma_ack:
      [
        flash_ctrl.rma_ack
        otbn.lc_rma_ack
      ]
      usbdev.usb_dp_pullup:
      [
        pinmux_aon.usbdev_dppullup_en
      ]
      usbdev.usb_dn_pullup:
      [
        pinmux_aon.usbdev_dnpullup_en
      ]
      usbdev.usb_aon_suspend_req:
      [
        pinmux_aon.usbdev_suspend_req
      ]
      usbdev.usb_aon_wake_ack:
      [
        pinmux_aon.usbdev_wake_ack
      ]
      usbdev.usb_aon_bus_not_idle:
      [
        pinmux_aon.usbdev_bus_not_idle
      ]
      usbdev.usb_aon_bus_reset:
      [
        pinmux_aon.usbdev_bus_reset
      ]
      usbdev.usb_aon_sense_lost:
      [
        pinmux_aon.usbdev_sense_lost
      ]
      pinmux_aon.usbdev_wake_detect_active:
      [
        usbdev.usb_aon_wake_detect_active
      ]
      edn0.edn:
      [
        keymgr.edn
        otp_ctrl.edn
        ast.edn
        kmac.entropy
        alert_handler.edn
        aes.edn
        otbn.edn_urnd
        rv_core_ibex.edn
      ]
      edn1.edn:
      [
        otbn.edn_rnd
      ]
      otp_ctrl.otbn_otp_key:
      [
        otbn.otbn_otp_key
      ]
      otp_ctrl.otp_keymgr_key:
      [
        keymgr.otp_key
      ]
      keymgr.aes_key:
      [
        aes.keymgr_key
      ]
      keymgr.kmac_key:
      [
        kmac.keymgr_key
      ]
      keymgr.otbn_key:
      [
        otbn.keymgr_key
      ]
      kmac.app:
      [
        keymgr.kmac_data
        lc_ctrl.kmac_data
        rom_ctrl.kmac_data
      ]
      kmac.en_masking:
      [
        keymgr.kmac_en_masking
      ]
      clkmgr_aon.idle:
      [
        aes.idle
        hmac.idle
        kmac.idle
        otbn.idle
      ]
      pinmux_aon.lc_jtag:
      [
        lc_ctrl.jtag
      ]
      pinmux_aon.rv_jtag:
      [
        rv_dm.jtag
      ]
      pinmux_aon.pinmux_hw_debug_en:
      [
        rv_dm.pinmux_hw_debug_en
      ]
      otp_ctrl.otp_lc_data:
      [
        lc_ctrl.otp_lc_data
      ]
      lc_ctrl.lc_otp_program:
      [
        otp_ctrl.lc_otp_program
      ]
      lc_ctrl.lc_otp_vendor_test:
      [
        otp_macro.test
      ]
      lc_ctrl.lc_keymgr_div:
      [
        keymgr.lc_keymgr_div
      ]
      lc_ctrl.strap_en_override:
      [
        pinmux_aon.strap_en_override
      ]
      lc_ctrl.lc_dft_en:
      [
        otp_macro.lc_dft_en
        pinmux_aon.lc_dft_en
        ast.lc_dft_en
        pwrmgr_aon.lc_dft_en
        rv_dm.lc_dft_en
      ]
      lc_ctrl.lc_nvm_debug_en:
      [
        flash_ctrl.lc_nvm_debug_en
      ]
      lc_ctrl.lc_hw_debug_en:
      [
        sram_ctrl_main.lc_hw_debug_en
        pinmux_aon.lc_hw_debug_en
        csrng.lc_hw_debug_en
        rv_dm.lc_hw_debug_en
        clkmgr_aon.lc_hw_debug_en
        pwrmgr_aon.lc_hw_debug_en
      ]
      lc_ctrl.lc_cpu_en:
      [
        rv_core_ibex.lc_cpu_en
      ]
      lc_ctrl.lc_keymgr_en:
      [
        keymgr.lc_keymgr_en
      ]
      lc_ctrl.lc_escalate_en:
      [
        aes.lc_escalate_en
        kmac.lc_escalate_en
        otbn.lc_escalate_en
        otp_ctrl.lc_escalate_en
        sram_ctrl_main.lc_escalate_en
        sram_ctrl_ret_aon.lc_escalate_en
        aon_timer_aon.lc_escalate_en
        flash_ctrl.lc_escalate_en
        pinmux_aon.lc_escalate_en
      ]
      lc_ctrl.lc_check_byp_en:
      [
        otp_ctrl.lc_check_byp_en
        pinmux_aon.lc_check_byp_en
      ]
      lc_ctrl.lc_clk_byp_req:
      [
        clkmgr_aon.lc_clk_byp_req
      ]
      lc_ctrl.lc_clk_byp_ack:
      [
        clkmgr_aon.lc_clk_byp_ack
      ]
      lc_ctrl.lc_creator_seed_sw_rw_en:
      [
        otp_ctrl.lc_creator_seed_sw_rw_en
        flash_ctrl.lc_creator_seed_sw_rw_en
      ]
      lc_ctrl.lc_owner_seed_sw_rw_en:
      [
        flash_ctrl.lc_owner_seed_sw_rw_en
      ]
      lc_ctrl.lc_iso_part_sw_rd_en:
      [
        flash_ctrl.lc_iso_part_sw_rd_en
      ]
      lc_ctrl.lc_iso_part_sw_wr_en:
      [
        flash_ctrl.lc_iso_part_sw_wr_en
      ]
      lc_ctrl.lc_seed_hw_rd_en:
      [
        otp_ctrl.lc_seed_hw_rd_en
        flash_ctrl.lc_seed_hw_rd_en
      ]
      otp_ctrl.otp_macro:
      [
        otp_macro.otp
      ]
      rv_plic.msip:
      [
        rv_core_ibex.irq_software
      ]
      rv_plic.irq:
      [
        rv_core_ibex.irq_external
      ]
      rv_dm.debug_req:
      [
        rv_core_ibex.debug_req
      ]
      rv_core_ibex.crash_dump:
      [
        rstmgr_aon.cpu_dump
      ]
      rv_core_ibex.pwrmgr:
      [
        pwrmgr_aon.pwr_cpu
      ]
      spi_device.passthrough:
      [
        spi_host0.passthrough
      ]
      rv_dm.ndmreset_req:
      [
        pwrmgr_aon.ndmreset_req
      ]
      rstmgr_aon.sw_rst_req:
      [
        pwrmgr_aon.sw_rst_req
      ]
      pwrmgr_aon.wakeups:
      [
        sysrst_ctrl_aon.wkup_req
        adc_ctrl_aon.wkup_req
        pinmux_aon.pin_wkup_req
        pinmux_aon.usb_wkup_req
        aon_timer_aon.wkup_req
        sensor_ctrl_aon.wkup_req
      ]
      pwrmgr_aon.rstreqs:
      [
        sysrst_ctrl_aon.rst_req
        aon_timer_aon.aon_timer_rst_req
      ]
      main.tl_rv_core_ibex__corei:
      [
        rv_core_ibex.corei_tl_h
      ]
      main.tl_rv_core_ibex__cored:
      [
        rv_core_ibex.cored_tl_h
      ]
      main.tl_rv_dm__sba:
      [
        rv_dm.sba_tl_h
      ]
      rv_dm.regs_tl_d:
      [
        main.tl_rv_dm__regs
      ]
      rv_dm.mem_tl_d:
      [
        main.tl_rv_dm__mem
      ]
      rom_ctrl.rom_tl:
      [
        main.tl_rom_ctrl__rom
      ]
      rom_ctrl.regs_tl:
      [
        main.tl_rom_ctrl__regs
      ]
      main.tl_peri:
      [
        peri.tl_main
      ]
      spi_host0.tl:
      [
        main.tl_spi_host0
      ]
      spi_host1.tl:
      [
        main.tl_spi_host1
      ]
      usbdev.tl:
      [
        main.tl_usbdev
      ]
      flash_ctrl.core_tl:
      [
        main.tl_flash_ctrl__core
      ]
      flash_ctrl.prim_tl:
      [
        main.tl_flash_ctrl__prim
      ]
      flash_ctrl.mem_tl:
      [
        main.tl_flash_ctrl__mem
      ]
      hmac.tl:
      [
        main.tl_hmac
      ]
      kmac.tl:
      [
        main.tl_kmac
      ]
      aes.tl:
      [
        main.tl_aes
      ]
      entropy_src.tl:
      [
        main.tl_entropy_src
      ]
      csrng.tl:
      [
        main.tl_csrng
      ]
      edn0.tl:
      [
        main.tl_edn0
      ]
      edn1.tl:
      [
        main.tl_edn1
      ]
      rv_plic.tl:
      [
        main.tl_rv_plic
      ]
      otbn.tl:
      [
        main.tl_otbn
      ]
      keymgr.tl:
      [
        main.tl_keymgr
      ]
      rv_core_ibex.cfg_tl_d:
      [
        main.tl_rv_core_ibex__cfg
      ]
      sram_ctrl_main.regs_tl:
      [
        main.tl_sram_ctrl_main__regs
      ]
      sram_ctrl_main.ram_tl:
      [
        main.tl_sram_ctrl_main__ram
      ]
      uart0.tl:
      [
        peri.tl_uart0
      ]
      uart1.tl:
      [
        peri.tl_uart1
      ]
      uart2.tl:
      [
        peri.tl_uart2
      ]
      uart3.tl:
      [
        peri.tl_uart3
      ]
      i2c0.tl:
      [
        peri.tl_i2c0
      ]
      i2c1.tl:
      [
        peri.tl_i2c1
      ]
      i2c2.tl:
      [
        peri.tl_i2c2
      ]
      pattgen.tl:
      [
        peri.tl_pattgen
      ]
      pwm_aon.tl:
      [
        peri.tl_pwm_aon
      ]
      gpio.tl:
      [
        peri.tl_gpio
      ]
      spi_device.tl:
      [
        peri.tl_spi_device
      ]
      rv_timer.tl:
      [
        peri.tl_rv_timer
      ]
      pwrmgr_aon.tl:
      [
        peri.tl_pwrmgr_aon
      ]
      rstmgr_aon.tl:
      [
        peri.tl_rstmgr_aon
      ]
      clkmgr_aon.tl:
      [
        peri.tl_clkmgr_aon
      ]
      pinmux_aon.tl:
      [
        peri.tl_pinmux_aon
      ]
      otp_ctrl.core_tl:
      [
        peri.tl_otp_ctrl__core
      ]
      otp_macro.tl:
      [
        peri.tl_otp_macro
      ]
      lc_ctrl.regs_tl:
      [
        peri.tl_lc_ctrl__regs
      ]
      sensor_ctrl_aon.tl:
      [
        peri.tl_sensor_ctrl_aon
      ]
      alert_handler.tl:
      [
        peri.tl_alert_handler
      ]
      sram_ctrl_ret_aon.regs_tl:
      [
        peri.tl_sram_ctrl_ret_aon__regs
      ]
      sram_ctrl_ret_aon.ram_tl:
      [
        peri.tl_sram_ctrl_ret_aon__ram
      ]
      aon_timer_aon.tl:
      [
        peri.tl_aon_timer_aon
      ]
      sysrst_ctrl_aon.tl:
      [
        peri.tl_sysrst_ctrl_aon
      ]
      adc_ctrl_aon.tl:
      [
        peri.tl_adc_ctrl_aon
      ]
    }
    top:
    [
      clkmgr_aon.clocks
      clkmgr_aon.cg_en
      rstmgr_aon.resets
      rstmgr_aon.rst_en
      rv_core_ibex.irq_timer
      rv_core_ibex.hart_id
      rv_core_ibex.boot_addr
      pinmux_aon.dft_jtag
      otp_ctrl.otp_broadcast
      csrng.otp_en_csrng_sw_app_read
      lc_ctrl.otp_device_id
      lc_ctrl.otp_manuf_state
      keymgr.otp_device_id
      sram_ctrl_main.otp_en_sram_ifetch
      rv_dm.otp_dis_rv_dm_late_debug
    ]
    external:
    {
      adc_ctrl_aon.adc: adc
      ast.edn: ""
      ast.lc_dft_en: ""
      ast.obs_ctrl: obs_ctrl
      ast.ram_1p_cfg: ram_1p_cfg
      sram_ctrl_main.cfg: sram_ctrl_main_cfg
      sram_ctrl_ret_aon.cfg: sram_ctrl_ret_aon_cfg
      ast.spi_ram_2p_cfg: spi_ram_2p_cfg
      ast.usb_ram_1p_cfg: usb_ram_1p_cfg
      ast.rom_cfg: rom_cfg
      clkmgr_aon.jitter_en: clk_main_jitter_en
      clkmgr_aon.io_clk_byp_req: io_clk_byp_req
      clkmgr_aon.io_clk_byp_ack: io_clk_byp_ack
      clkmgr_aon.all_clk_byp_req: all_clk_byp_req
      clkmgr_aon.all_clk_byp_ack: all_clk_byp_ack
      clkmgr_aon.hi_speed_sel: hi_speed_sel
      clkmgr_aon.div_step_down_req: div_step_down_req
      clkmgr_aon.calib_rdy: calib_rdy
      flash_ctrl.flash_bist_enable: flash_bist_enable
      flash_ctrl.flash_power_down_h: flash_power_down_h
      flash_ctrl.flash_power_ready_h: flash_power_ready_h
      flash_ctrl.flash_test_mode_a: flash_test_mode_a
      flash_ctrl.flash_test_voltage_h: flash_test_voltage_h
      flash_ctrl.fla_obs: flash_obs
      entropy_src.entropy_src_rng: es_rng
      entropy_src.rng_fips: es_rng_fips
      peri.tl_ast: ast_tl
      pinmux_aon.dft_strap_test: dft_strap_test
      pinmux_aon.dft_hold_tap_sel: dft_hold_tap_sel
      pinmux_aon.usb_dppullup_en: usb_dp_pullup_en
      pinmux_aon.usb_dnpullup_en: usb_dn_pullup_en
      pwrmgr_aon.pwr_ast: pwrmgr_ast
      otp_macro.pwr_seq: ""
      otp_macro.pwr_seq_h: ""
      otp_macro.ext_voltage_h: otp_ext_voltage_h
      otp_macro.otp_obs: otp_obs
      rstmgr_aon.por_n: por_n
      rv_core_ibex.fpga_info: fpga_info
      sensor_ctrl_aon.ast_alert: sensor_ctrl_ast_alert
      sensor_ctrl_aon.ast_status: sensor_ctrl_ast_status
      sensor_ctrl_aon.ast2pinmux: ast2pinmux
      sensor_ctrl_aon.ast_init_done: ast_init_done
      sensor_ctrl_aon.manual_pad_attr: sensor_ctrl_manual_pad_attr
      spi_device.sck_monitor: sck_monitor
      usbdev.usb_rx_d: ""
      usbdev.usb_tx_d: ""
      usbdev.usb_tx_se0: ""
      usbdev.usb_tx_use_d_se0: ""
      usbdev.usb_rx_enable: ""
      usbdev.usb_ref_val: ""
      usbdev.usb_ref_pulse: ""
    }
  }
  xbar:
  [
    {
      name: main
      clock_srcs:
      {
        clk_main_i: main
        clk_fixed_i: io_div4
        clk_usb_i: usb
        clk_spi_host0_i: io
        clk_spi_host1_i: io_div2
      }
      clock_group: infra
      reset: rst_main_ni
      reset_connections:
      {
        rst_main_ni:
        {
          name: lc
          domain: "0"
        }
        rst_fixed_ni:
        {
          name: lc_io_div4
          domain: "0"
        }
        rst_usb_ni:
        {
          name: lc_usb
          domain: "0"
        }
        rst_spi_host0_ni:
        {
          name: lc_io
          domain: "0"
        }
        rst_spi_host1_ni:
        {
          name: lc_io_div2
          domain: "0"
        }
      }
      clock_connections:
      {
        clk_main_i: clkmgr_aon_clocks.clk_main_infra
        clk_fixed_i: clkmgr_aon_clocks.clk_io_div4_infra
        clk_usb_i: clkmgr_aon_clocks.clk_usb_infra
        clk_spi_host0_i: clkmgr_aon_clocks.clk_io_infra
        clk_spi_host1_i: clkmgr_aon_clocks.clk_io_div2_infra
      }
      domain:
      [
        "0"
      ]
      connections:
      {
        rv_core_ibex.corei:
        [
          rom_ctrl.rom
          rv_dm.mem
          sram_ctrl_main.ram
          flash_ctrl.mem
        ]
        rv_core_ibex.cored:
        [
          rom_ctrl.rom
          rom_ctrl.regs
          rv_dm.mem
          rv_dm.regs
          sram_ctrl_main.ram
          peri
          spi_host0
          spi_host1
          usbdev
          flash_ctrl.core
          flash_ctrl.prim
          flash_ctrl.mem
          aes
          entropy_src
          csrng
          edn0
          edn1
          hmac
          rv_plic
          otbn
          keymgr
          kmac
          sram_ctrl_main.regs
          rv_core_ibex.cfg
        ]
        rv_dm.sba:
        [
          rom_ctrl.rom
          rom_ctrl.regs
          rv_dm.mem
          rv_dm.regs
          sram_ctrl_main.ram
          peri
          spi_host0
          spi_host1
          usbdev
          flash_ctrl.core
          flash_ctrl.prim
          flash_ctrl.mem
          aes
          entropy_src
          csrng
          edn0
          edn1
          hmac
          rv_plic
          otbn
          keymgr
          kmac
          sram_ctrl_main.regs
          rv_core_ibex.cfg
        ]
      }
      nodes:
      [
        {
          name: rv_core_ibex.corei
          type: host
          addr_space: hart
          clock: clk_main_i
          reset: rst_main_ni
          pipeline: false
          xbar: false
          stub: false
          inst_type: ""
          req_fifo_pass: true
          rsp_fifo_pass: true
        }
        {
          name: rv_core_ibex.cored
          type: host
          addr_space: hart
          clock: clk_main_i
          reset: rst_main_ni
          pipeline: false
          xbar: false
          stub: false
          inst_type: ""
          req_fifo_pass: true
          rsp_fifo_pass: true
        }
        {
          name: rv_dm.sba
          type: host
          addr_space: hart
          clock: clk_main_i
          reset: rst_main_ni
          req_fifo_pass: false
          rsp_fifo_pass: false
          xbar: false
          stub: false
          inst_type: ""
          pipeline: true
        }
        {
          name: rv_dm.regs
          type: device
          clock: clk_main_i
          reset: rst_main_ni
          req_fifo_pass: false
          rsp_fifo_pass: false
          inst_type: rv_dm
          addr_range:
          [
            {
              base_addrs:
              {
                hart: 0x41200000
              }
              size_byte: 0x10
            }
          ]
          xbar: false
          stub: false
          pipeline: true
        }
        {
          name: rv_dm.mem
          type: device
          clock: clk_main_i
          reset: rst_main_ni
          req_fifo_pass: false
          rsp_fifo_pass: false
          inst_type: rv_dm
          addr_range:
          [
            {
              base_addrs:
              {
                hart: 0x10000
              }
              size_byte: 0x1000
            }
          ]
          xbar: false
          stub: false
          pipeline: true
        }
        {
          name: rom_ctrl.rom
          type: device
          clock: clk_main_i
          reset: rst_main_ni
          req_fifo_pass: true
          rsp_fifo_pass: false
          inst_type: rom_ctrl
          addr_range:
          [
            {
              base_addrs:
              {
                hart: 0x8000
              }
              size_byte: 0x8000
            }
          ]
          xbar: false
          stub: false
          pipeline: true
        }
        {
          name: rom_ctrl.regs
          type: device
          clock: clk_main_i
          reset: rst_main_ni
          req_fifo_pass: false
          rsp_fifo_pass: false
          inst_type: rom_ctrl
          addr_range:
          [
            {
              base_addrs:
              {
                hart: 0x411e0000
              }
              size_byte: 0x80
            }
          ]
          xbar: false
          stub: false
          pipeline: true
        }
        {
          name: peri
          type: device
          clock: clk_fixed_i
          reset: rst_fixed_ni
          req_fifo_pass: false
          rsp_fifo_pass: false
          xbar: true
          stub: false
          pipeline: true
          addr_space: hart
          addr_range:
          [
            {
              base_addrs:
              {
                hart: 0x40000000
              }
              size_byte: 0x200000
            }
            {
              base_addrs:
              {
                hart: 0x40400000
              }
              size_byte: 0x400000
            }
          ]
        }
        {
          name: spi_host0
          type: device
          clock: clk_spi_host0_i
          reset: rst_spi_host0_ni
          req_fifo_pass: false
          rsp_fifo_pass: false
          inst_type: spi_host
          addr_range:
          [
            {
              base_addrs:
              {
                hart: 0x40300000
              }
              size_byte: 0x40
            }
          ]
          xbar: false
          stub: false
          pipeline: true
        }
        {
          name: spi_host1
          type: device
          clock: clk_spi_host1_i
          reset: rst_spi_host1_ni
          req_fifo_pass: false
          rsp_fifo_pass: false
          inst_type: spi_host
          addr_range:
          [
            {
              base_addrs:
              {
                hart: 0x40310000
              }
              size_byte: 0x40
            }
          ]
          xbar: false
          stub: false
          pipeline: true
        }
        {
          name: usbdev
          type: device
          clock: clk_usb_i
          reset: rst_usb_ni
          req_fifo_pass: false
          rsp_fifo_pass: false
          inst_type: usbdev
          addr_range:
          [
            {
              base_addrs:
              {
                hart: 0x40320000
              }
              size_byte: 0x1000
            }
          ]
          xbar: false
          stub: false
          pipeline: true
        }
        {
          name: flash_ctrl.core
          type: device
          clock: clk_main_i
          reset: rst_main_ni
          req_fifo_pass: false
          rsp_fifo_pass: false
          inst_type: flash_ctrl
          addr_range:
          [
            {
              base_addrs:
              {
                hart: 0x41000000
              }
              size_byte: 0x200
            }
          ]
          xbar: false
          stub: false
          pipeline: true
        }
        {
          name: flash_ctrl.prim
          type: device
          clock: clk_main_i
          reset: rst_main_ni
          req_fifo_pass: false
          rsp_fifo_pass: false
          inst_type: flash_ctrl
          addr_range:
          [
            {
              base_addrs:
              {
                hart: 0x41008000
              }
              size_byte: 0x80
            }
          ]
          xbar: false
          stub: false
          pipeline: true
        }
        {
          name: flash_ctrl.mem
          type: device
          clock: clk_main_i
          reset: rst_main_ni
          req_fifo_pass: false
          rsp_fifo_pass: false
          inst_type: flash_ctrl
          addr_range:
          [
            {
              base_addrs:
              {
                hart: 0x20000000
              }
              size_byte: 0x100000
            }
          ]
          xbar: false
          stub: false
          pipeline: true
        }
        {
          name: hmac
          type: device
          clock: clk_main_i
          reset: rst_main_ni
          req_fifo_pass: false
          rsp_fifo_pass: false
          inst_type: hmac
          addr_range:
          [
            {
              base_addrs:
              {
                hart: 0x41110000
              }
              size_byte: 0x2000
            }
          ]
          xbar: false
          stub: false
          pipeline: true
        }
        {
          name: kmac
          type: device
          clock: clk_main_i
          reset: rst_main_ni
          req_fifo_pass: false
          rsp_fifo_pass: false
          inst_type: kmac
          addr_range:
          [
            {
              base_addrs:
              {
                hart: 0x41120000
              }
              size_byte: 0x1000
            }
          ]
          xbar: false
          stub: false
          pipeline: true
        }
        {
          name: aes
          type: device
          clock: clk_main_i
          reset: rst_main_ni
          req_fifo_pass: false
          rsp_fifo_pass: false
          inst_type: aes
          addr_range:
          [
            {
              base_addrs:
              {
                hart: 0x41100000
              }
              size_byte: 0x100
            }
          ]
          xbar: false
          stub: false
          pipeline: true
        }
        {
          name: entropy_src
          type: device
          clock: clk_main_i
          reset: rst_main_ni
          req_fifo_pass: false
          rsp_fifo_pass: false
          inst_type: entropy_src
          addr_range:
          [
            {
              base_addrs:
              {
                hart: 0x41160000
              }
              size_byte: 0x100
            }
          ]
          xbar: false
          stub: false
          pipeline: true
        }
        {
          name: csrng
          type: device
          clock: clk_main_i
          reset: rst_main_ni
          req_fifo_pass: false
          rsp_fifo_pass: false
          inst_type: csrng
          addr_range:
          [
            {
              base_addrs:
              {
                hart: 0x41150000
              }
              size_byte: 0x80
            }
          ]
          xbar: false
          stub: false
          pipeline: true
        }
        {
          name: edn0
          type: device
          clock: clk_main_i
          reset: rst_main_ni
          req_fifo_pass: false
          rsp_fifo_pass: false
          inst_type: edn
          addr_range:
          [
            {
              base_addrs:
              {
                hart: 0x41170000
              }
              size_byte: 0x80
            }
          ]
          xbar: false
          stub: false
          pipeline: true
        }
        {
          name: edn1
          type: device
          clock: clk_main_i
          reset: rst_main_ni
          req_fifo_pass: false
          rsp_fifo_pass: false
          inst_type: edn
          addr_range:
          [
            {
              base_addrs:
              {
                hart: 0x41180000
              }
              size_byte: 0x80
            }
          ]
          xbar: false
          stub: false
          pipeline: true
        }
        {
          name: rv_plic
          type: device
          clock: clk_main_i
          reset: rst_main_ni
          inst_type: rv_plic
          req_fifo_pass: false
          rsp_fifo_pass: false
          addr_range:
          [
            {
              base_addrs:
              {
                hart: 0x48000000
              }
              size_byte: 0x8000000
            }
          ]
          xbar: false
          stub: false
          pipeline: true
        }
        {
          name: otbn
          type: device
          clock: clk_main_i
          reset: rst_main_ni
          req_fifo_pass: false
          rsp_fifo_pass: false
          inst_type: otbn
          addr_range:
          [
            {
              base_addrs:
              {
                hart: 0x41130000
              }
              size_byte: 0x10000
            }
          ]
          xbar: false
          stub: false
          pipeline: true
        }
        {
          name: keymgr
          type: device
          clock: clk_main_i
          reset: rst_main_ni
          req_fifo_pass: false
          rsp_fifo_pass: false
          inst_type: keymgr
          addr_range:
          [
            {
              base_addrs:
              {
                hart: 0x41140000
              }
              size_byte: 0x100
            }
          ]
          xbar: false
          stub: false
          pipeline: true
        }
        {
          name: rv_core_ibex.cfg
          type: device
          clock: clk_main_i
          reset: rst_main_ni
          req_fifo_pass: false
          rsp_fifo_pass: false
          inst_type: rv_core_ibex
          addr_range:
          [
            {
              base_addrs:
              {
                hart: 0x411f0000
              }
              size_byte: 0x100
            }
          ]
          xbar: false
          stub: false
          pipeline: true
        }
        {
          name: sram_ctrl_main.regs
          type: device
          clock: clk_main_i
          reset: rst_main_ni
          req_fifo_pass: false
          rsp_fifo_pass: false
          inst_type: sram_ctrl
          addr_range:
          [
            {
              base_addrs:
              {
                hart: 0x411c0000
              }
              size_byte: 0x40
            }
          ]
          xbar: false
          stub: false
          pipeline: true
        }
        {
          name: sram_ctrl_main.ram
          type: device
          clock: clk_main_i
          reset: rst_main_ni
          pipeline: false
          inst_type: sram_ctrl
          addr_range:
          [
            {
              base_addrs:
              {
                hart: 0x10000000
              }
              size_byte: 0x20000
            }
          ]
          xbar: false
          stub: false
          req_fifo_pass: true
        }
      ]
      addr_spaces:
      [
        hart
      ]
      clock: clk_main_i
      type: xbar
      inter_signal_list:
      [
        {
          name: tl_rv_core_ibex__corei
          struct: tl
          package: tlul_pkg
          type: req_rsp
          act: rsp
          inst_name: main
          width: 1
          default: ""
          end_idx: -1
          top_signame: main_tl_rv_core_ibex__corei
          index: -1
        }
        {
          name: tl_rv_core_ibex__cored
          struct: tl
          package: tlul_pkg
          type: req_rsp
          act: rsp
          inst_name: main
          width: 1
          default: ""
          end_idx: -1
          top_signame: main_tl_rv_core_ibex__cored
          index: -1
        }
        {
          name: tl_rv_dm__sba
          struct: tl
          package: tlul_pkg
          type: req_rsp
          act: rsp
          inst_name: main
          width: 1
          default: ""
          end_idx: -1
          top_signame: main_tl_rv_dm__sba
          index: -1
        }
        {
          name: tl_rv_dm__regs
          struct: tl
          package: tlul_pkg
          type: req_rsp
          act: req
          inst_name: main
          width: 1
          default: ""
          top_signame: rv_dm_regs_tl_d
          index: -1
        }
        {
          name: tl_rv_dm__mem
          struct: tl
          package: tlul_pkg
          type: req_rsp
          act: req
          inst_name: main
          width: 1
          default: ""
          top_signame: rv_dm_mem_tl_d
          index: -1
        }
        {
          name: tl_rom_ctrl__rom
          struct: tl
          package: tlul_pkg
          type: req_rsp
          act: req
          inst_name: main
          width: 1
          default: ""
          top_signame: rom_ctrl_rom_tl
          index: -1
        }
        {
          name: tl_rom_ctrl__regs
          struct: tl
          package: tlul_pkg
          type: req_rsp
          act: req
          inst_name: main
          width: 1
          default: ""
          top_signame: rom_ctrl_regs_tl
          index: -1
        }
        {
          name: tl_peri
          struct: tl
          package: tlul_pkg
          type: req_rsp
          act: req
          inst_name: main
          width: 1
          default: ""
          end_idx: -1
          top_signame: main_tl_peri
          index: -1
        }
        {
          name: tl_spi_host0
          struct: tl
          package: tlul_pkg
          type: req_rsp
          act: req
          inst_name: main
          width: 1
          default: ""
          top_signame: spi_host0_tl
          index: -1
        }
        {
          name: tl_spi_host1
          struct: tl
          package: tlul_pkg
          type: req_rsp
          act: req
          inst_name: main
          width: 1
          default: ""
          top_signame: spi_host1_tl
          index: -1
        }
        {
          name: tl_usbdev
          struct: tl
          package: tlul_pkg
          type: req_rsp
          act: req
          inst_name: main
          width: 1
          default: ""
          top_signame: usbdev_tl
          index: -1
        }
        {
          name: tl_flash_ctrl__core
          struct: tl
          package: tlul_pkg
          type: req_rsp
          act: req
          inst_name: main
          width: 1
          default: ""
          top_signame: flash_ctrl_core_tl
          index: -1
        }
        {
          name: tl_flash_ctrl__prim
          struct: tl
          package: tlul_pkg
          type: req_rsp
          act: req
          inst_name: main
          width: 1
          default: ""
          top_signame: flash_ctrl_prim_tl
          index: -1
        }
        {
          name: tl_flash_ctrl__mem
          struct: tl
          package: tlul_pkg
          type: req_rsp
          act: req
          inst_name: main
          width: 1
          default: ""
          top_signame: flash_ctrl_mem_tl
          index: -1
        }
        {
          name: tl_hmac
          struct: tl
          package: tlul_pkg
          type: req_rsp
          act: req
          inst_name: main
          width: 1
          default: ""
          top_signame: hmac_tl
          index: -1
        }
        {
          name: tl_kmac
          struct: tl
          package: tlul_pkg
          type: req_rsp
          act: req
          inst_name: main
          width: 1
          default: ""
          top_signame: kmac_tl
          index: -1
        }
        {
          name: tl_aes
          struct: tl
          package: tlul_pkg
          type: req_rsp
          act: req
          inst_name: main
          width: 1
          default: ""
          top_signame: aes_tl
          index: -1
        }
        {
          name: tl_entropy_src
          struct: tl
          package: tlul_pkg
          type: req_rsp
          act: req
          inst_name: main
          width: 1
          default: ""
          top_signame: entropy_src_tl
          index: -1
        }
        {
          name: tl_csrng
          struct: tl
          package: tlul_pkg
          type: req_rsp
          act: req
          inst_name: main
          width: 1
          default: ""
          top_signame: csrng_tl
          index: -1
        }
        {
          name: tl_edn0
          struct: tl
          package: tlul_pkg
          type: req_rsp
          act: req
          inst_name: main
          width: 1
          default: ""
          top_signame: edn0_tl
          index: -1
        }
        {
          name: tl_edn1
          struct: tl
          package: tlul_pkg
          type: req_rsp
          act: req
          inst_name: main
          width: 1
          default: ""
          top_signame: edn1_tl
          index: -1
        }
        {
          name: tl_rv_plic
          struct: tl
          package: tlul_pkg
          type: req_rsp
          act: req
          inst_name: main
          width: 1
          default: ""
          top_signame: rv_plic_tl
          index: -1
        }
        {
          name: tl_otbn
          struct: tl
          package: tlul_pkg
          type: req_rsp
          act: req
          inst_name: main
          width: 1
          default: ""
          top_signame: otbn_tl
          index: -1
        }
        {
          name: tl_keymgr
          struct: tl
          package: tlul_pkg
          type: req_rsp
          act: req
          inst_name: main
          width: 1
          default: ""
          top_signame: keymgr_tl
          index: -1
        }
        {
          name: tl_rv_core_ibex__cfg
          struct: tl
          package: tlul_pkg
          type: req_rsp
          act: req
          inst_name: main
          width: 1
          default: ""
          top_signame: rv_core_ibex_cfg_tl_d
          index: -1
        }
        {
          name: tl_sram_ctrl_main__regs
          struct: tl
          package: tlul_pkg
          type: req_rsp
          act: req
          inst_name: main
          width: 1
          default: ""
          top_signame: sram_ctrl_main_regs_tl
          index: -1
        }
        {
          name: tl_sram_ctrl_main__ram
          struct: tl
          package: tlul_pkg
          type: req_rsp
          act: req
          inst_name: main
          width: 1
          default: ""
          top_signame: sram_ctrl_main_ram_tl
          index: -1
        }
      ]
    }
    {
      name: peri
      clock_srcs:
      {
        clk_peri_i: io_div4
      }
      clock_group: infra
      reset: rst_peri_ni
      reset_connections:
      {
        rst_peri_ni:
        {
          name: lc_io_div4
          domain: "0"
        }
      }
      clock_connections:
      {
        clk_peri_i: clkmgr_aon_clocks.clk_io_div4_infra
      }
      domain:
      [
        "0"
      ]
      connections:
      {
        main:
        [
          uart0
          uart1
          uart2
          uart3
          i2c0
          i2c1
          i2c2
          pattgen
          gpio
          spi_device
          rv_timer
          pwrmgr_aon
          rstmgr_aon
          clkmgr_aon
          pinmux_aon
          otp_ctrl.core
          otp_macro
          lc_ctrl.regs
          sensor_ctrl_aon
          alert_handler
          ast
          sram_ctrl_ret_aon.ram
          sram_ctrl_ret_aon.regs
          aon_timer_aon
          adc_ctrl_aon
          sysrst_ctrl_aon
          pwm_aon
        ]
      }
      nodes:
      [
        {
          name: main
          type: host
          addr_space: hart
          clock: clk_peri_i
          reset: rst_peri_ni
          xbar: true
          pipeline: false
          stub: false
          inst_type: ""
          req_fifo_pass: true
          rsp_fifo_pass: true
        }
        {
          name: uart0
          type: device
          clock: clk_peri_i
          reset: rst_peri_ni
          pipeline: false
          inst_type: uart
          addr_range:
          [
            {
              base_addrs:
              {
                hart: 0x40000000
              }
              size_byte: 0x40
            }
          ]
          xbar: false
          stub: false
          req_fifo_pass: true
        }
        {
          name: uart1
          type: device
          clock: clk_peri_i
          reset: rst_peri_ni
          pipeline: false
          inst_type: uart
          addr_range:
          [
            {
              base_addrs:
              {
                hart: 0x40010000
              }
              size_byte: 0x40
            }
          ]
          xbar: false
          stub: false
          req_fifo_pass: true
        }
        {
          name: uart2
          type: device
          clock: clk_peri_i
          reset: rst_peri_ni
          pipeline: false
          inst_type: uart
          addr_range:
          [
            {
              base_addrs:
              {
                hart: 0x40020000
              }
              size_byte: 0x40
            }
          ]
          xbar: false
          stub: false
          req_fifo_pass: true
        }
        {
          name: uart3
          type: device
          clock: clk_peri_i
          reset: rst_peri_ni
          pipeline: false
          inst_type: uart
          addr_range:
          [
            {
              base_addrs:
              {
                hart: 0x40030000
              }
              size_byte: 0x40
            }
          ]
          xbar: false
          stub: false
          req_fifo_pass: true
        }
        {
          name: i2c0
          type: device
          clock: clk_peri_i
          reset: rst_peri_ni
          pipeline: false
          inst_type: i2c
          addr_range:
          [
            {
              base_addrs:
              {
                hart: 0x40080000
              }
              size_byte: 0x80
            }
          ]
          xbar: false
          stub: false
          req_fifo_pass: true
        }
        {
          name: i2c1
          type: device
          clock: clk_peri_i
          reset: rst_peri_ni
          pipeline: false
          inst_type: i2c
          addr_range:
          [
            {
              base_addrs:
              {
                hart: 0x40090000
              }
              size_byte: 0x80
            }
          ]
          xbar: false
          stub: false
          req_fifo_pass: true
        }
        {
          name: i2c2
          type: device
          clock: clk_peri_i
          reset: rst_peri_ni
          pipeline: false
          inst_type: i2c
          addr_range:
          [
            {
              base_addrs:
              {
                hart: 0x400a0000
              }
              size_byte: 0x80
            }
          ]
          xbar: false
          stub: false
          req_fifo_pass: true
        }
        {
          name: pattgen
          type: device
          clock: clk_peri_i
          reset: rst_peri_ni
          pipeline: false
          inst_type: pattgen
          addr_range:
          [
            {
              base_addrs:
              {
                hart: 0x400e0000
              }
              size_byte: 0x40
            }
          ]
          xbar: false
          stub: false
          req_fifo_pass: true
        }
        {
          name: pwm_aon
          type: device
          clock: clk_peri_i
          reset: rst_peri_ni
          pipeline: false
          inst_type: pwm
          addr_range:
          [
            {
              base_addrs:
              {
                hart: 0x40450000
              }
              size_byte: 0x80
            }
          ]
          xbar: false
          stub: false
          req_fifo_pass: true
        }
        {
          name: gpio
          type: device
          clock: clk_peri_i
          reset: rst_peri_ni
          pipeline: false
          inst_type: gpio
          addr_range:
          [
            {
              base_addrs:
              {
                hart: 0x40040000
              }
              size_byte: 0x80
            }
          ]
          xbar: false
          stub: false
          req_fifo_pass: true
        }
        {
          name: spi_device
          type: device
          clock: clk_peri_i
          reset: rst_peri_ni
          pipeline: false
          inst_type: spi_device
          addr_range:
          [
            {
              base_addrs:
              {
                hart: 0x40050000
              }
              size_byte: 0x2000
            }
          ]
          xbar: false
          stub: false
          req_fifo_pass: true
        }
        {
          name: rv_timer
          type: device
          clock: clk_peri_i
          reset: rst_peri_ni
          pipeline: false
          inst_type: rv_timer
          addr_range:
          [
            {
              base_addrs:
              {
                hart: 0x40100000
              }
              size_byte: 0x200
            }
          ]
          xbar: false
          stub: false
          req_fifo_pass: true
        }
        {
          name: pwrmgr_aon
          type: device
          clock: clk_peri_i
          reset: rst_peri_ni
          pipeline: false
          inst_type: pwrmgr
          addr_range:
          [
            {
              base_addrs:
              {
                hart: 0x40400000
              }
              size_byte: 0x80
            }
          ]
          xbar: false
          stub: false
          req_fifo_pass: true
        }
        {
          name: rstmgr_aon
          type: device
          clock: clk_peri_i
          reset: rst_peri_ni
          pipeline: false
          inst_type: rstmgr
          addr_range:
          [
            {
              base_addrs:
              {
                hart: 0x40410000
              }
              size_byte: 0x80
            }
          ]
          xbar: false
          stub: false
          req_fifo_pass: true
        }
        {
          name: clkmgr_aon
          type: device
          clock: clk_peri_i
          reset: rst_peri_ni
          pipeline: false
          inst_type: clkmgr
          addr_range:
          [
            {
              base_addrs:
              {
                hart: 0x40420000
              }
              size_byte: 0x80
            }
          ]
          xbar: false
          stub: false
          req_fifo_pass: true
        }
        {
          name: pinmux_aon
          type: device
          clock: clk_peri_i
          reset: rst_peri_ni
          pipeline: false
          inst_type: pinmux
          addr_range:
          [
            {
              base_addrs:
              {
                hart: 0x40460000
              }
              size_byte: 0x1000
            }
          ]
          xbar: false
          stub: false
          req_fifo_pass: true
        }
        {
          name: otp_ctrl.core
          type: device
          clock: clk_peri_i
          reset: rst_peri_ni
          pipeline: false
          inst_type: otp_ctrl
          addr_range:
          [
            {
              base_addrs:
              {
                hart: 0x40130000
              }
              size_byte: 0x1000
            }
          ]
          xbar: false
          stub: false
          req_fifo_pass: true
        }
        {
          name: otp_macro
          type: device
          clock: clk_peri_i
          reset: rst_peri_ni
          pipeline: false
          inst_type: otp_macro
          addr_range:
          [
            {
              base_addrs:
              {
                hart: 0x40138000
              }
              size_byte: 0x20
            }
          ]
          xbar: false
          stub: false
          req_fifo_pass: true
        }
        {
          name: lc_ctrl.regs
          type: device
          clock: clk_peri_i
          reset: rst_peri_ni
          pipeline: false
          inst_type: lc_ctrl
          addr_range:
          [
            {
              base_addrs:
              {
                hart: 0x40140000
              }
              size_byte: 0x100
            }
          ]
          xbar: false
          stub: false
          req_fifo_pass: true
        }
        {
          name: sensor_ctrl_aon
          type: device
          clock: clk_peri_i
          reset: rst_peri_ni
          pipeline: false
          inst_type: sensor_ctrl
          addr_range:
          [
            {
              base_addrs:
              {
                hart: 0x40490000
              }
              size_byte: 0x80
            }
          ]
          xbar: false
          stub: false
          req_fifo_pass: true
        }
        {
          name: alert_handler
          type: device
          clock: clk_peri_i
          reset: rst_peri_ni
          pipeline: false
          inst_type: alert_handler
          addr_range:
          [
            {
              base_addrs:
              {
                hart: 0x40150000
              }
              size_byte: 0x800
            }
          ]
          xbar: false
          stub: false
          req_fifo_pass: true
        }
        {
          name: sram_ctrl_ret_aon.regs
          type: device
          clock: clk_peri_i
          reset: rst_peri_ni
          pipeline: false
          inst_type: sram_ctrl
          addr_range:
          [
            {
              base_addrs:
              {
                hart: 0x40500000
              }
              size_byte: 0x40
            }
          ]
          xbar: false
          stub: false
          req_fifo_pass: true
        }
        {
          name: sram_ctrl_ret_aon.ram
          type: device
          clock: clk_peri_i
          reset: rst_peri_ni
          pipeline: false
          inst_type: sram_ctrl
          addr_range:
          [
            {
              base_addrs:
              {
                hart: 0x40600000
              }
              size_byte: 0x1000
            }
          ]
          xbar: false
          stub: false
          req_fifo_pass: true
        }
        {
          name: aon_timer_aon
          type: device
          clock: clk_peri_i
          reset: rst_peri_ni
          pipeline: false
          inst_type: aon_timer
          addr_range:
          [
            {
              base_addrs:
              {
                hart: 0x40470000
              }
              size_byte: 0x40
            }
          ]
          xbar: false
          stub: false
          req_fifo_pass: true
        }
        {
          name: sysrst_ctrl_aon
          type: device
          clock: clk_peri_i
          reset: rst_peri_ni
          pipeline: false
          inst_type: sysrst_ctrl
          addr_range:
          [
            {
              base_addrs:
              {
                hart: 0x40430000
              }
              size_byte: 0x100
            }
          ]
          xbar: false
          stub: false
          req_fifo_pass: true
        }
        {
          name: adc_ctrl_aon
          type: device
          clock: clk_peri_i
          reset: rst_peri_ni
          pipeline: false
          inst_type: adc_ctrl
          addr_range:
          [
            {
              base_addrs:
              {
                hart: 0x40440000
              }
              size_byte: 0x80
            }
          ]
          xbar: false
          stub: false
          req_fifo_pass: true
        }
        {
          name: ast
          type: device
          clock: clk_peri_i
          reset: rst_peri_ni
          pipeline: false
          inst_type: ast
          addr_range:
          [
            {
              base_addrs:
              {
                hart: 0x40480000
              }
              size_byte: 0x400
            }
          ]
          xbar: false
          stub: true
          req_fifo_pass: true
        }
      ]
      addr_spaces:
      [
        hart
      ]
      clock: clk_peri_i
      type: xbar
      inter_signal_list:
      [
        {
          name: tl_main
          struct: tl
          package: tlul_pkg
          type: req_rsp
          act: rsp
          inst_name: peri
          width: 1
          default: ""
          top_signame: main_tl_peri
          index: -1
        }
        {
          name: tl_uart0
          struct: tl
          package: tlul_pkg
          type: req_rsp
          act: req
          inst_name: peri
          width: 1
          default: ""
          top_signame: uart0_tl
          index: -1
        }
        {
          name: tl_uart1
          struct: tl
          package: tlul_pkg
          type: req_rsp
          act: req
          inst_name: peri
          width: 1
          default: ""
          top_signame: uart1_tl
          index: -1
        }
        {
          name: tl_uart2
          struct: tl
          package: tlul_pkg
          type: req_rsp
          act: req
          inst_name: peri
          width: 1
          default: ""
          top_signame: uart2_tl
          index: -1
        }
        {
          name: tl_uart3
          struct: tl
          package: tlul_pkg
          type: req_rsp
          act: req
          inst_name: peri
          width: 1
          default: ""
          top_signame: uart3_tl
          index: -1
        }
        {
          name: tl_i2c0
          struct: tl
          package: tlul_pkg
          type: req_rsp
          act: req
          inst_name: peri
          width: 1
          default: ""
          top_signame: i2c0_tl
          index: -1
        }
        {
          name: tl_i2c1
          struct: tl
          package: tlul_pkg
          type: req_rsp
          act: req
          inst_name: peri
          width: 1
          default: ""
          top_signame: i2c1_tl
          index: -1
        }
        {
          name: tl_i2c2
          struct: tl
          package: tlul_pkg
          type: req_rsp
          act: req
          inst_name: peri
          width: 1
          default: ""
          top_signame: i2c2_tl
          index: -1
        }
        {
          name: tl_pattgen
          struct: tl
          package: tlul_pkg
          type: req_rsp
          act: req
          inst_name: peri
          width: 1
          default: ""
          top_signame: pattgen_tl
          index: -1
        }
        {
          name: tl_pwm_aon
          struct: tl
          package: tlul_pkg
          type: req_rsp
          act: req
          inst_name: peri
          width: 1
          default: ""
          top_signame: pwm_aon_tl
          index: -1
        }
        {
          name: tl_gpio
          struct: tl
          package: tlul_pkg
          type: req_rsp
          act: req
          inst_name: peri
          width: 1
          default: ""
          top_signame: gpio_tl
          index: -1
        }
        {
          name: tl_spi_device
          struct: tl
          package: tlul_pkg
          type: req_rsp
          act: req
          inst_name: peri
          width: 1
          default: ""
          top_signame: spi_device_tl
          index: -1
        }
        {
          name: tl_rv_timer
          struct: tl
          package: tlul_pkg
          type: req_rsp
          act: req
          inst_name: peri
          width: 1
          default: ""
          top_signame: rv_timer_tl
          index: -1
        }
        {
          name: tl_pwrmgr_aon
          struct: tl
          package: tlul_pkg
          type: req_rsp
          act: req
          inst_name: peri
          width: 1
          default: ""
          top_signame: pwrmgr_aon_tl
          index: -1
        }
        {
          name: tl_rstmgr_aon
          struct: tl
          package: tlul_pkg
          type: req_rsp
          act: req
          inst_name: peri
          width: 1
          default: ""
          top_signame: rstmgr_aon_tl
          index: -1
        }
        {
          name: tl_clkmgr_aon
          struct: tl
          package: tlul_pkg
          type: req_rsp
          act: req
          inst_name: peri
          width: 1
          default: ""
          top_signame: clkmgr_aon_tl
          index: -1
        }
        {
          name: tl_pinmux_aon
          struct: tl
          package: tlul_pkg
          type: req_rsp
          act: req
          inst_name: peri
          width: 1
          default: ""
          top_signame: pinmux_aon_tl
          index: -1
        }
        {
          name: tl_otp_ctrl__core
          struct: tl
          package: tlul_pkg
          type: req_rsp
          act: req
          inst_name: peri
          width: 1
          default: ""
          top_signame: otp_ctrl_core_tl
          index: -1
        }
        {
          name: tl_otp_macro
          struct: tl
          package: tlul_pkg
          type: req_rsp
          act: req
          inst_name: peri
          width: 1
          default: ""
          top_signame: otp_macro_tl
          index: -1
        }
        {
          name: tl_lc_ctrl__regs
          struct: tl
          package: tlul_pkg
          type: req_rsp
          act: req
          inst_name: peri
          width: 1
          default: ""
          top_signame: lc_ctrl_regs_tl
          index: -1
        }
        {
          name: tl_sensor_ctrl_aon
          struct: tl
          package: tlul_pkg
          type: req_rsp
          act: req
          inst_name: peri
          width: 1
          default: ""
          top_signame: sensor_ctrl_aon_tl
          index: -1
        }
        {
          name: tl_alert_handler
          struct: tl
          package: tlul_pkg
          type: req_rsp
          act: req
          inst_name: peri
          width: 1
          default: ""
          top_signame: alert_handler_tl
          index: -1
        }
        {
          name: tl_sram_ctrl_ret_aon__regs
          struct: tl
          package: tlul_pkg
          type: req_rsp
          act: req
          inst_name: peri
          width: 1
          default: ""
          top_signame: sram_ctrl_ret_aon_regs_tl
          index: -1
        }
        {
          name: tl_sram_ctrl_ret_aon__ram
          struct: tl
          package: tlul_pkg
          type: req_rsp
          act: req
          inst_name: peri
          width: 1
          default: ""
          top_signame: sram_ctrl_ret_aon_ram_tl
          index: -1
        }
        {
          name: tl_aon_timer_aon
          struct: tl
          package: tlul_pkg
          type: req_rsp
          act: req
          inst_name: peri
          width: 1
          default: ""
          top_signame: aon_timer_aon_tl
          index: -1
        }
        {
          name: tl_sysrst_ctrl_aon
          struct: tl
          package: tlul_pkg
          type: req_rsp
          act: req
          inst_name: peri
          width: 1
          default: ""
          top_signame: sysrst_ctrl_aon_tl
          index: -1
        }
        {
          name: tl_adc_ctrl_aon
          struct: tl
          package: tlul_pkg
          type: req_rsp
          act: req
          inst_name: peri
          width: 1
          default: ""
          top_signame: adc_ctrl_aon_tl
          index: -1
        }
        {
          name: tl_ast
          struct: tl
          package: tlul_pkg
          type: req_rsp
          act: req
          inst_name: peri
          width: 1
          default: ""
          external: true
          top_signame: ast_tl
          conn_type: false
          index: -1
        }
      ]
    }
  ]
  pinout:
  {
    banks:
    [
      VCC
      AVCC
      VIOA
      VIOB
    ]
    pads:
    [
      {
        name: POR_N
        type: InputStd
        bank: VCC
        connection: manual
        desc: System reset
        idx: 0
        port_type: inout
      }
      {
        name: USB_P
        type: DualBidirTol
        bank: VCC
        connection: manual
        desc: USB P signal
        idx: 1
        port_type: inout
      }
      {
        name: USB_N
        type: DualBidirTol
        bank: VCC
        connection: manual
        desc: USB N signal
        idx: 2
        port_type: inout
      }
      {
        name: CC1
        type: BidirTol
        bank: AVCC
        connection: manual
        desc: ADC input 1
        port_type: `INOUT_AI
        idx: 3
      }
      {
        name: CC2
        type: BidirTol
        bank: AVCC
        connection: manual
        desc: ADC input 2
        port_type: `INOUT_AI
        idx: 4
      }
      {
        name: FLASH_TEST_VOLT
        type: AnalogIn0
        bank: VCC
        connection: manual
        desc: Flash test voltage input
        idx: 5
        port_type: inout
      }
      {
        name: FLASH_TEST_MODE0
        type: InputStd
        bank: VCC
        connection: manual
        desc: Flash test mode signal
        idx: 6
        port_type: inout
      }
      {
        name: FLASH_TEST_MODE1
        type: InputStd
        bank: VCC
        connection: manual
        desc: Flash test mode signal
        idx: 7
        port_type: inout
      }
      {
        name: OTP_EXT_VOLT
        type: AnalogIn1
        bank: VCC
        connection: manual
        desc: OTP external voltage input
        idx: 8
        port_type: inout
      }
      {
        name: SPI_HOST_D0
        type: BidirStd
        bank: VIOA
        connection: direct
        desc: SPI host data
        idx: 9
        port_type: inout
      }
      {
        name: SPI_HOST_D1
        type: BidirStd
        bank: VIOA
        connection: direct
        desc: SPI host data
        idx: 10
        port_type: inout
      }
      {
        name: SPI_HOST_D2
        type: BidirStd
        bank: VIOA
        connection: direct
        desc: SPI host data
        idx: 11
        port_type: inout
      }
      {
        name: SPI_HOST_D3
        type: BidirStd
        bank: VIOA
        connection: direct
        desc: SPI host data
        idx: 12
        port_type: inout
      }
      {
        name: SPI_HOST_CLK
        type: BidirStd
        bank: VIOA
        connection: direct
        desc: SPI host clock
        idx: 13
        port_type: inout
      }
      {
        name: SPI_HOST_CS_L
        type: BidirStd
        bank: VIOA
        connection: direct
        desc: SPI host chip select
        idx: 14
        port_type: inout
      }
      {
        name: SPI_DEV_D0
        type: BidirStd
        bank: VIOA
        connection: direct
        desc: SPI device data
        idx: 15
        port_type: inout
      }
      {
        name: SPI_DEV_D1
        type: BidirStd
        bank: VIOA
        connection: direct
        desc: SPI device data
        idx: 16
        port_type: inout
      }
      {
        name: SPI_DEV_D2
        type: BidirStd
        bank: VIOA
        connection: direct
        desc: SPI device data
        idx: 17
        port_type: inout
      }
      {
        name: SPI_DEV_D3
        type: BidirStd
        bank: VIOA
        connection: direct
        desc: SPI device data
        idx: 18
        port_type: inout
      }
      {
        name: SPI_DEV_CLK
        type: InputStd
        bank: VIOA
        connection: direct
        desc: SPI device clock
        idx: 19
        port_type: inout
      }
      {
        name: SPI_DEV_CS_L
        type: InputStd
        bank: VIOA
        connection: direct
        desc: SPI device chip select
        idx: 20
        port_type: inout
      }
      {
        name: IOA0
        type: BidirStd
        bank: VIOA
        connection: muxed
        desc: Muxed IO pad
        idx: 0
        port_type: inout
      }
      {
        name: IOA1
        type: BidirStd
        bank: VIOA
        connection: muxed
        desc: Muxed IO pad
        idx: 1
        port_type: inout
      }
      {
        name: IOA2
        type: BidirStd
        bank: VIOA
        connection: muxed
        desc: Muxed IO pad
        port_type: `INOUT_AO
        idx: 2
      }
      {
        name: IOA3
        type: BidirStd
        bank: VIOA
        connection: muxed
        desc: Muxed IO pad
        port_type: `INOUT_AO
        idx: 3
      }
      {
        name: IOA4
        type: BidirStd
        bank: VIOA
        connection: muxed
        desc: Muxed IO pad
        idx: 4
        port_type: inout
      }
      {
        name: IOA5
        type: BidirStd
        bank: VIOA
        connection: muxed
        desc: Muxed IO pad
        idx: 5
        port_type: inout
      }
      {
        name: IOA6
        type: BidirOd
        bank: VIOA
        connection: muxed
        desc: Muxed IO pad
        idx: 6
        port_type: inout
      }
      {
        name: IOA7
        type: BidirOd
        bank: VIOA
        connection: muxed
        desc: Muxed IO pad
        idx: 7
        port_type: inout
      }
      {
        name: IOA8
        type: BidirOd
        bank: VIOA
        connection: muxed
        desc: Muxed IO pad
        idx: 8
        port_type: inout
      }
      {
        name: IOB0
        type: BidirStd
        bank: VIOB
        connection: muxed
        desc: Muxed IO pad
        idx: 9
        port_type: inout
      }
      {
        name: IOB1
        type: BidirStd
        bank: VIOB
        connection: muxed
        desc: Muxed IO pad
        idx: 10
        port_type: inout
      }
      {
        name: IOB2
        type: BidirStd
        bank: VIOB
        connection: muxed
        desc: Muxed IO pad
        idx: 11
        port_type: inout
      }
      {
        name: IOB3
        type: BidirStd
        bank: VIOB
        connection: muxed
        desc: Muxed IO pad
        idx: 12
        port_type: inout
      }
      {
        name: IOB4
        type: BidirStd
        bank: VIOB
        connection: muxed
        desc: Muxed IO pad
        idx: 13
        port_type: inout
      }
      {
        name: IOB5
        type: BidirStd
        bank: VIOB
        connection: muxed
        desc: Muxed IO pad
        idx: 14
        port_type: inout
      }
      {
        name: IOB6
        type: BidirStd
        bank: VIOB
        connection: muxed
        desc: Muxed IO pad
        idx: 15
        port_type: inout
      }
      {
        name: IOB7
        type: BidirStd
        bank: VIOB
        connection: muxed
        desc: Muxed IO pad
        idx: 16
        port_type: inout
      }
      {
        name: IOB8
        type: BidirStd
        bank: VIOB
        connection: muxed
        desc: Muxed IO pad
        idx: 17
        port_type: inout
      }
      {
        name: IOB9
        type: BidirOd
        bank: VIOB
        connection: muxed
        desc: Muxed IO pad
        idx: 18
        port_type: inout
      }
      {
        name: IOB10
        type: BidirOd
        bank: VIOB
        connection: muxed
        desc: Muxed IO pad
        idx: 19
        port_type: inout
      }
      {
        name: IOB11
        type: BidirOd
        bank: VIOB
        connection: muxed
        desc: Muxed IO pad
        idx: 20
        port_type: inout
      }
      {
        name: IOB12
        type: BidirOd
        bank: VIOB
        connection: muxed
        desc: Muxed IO pad
        idx: 21
        port_type: inout
      }
      {
        name: IOC0
        type: BidirStd
        bank: VCC
        connection: muxed
        desc: Muxed IO pad
        idx: 22
        port_type: inout
      }
      {
        name: IOC1
        type: BidirStd
        bank: VCC
        connection: muxed
        desc: Muxed IO pad
        idx: 23
        port_type: inout
      }
      {
        name: IOC2
        type: BidirStd
        bank: VCC
        connection: muxed
        desc: Muxed IO pad
        idx: 24
        port_type: inout
      }
      {
        name: IOC3
        type: BidirStd
        bank: VCC
        connection: muxed
        desc: Muxed IO pad
        idx: 25
        port_type: inout
      }
      {
        name: IOC4
        type: BidirStd
        bank: VCC
        connection: muxed
        desc: Muxed IO pad
        idx: 26
        port_type: inout
      }
      {
        name: IOC5
        type: BidirStd
        bank: VCC
        connection: muxed
        desc: Muxed IO pad
        idx: 27
        port_type: inout
      }
      {
        name: IOC6
        type: BidirStd
        bank: VCC
        connection: muxed
        desc: Muxed IO pad
        idx: 28
        port_type: inout
      }
      {
        name: IOC7
        type: BidirStd
        bank: VCC
        connection: muxed
        desc: Muxed IO pad
        idx: 29
        port_type: inout
      }
      {
        name: IOC8
        type: BidirStd
        bank: VCC
        connection: muxed
        desc: Muxed IO pad
        idx: 30
        port_type: inout
      }
      {
        name: IOC9
        type: BidirStd
        bank: VCC
        connection: muxed
        desc: Muxed IO pad
        idx: 31
        port_type: inout
      }
      {
        name: IOC10
        type: BidirOd
        bank: VCC
        connection: muxed
        desc: Muxed IO pad
        idx: 32
        port_type: inout
      }
      {
        name: IOC11
        type: BidirOd
        bank: VCC
        connection: muxed
        desc: Muxed IO pad
        idx: 33
        port_type: inout
      }
      {
        name: IOC12
        type: BidirOd
        bank: VCC
        connection: muxed
        desc: Muxed IO pad
        idx: 34
        port_type: inout
      }
      {
        name: IOR0
        type: BidirStd
        bank: VCC
        connection: muxed
        desc: Muxed IO pad
        idx: 35
        port_type: inout
      }
      {
        name: IOR1
        type: BidirStd
        bank: VCC
        connection: muxed
        desc: Muxed IO pad
        idx: 36
        port_type: inout
      }
      {
        name: IOR2
        type: BidirStd
        bank: VCC
        connection: muxed
        desc: Muxed IO pad
        idx: 37
        port_type: inout
      }
      {
        name: IOR3
        type: BidirStd
        bank: VCC
        connection: muxed
        desc: Muxed IO pad
        idx: 38
        port_type: inout
      }
      {
        name: IOR4
        type: BidirStd
        bank: VCC
        connection: muxed
        desc: Muxed IO pad
        idx: 39
        port_type: inout
      }
      {
        name: IOR5
        type: BidirStd
        bank: VCC
        connection: muxed
        desc: Muxed IO pad
        idx: 40
        port_type: inout
      }
      {
        name: IOR6
        type: BidirStd
        bank: VCC
        connection: muxed
        desc: Muxed IO pad
        idx: 41
        port_type: inout
      }
      {
        name: IOR7
        type: BidirStd
        bank: VCC
        connection: muxed
        desc: Muxed IO pad
        idx: 42
        port_type: inout
      }
      {
        name: IOR8
        type: BidirOd
        bank: VCC
        connection: direct
        desc: Dedicated sysrst_ctrl output (ec_rst_l)
        idx: 21
        port_type: inout
      }
      {
        name: IOR9
        type: BidirOd
        bank: VCC
        connection: direct
        desc: Dedicated sysrst_ctrl output (flash_wp_l))
        idx: 22
        port_type: inout
      }
      {
        name: IOR10
        type: BidirOd
        bank: VCC
        connection: muxed
        desc: Muxed IO pad
        idx: 43
        port_type: inout
      }
      {
        name: IOR11
        type: BidirOd
        bank: VCC
        connection: muxed
        desc: Muxed IO pad
        idx: 44
        port_type: inout
      }
      {
        name: IOR12
        type: BidirOd
        bank: VCC
        connection: muxed
        desc: Muxed IO pad
        idx: 45
        port_type: inout
      }
      {
        name: IOR13
        type: BidirOd
        bank: VCC
        connection: muxed
        desc: Muxed IO pad
        idx: 46
        port_type: inout
      }
    ]
  }
  pinmux:
  {
    signals:
    [
      {
        instance: usbdev
        port: usb_dp
        connection: manual
        pad: ""
        desc: ""
        attr: BidirStd
      }
      {
        instance: usbdev
        port: usb_dn
        connection: manual
        pad: ""
        desc: ""
        attr: BidirStd
      }
      {
        instance: spi_host0
        port: sck
        connection: direct
        pad: SPI_HOST_CLK
        desc: ""
        attr: BidirStd
      }
      {
        instance: spi_host0
        port: csb
        connection: direct
        pad: SPI_HOST_CS_L
        desc: ""
        attr: BidirStd
      }
      {
        instance: spi_host0
        port: sd[0]
        connection: direct
        pad: SPI_HOST_D0
        desc: ""
        attr: BidirStd
      }
      {
        instance: spi_host0
        port: sd[1]
        connection: direct
        pad: SPI_HOST_D1
        desc: ""
        attr: BidirStd
      }
      {
        instance: spi_host0
        port: sd[2]
        connection: direct
        pad: SPI_HOST_D2
        desc: ""
        attr: BidirStd
      }
      {
        instance: spi_host0
        port: sd[3]
        connection: direct
        pad: SPI_HOST_D3
        desc: ""
        attr: BidirStd
      }
      {
        instance: spi_device
        port: sck
        connection: direct
        pad: SPI_DEV_CLK
        desc: ""
        attr: InputStd
      }
      {
        instance: spi_device
        port: csb
        connection: direct
        pad: SPI_DEV_CS_L
        desc: ""
        attr: InputStd
      }
      {
        instance: spi_device
        port: sd[0]
        connection: direct
        pad: SPI_DEV_D0
        desc: ""
        attr: BidirStd
      }
      {
        instance: spi_device
        port: sd[1]
        connection: direct
        pad: SPI_DEV_D1
        desc: ""
        attr: BidirStd
      }
      {
        instance: spi_device
        port: sd[2]
        connection: direct
        pad: SPI_DEV_D2
        desc: ""
        attr: BidirStd
      }
      {
        instance: spi_device
        port: sd[3]
        connection: direct
        pad: SPI_DEV_D3
        desc: ""
        attr: BidirStd
      }
      {
        instance: gpio
        port: ""
        connection: muxed
        pad: ""
        desc: ""
        attr: ""
      }
      {
        instance: uart0
        port: ""
        connection: muxed
        pad: ""
        desc: ""
        attr: ""
      }
      {
        instance: uart1
        port: ""
        connection: muxed
        pad: ""
        desc: ""
        attr: ""
      }
      {
        instance: uart2
        port: ""
        connection: muxed
        pad: ""
        desc: ""
        attr: ""
      }
      {
        instance: uart3
        port: ""
        connection: muxed
        pad: ""
        desc: ""
        attr: ""
      }
      {
        instance: i2c0
        port: ""
        connection: muxed
        pad: ""
        desc: ""
        attr: ""
      }
      {
        instance: i2c1
        port: ""
        connection: muxed
        pad: ""
        desc: ""
        attr: ""
      }
      {
        instance: i2c2
        port: ""
        connection: muxed
        pad: ""
        desc: ""
        attr: ""
      }
      {
        instance: pattgen
        port: ""
        connection: muxed
        pad: ""
        desc: ""
        attr: ""
      }
      {
        instance: spi_device
        port: tpm_csb
        connection: muxed
        pad: ""
        desc: ""
        attr: ""
      }
      {
        instance: spi_host1
        port: ""
        connection: muxed
        pad: ""
        desc: ""
        attr: ""
      }
      {
        instance: flash_ctrl
        port: ""
        connection: muxed
        pad: ""
        desc: ""
        attr: ""
      }
      {
        instance: sensor_ctrl_aon
        port: ""
        connection: muxed
        pad: ""
        desc: ""
        attr: ""
      }
      {
        instance: pwm_aon
        port: ""
        connection: muxed
        pad: ""
        desc: ""
        attr: ""
      }
      {
        instance: otp_macro
        port: test[0]
        connection: muxed
        pad: ""
        desc: ""
        attr: ""
      }
      {
        instance: sysrst_ctrl_aon
        port: ac_present
        connection: muxed
        pad: ""
        desc: ""
        attr: ""
      }
      {
        instance: sysrst_ctrl_aon
        port: key0_in
        connection: muxed
        pad: ""
        desc: ""
        attr: ""
      }
      {
        instance: sysrst_ctrl_aon
        port: key1_in
        connection: muxed
        pad: ""
        desc: ""
        attr: ""
      }
      {
        instance: sysrst_ctrl_aon
        port: key2_in
        connection: muxed
        pad: ""
        desc: ""
        attr: ""
      }
      {
        instance: sysrst_ctrl_aon
        port: pwrb_in
        connection: muxed
        pad: ""
        desc: ""
        attr: ""
      }
      {
        instance: sysrst_ctrl_aon
        port: bat_disable
        connection: muxed
        pad: ""
        desc: ""
        attr: ""
      }
      {
        instance: sysrst_ctrl_aon
        port: ec_rst_l
        connection: direct
        pad: IOR8
        desc: ""
        attr: BidirOd
      }
      {
        instance: sysrst_ctrl_aon
        port: flash_wp_l
        connection: direct
        pad: IOR9
        desc: ""
        attr: BidirOd
      }
      {
        instance: sysrst_ctrl_aon
        port: key0_out
        connection: muxed
        pad: ""
        desc: ""
        attr: ""
      }
      {
        instance: sysrst_ctrl_aon
        port: key1_out
        connection: muxed
        pad: ""
        desc: ""
        attr: ""
      }
      {
        instance: sysrst_ctrl_aon
        port: key2_out
        connection: muxed
        pad: ""
        desc: ""
        attr: ""
      }
      {
        instance: sysrst_ctrl_aon
        port: pwrb_out
        connection: muxed
        pad: ""
        desc: ""
        attr: ""
      }
      {
        instance: sysrst_ctrl_aon
        port: lid_open
        connection: muxed
        pad: ""
        desc: ""
        attr: ""
      }
      {
        instance: sysrst_ctrl_aon
        port: z3_wakeup
        connection: muxed
        pad: ""
        desc: ""
        attr: ""
      }
      {
        instance: usbdev
        port: sense
        connection: muxed
        pad: ""
        desc: ""
        attr: ""
      }
    ]
    num_wkup_detect: 8
    wkup_cnt_width: 8
    enable_usb_wakeup: true
    enable_strap_sampling: true
    ios:
    [
      {
        name: usbdev_usb_dp
        width: 1
        type: inout
        idx: -1
        pad: ""
        attr: BidirStd
        connection: manual
        desc: ""
        glob_idx: 0
      }
      {
        name: usbdev_usb_dn
        width: 1
        type: inout
        idx: -1
        pad: ""
        attr: BidirStd
        connection: manual
        desc: ""
        glob_idx: 1
      }
      {
        name: spi_host0_sd
        width: 4
        type: inout
        idx: 0
        pad: SPI_HOST_D0
        attr: BidirStd
        connection: direct
        desc: ""
        glob_idx: 2
      }
      {
        name: spi_host0_sd
        width: 4
        type: inout
        idx: 1
        pad: SPI_HOST_D1
        attr: BidirStd
        connection: direct
        desc: ""
        glob_idx: 3
      }
      {
        name: spi_host0_sd
        width: 4
        type: inout
        idx: 2
        pad: SPI_HOST_D2
        attr: BidirStd
        connection: direct
        desc: ""
        glob_idx: 4
      }
      {
        name: spi_host0_sd
        width: 4
        type: inout
        idx: 3
        pad: SPI_HOST_D3
        attr: BidirStd
        connection: direct
        desc: ""
        glob_idx: 5
      }
      {
        name: spi_device_sd
        width: 4
        type: inout
        idx: 0
        pad: SPI_DEV_D0
        attr: BidirStd
        connection: direct
        desc: ""
        glob_idx: 6
      }
      {
        name: spi_device_sd
        width: 4
        type: inout
        idx: 1
        pad: SPI_DEV_D1
        attr: BidirStd
        connection: direct
        desc: ""
        glob_idx: 7
      }
      {
        name: spi_device_sd
        width: 4
        type: inout
        idx: 2
        pad: SPI_DEV_D2
        attr: BidirStd
        connection: direct
        desc: ""
        glob_idx: 8
      }
      {
        name: spi_device_sd
        width: 4
        type: inout
        idx: 3
        pad: SPI_DEV_D3
        attr: BidirStd
        connection: direct
        desc: ""
        glob_idx: 9
      }
      {
        name: gpio_gpio
        width: 32
        type: inout
        idx: 0
        pad: ""
        attr: ""
        connection: muxed
        desc: ""
        glob_idx: 0
      }
      {
        name: gpio_gpio
        width: 32
        type: inout
        idx: 1
        pad: ""
        attr: ""
        connection: muxed
        desc: ""
        glob_idx: 1
      }
      {
        name: gpio_gpio
        width: 32
        type: inout
        idx: 2
        pad: ""
        attr: ""
        connection: muxed
        desc: ""
        glob_idx: 2
      }
      {
        name: gpio_gpio
        width: 32
        type: inout
        idx: 3
        pad: ""
        attr: ""
        connection: muxed
        desc: ""
        glob_idx: 3
      }
      {
        name: gpio_gpio
        width: 32
        type: inout
        idx: 4
        pad: ""
        attr: ""
        connection: muxed
        desc: ""
        glob_idx: 4
      }
      {
        name: gpio_gpio
        width: 32
        type: inout
        idx: 5
        pad: ""
        attr: ""
        connection: muxed
        desc: ""
        glob_idx: 5
      }
      {
        name: gpio_gpio
        width: 32
        type: inout
        idx: 6
        pad: ""
        attr: ""
        connection: muxed
        desc: ""
        glob_idx: 6
      }
      {
        name: gpio_gpio
        width: 32
        type: inout
        idx: 7
        pad: ""
        attr: ""
        connection: muxed
        desc: ""
        glob_idx: 7
      }
      {
        name: gpio_gpio
        width: 32
        type: inout
        idx: 8
        pad: ""
        attr: ""
        connection: muxed
        desc: ""
        glob_idx: 8
      }
      {
        name: gpio_gpio
        width: 32
        type: inout
        idx: 9
        pad: ""
        attr: ""
        connection: muxed
        desc: ""
        glob_idx: 9
      }
      {
        name: gpio_gpio
        width: 32
        type: inout
        idx: 10
        pad: ""
        attr: ""
        connection: muxed
        desc: ""
        glob_idx: 10
      }
      {
        name: gpio_gpio
        width: 32
        type: inout
        idx: 11
        pad: ""
        attr: ""
        connection: muxed
        desc: ""
        glob_idx: 11
      }
      {
        name: gpio_gpio
        width: 32
        type: inout
        idx: 12
        pad: ""
        attr: ""
        connection: muxed
        desc: ""
        glob_idx: 12
      }
      {
        name: gpio_gpio
        width: 32
        type: inout
        idx: 13
        pad: ""
        attr: ""
        connection: muxed
        desc: ""
        glob_idx: 13
      }
      {
        name: gpio_gpio
        width: 32
        type: inout
        idx: 14
        pad: ""
        attr: ""
        connection: muxed
        desc: ""
        glob_idx: 14
      }
      {
        name: gpio_gpio
        width: 32
        type: inout
        idx: 15
        pad: ""
        attr: ""
        connection: muxed
        desc: ""
        glob_idx: 15
      }
      {
        name: gpio_gpio
        width: 32
        type: inout
        idx: 16
        pad: ""
        attr: ""
        connection: muxed
        desc: ""
        glob_idx: 16
      }
      {
        name: gpio_gpio
        width: 32
        type: inout
        idx: 17
        pad: ""
        attr: ""
        connection: muxed
        desc: ""
        glob_idx: 17
      }
      {
        name: gpio_gpio
        width: 32
        type: inout
        idx: 18
        pad: ""
        attr: ""
        connection: muxed
        desc: ""
        glob_idx: 18
      }
      {
        name: gpio_gpio
        width: 32
        type: inout
        idx: 19
        pad: ""
        attr: ""
        connection: muxed
        desc: ""
        glob_idx: 19
      }
      {
        name: gpio_gpio
        width: 32
        type: inout
        idx: 20
        pad: ""
        attr: ""
        connection: muxed
        desc: ""
        glob_idx: 20
      }
      {
        name: gpio_gpio
        width: 32
        type: inout
        idx: 21
        pad: ""
        attr: ""
        connection: muxed
        desc: ""
        glob_idx: 21
      }
      {
        name: gpio_gpio
        width: 32
        type: inout
        idx: 22
        pad: ""
        attr: ""
        connection: muxed
        desc: ""
        glob_idx: 22
      }
      {
        name: gpio_gpio
        width: 32
        type: inout
        idx: 23
        pad: ""
        attr: ""
        connection: muxed
        desc: ""
        glob_idx: 23
      }
      {
        name: gpio_gpio
        width: 32
        type: inout
        idx: 24
        pad: ""
        attr: ""
        connection: muxed
        desc: ""
        glob_idx: 24
      }
      {
        name: gpio_gpio
        width: 32
        type: inout
        idx: 25
        pad: ""
        attr: ""
        connection: muxed
        desc: ""
        glob_idx: 25
      }
      {
        name: gpio_gpio
        width: 32
        type: inout
        idx: 26
        pad: ""
        attr: ""
        connection: muxed
        desc: ""
        glob_idx: 26
      }
      {
        name: gpio_gpio
        width: 32
        type: inout
        idx: 27
        pad: ""
        attr: ""
        connection: muxed
        desc: ""
        glob_idx: 27
      }
      {
        name: gpio_gpio
        width: 32
        type: inout
        idx: 28
        pad: ""
        attr: ""
        connection: muxed
        desc: ""
        glob_idx: 28
      }
      {
        name: gpio_gpio
        width: 32
        type: inout
        idx: 29
        pad: ""
        attr: ""
        connection: muxed
        desc: ""
        glob_idx: 29
      }
      {
        name: gpio_gpio
        width: 32
        type: inout
        idx: 30
        pad: ""
        attr: ""
        connection: muxed
        desc: ""
        glob_idx: 30
      }
      {
        name: gpio_gpio
        width: 32
        type: inout
        idx: 31
        pad: ""
        attr: ""
        connection: muxed
        desc: ""
        glob_idx: 31
      }
      {
        name: i2c0_sda
        width: 1
        type: inout
        idx: -1
        pad: ""
        attr: ""
        connection: muxed
        desc: ""
        glob_idx: 32
      }
      {
        name: i2c0_scl
        width: 1
        type: inout
        idx: -1
        pad: ""
        attr: ""
        connection: muxed
        desc: ""
        glob_idx: 33
      }
      {
        name: i2c1_sda
        width: 1
        type: inout
        idx: -1
        pad: ""
        attr: ""
        connection: muxed
        desc: ""
        glob_idx: 34
      }
      {
        name: i2c1_scl
        width: 1
        type: inout
        idx: -1
        pad: ""
        attr: ""
        connection: muxed
        desc: ""
        glob_idx: 35
      }
      {
        name: i2c2_sda
        width: 1
        type: inout
        idx: -1
        pad: ""
        attr: ""
        connection: muxed
        desc: ""
        glob_idx: 36
      }
      {
        name: i2c2_scl
        width: 1
        type: inout
        idx: -1
        pad: ""
        attr: ""
        connection: muxed
        desc: ""
        glob_idx: 37
      }
      {
        name: spi_host1_sd
        width: 4
        type: inout
        idx: 0
        pad: ""
        attr: ""
        connection: muxed
        desc: ""
        glob_idx: 38
      }
      {
        name: spi_host1_sd
        width: 4
        type: inout
        idx: 1
        pad: ""
        attr: ""
        connection: muxed
        desc: ""
        glob_idx: 39
      }
      {
        name: spi_host1_sd
        width: 4
        type: inout
        idx: 2
        pad: ""
        attr: ""
        connection: muxed
        desc: ""
        glob_idx: 40
      }
      {
        name: spi_host1_sd
        width: 4
        type: inout
        idx: 3
        pad: ""
        attr: ""
        connection: muxed
        desc: ""
        glob_idx: 41
      }
      {
        name: sysrst_ctrl_aon_ec_rst_l
        width: 1
        type: inout
        idx: -1
        pad: IOR8
        attr: BidirOd
        connection: direct
        desc: ""
        glob_idx: 10
      }
      {
        name: sysrst_ctrl_aon_flash_wp_l
        width: 1
        type: inout
        idx: -1
        pad: IOR9
        attr: BidirOd
        connection: direct
        desc: ""
        glob_idx: 11
      }
      {
        name: spi_device_sck
        width: 1
        type: input
        idx: -1
        pad: SPI_DEV_CLK
        attr: InputStd
        connection: direct
        desc: ""
        glob_idx: 12
      }
      {
        name: spi_device_csb
        width: 1
        type: input
        idx: -1
        pad: SPI_DEV_CS_L
        attr: InputStd
        connection: direct
        desc: ""
        glob_idx: 13
      }
      {
        name: uart0_rx
        width: 1
        type: input
        idx: -1
        pad: ""
        attr: ""
        connection: muxed
        desc: ""
        glob_idx: 42
      }
      {
        name: uart1_rx
        width: 1
        type: input
        idx: -1
        pad: ""
        attr: ""
        connection: muxed
        desc: ""
        glob_idx: 43
      }
      {
        name: uart2_rx
        width: 1
        type: input
        idx: -1
        pad: ""
        attr: ""
        connection: muxed
        desc: ""
        glob_idx: 44
      }
      {
        name: uart3_rx
        width: 1
        type: input
        idx: -1
        pad: ""
        attr: ""
        connection: muxed
        desc: ""
        glob_idx: 45
      }
      {
        name: spi_device_tpm_csb
        width: 1
        type: input
        idx: -1
        pad: ""
        attr: ""
        connection: muxed
        desc: ""
        glob_idx: 46
      }
      {
        name: flash_ctrl_tck
        width: 1
        type: input
        idx: -1
        pad: ""
        attr: ""
        connection: muxed
        desc: ""
        glob_idx: 47
      }
      {
        name: flash_ctrl_tms
        width: 1
        type: input
        idx: -1
        pad: ""
        attr: ""
        connection: muxed
        desc: ""
        glob_idx: 48
      }
      {
        name: flash_ctrl_tdi
        width: 1
        type: input
        idx: -1
        pad: ""
        attr: ""
        connection: muxed
        desc: ""
        glob_idx: 49
      }
      {
        name: sysrst_ctrl_aon_ac_present
        width: 1
        type: input
        idx: -1
        pad: ""
        attr: ""
        connection: muxed
        desc: ""
        glob_idx: 50
      }
      {
        name: sysrst_ctrl_aon_key0_in
        width: 1
        type: input
        idx: -1
        pad: ""
        attr: ""
        connection: muxed
        desc: ""
        glob_idx: 51
      }
      {
        name: sysrst_ctrl_aon_key1_in
        width: 1
        type: input
        idx: -1
        pad: ""
        attr: ""
        connection: muxed
        desc: ""
        glob_idx: 52
      }
      {
        name: sysrst_ctrl_aon_key2_in
        width: 1
        type: input
        idx: -1
        pad: ""
        attr: ""
        connection: muxed
        desc: ""
        glob_idx: 53
      }
      {
        name: sysrst_ctrl_aon_pwrb_in
        width: 1
        type: input
        idx: -1
        pad: ""
        attr: ""
        connection: muxed
        desc: ""
        glob_idx: 54
      }
      {
        name: sysrst_ctrl_aon_lid_open
        width: 1
        type: input
        idx: -1
        pad: ""
        attr: ""
        connection: muxed
        desc: ""
        glob_idx: 55
      }
      {
        name: usbdev_sense
        width: 1
        type: input
        idx: -1
        pad: ""
        attr: ""
        connection: muxed
        desc: ""
        glob_idx: 56
      }
      {
        name: spi_host0_sck
        width: 1
        type: output
        idx: -1
        pad: SPI_HOST_CLK
        attr: BidirStd
        connection: direct
        desc: ""
        glob_idx: 14
      }
      {
        name: spi_host0_csb
        width: 1
        type: output
        idx: -1
        pad: SPI_HOST_CS_L
        attr: BidirStd
        connection: direct
        desc: ""
        glob_idx: 15
      }
      {
        name: uart0_tx
        width: 1
        type: output
        idx: -1
        pad: ""
        attr: ""
        connection: muxed
        desc: ""
        glob_idx: 42
      }
      {
        name: uart1_tx
        width: 1
        type: output
        idx: -1
        pad: ""
        attr: ""
        connection: muxed
        desc: ""
        glob_idx: 43
      }
      {
        name: uart2_tx
        width: 1
        type: output
        idx: -1
        pad: ""
        attr: ""
        connection: muxed
        desc: ""
        glob_idx: 44
      }
      {
        name: uart3_tx
        width: 1
        type: output
        idx: -1
        pad: ""
        attr: ""
        connection: muxed
        desc: ""
        glob_idx: 45
      }
      {
        name: pattgen_pda0_tx
        width: 1
        type: output
        idx: -1
        pad: ""
        attr: ""
        connection: muxed
        desc: ""
        glob_idx: 46
      }
      {
        name: pattgen_pcl0_tx
        width: 1
        type: output
        idx: -1
        pad: ""
        attr: ""
        connection: muxed
        desc: ""
        glob_idx: 47
      }
      {
        name: pattgen_pda1_tx
        width: 1
        type: output
        idx: -1
        pad: ""
        attr: ""
        connection: muxed
        desc: ""
        glob_idx: 48
      }
      {
        name: pattgen_pcl1_tx
        width: 1
        type: output
        idx: -1
        pad: ""
        attr: ""
        connection: muxed
        desc: ""
        glob_idx: 49
      }
      {
        name: spi_host1_sck
        width: 1
        type: output
        idx: -1
        pad: ""
        attr: ""
        connection: muxed
        desc: ""
        glob_idx: 50
      }
      {
        name: spi_host1_csb
        width: 1
        type: output
        idx: -1
        pad: ""
        attr: ""
        connection: muxed
        desc: ""
        glob_idx: 51
      }
      {
        name: flash_ctrl_tdo
        width: 1
        type: output
        idx: -1
        pad: ""
        attr: ""
        connection: muxed
        desc: ""
        glob_idx: 52
      }
      {
        name: sensor_ctrl_aon_ast_debug_out
        width: 9
        type: output
        idx: 0
        pad: ""
        attr: ""
        connection: muxed
        desc: ""
        glob_idx: 53
      }
      {
        name: sensor_ctrl_aon_ast_debug_out
        width: 9
        type: output
        idx: 1
        pad: ""
        attr: ""
        connection: muxed
        desc: ""
        glob_idx: 54
      }
      {
        name: sensor_ctrl_aon_ast_debug_out
        width: 9
        type: output
        idx: 2
        pad: ""
        attr: ""
        connection: muxed
        desc: ""
        glob_idx: 55
      }
      {
        name: sensor_ctrl_aon_ast_debug_out
        width: 9
        type: output
        idx: 3
        pad: ""
        attr: ""
        connection: muxed
        desc: ""
        glob_idx: 56
      }
      {
        name: sensor_ctrl_aon_ast_debug_out
        width: 9
        type: output
        idx: 4
        pad: ""
        attr: ""
        connection: muxed
        desc: ""
        glob_idx: 57
      }
      {
        name: sensor_ctrl_aon_ast_debug_out
        width: 9
        type: output
        idx: 5
        pad: ""
        attr: ""
        connection: muxed
        desc: ""
        glob_idx: 58
      }
      {
        name: sensor_ctrl_aon_ast_debug_out
        width: 9
        type: output
        idx: 6
        pad: ""
        attr: ""
        connection: muxed
        desc: ""
        glob_idx: 59
      }
      {
        name: sensor_ctrl_aon_ast_debug_out
        width: 9
        type: output
        idx: 7
        pad: ""
        attr: ""
        connection: muxed
        desc: ""
        glob_idx: 60
      }
      {
        name: sensor_ctrl_aon_ast_debug_out
        width: 9
        type: output
        idx: 8
        pad: ""
        attr: ""
        connection: muxed
        desc: ""
        glob_idx: 61
      }
      {
        name: pwm_aon_pwm
        width: 6
        type: output
        idx: 0
        pad: ""
        attr: ""
        connection: muxed
        desc: ""
        glob_idx: 62
      }
      {
        name: pwm_aon_pwm
        width: 6
        type: output
        idx: 1
        pad: ""
        attr: ""
        connection: muxed
        desc: ""
        glob_idx: 63
      }
      {
        name: pwm_aon_pwm
        width: 6
        type: output
        idx: 2
        pad: ""
        attr: ""
        connection: muxed
        desc: ""
        glob_idx: 64
      }
      {
        name: pwm_aon_pwm
        width: 6
        type: output
        idx: 3
        pad: ""
        attr: ""
        connection: muxed
        desc: ""
        glob_idx: 65
      }
      {
        name: pwm_aon_pwm
        width: 6
        type: output
        idx: 4
        pad: ""
        attr: ""
        connection: muxed
        desc: ""
        glob_idx: 66
      }
      {
        name: pwm_aon_pwm
        width: 6
        type: output
        idx: 5
        pad: ""
        attr: ""
        connection: muxed
        desc: ""
        glob_idx: 67
      }
      {
        name: otp_macro_test
        width: 8
        type: output
        idx: 0
        pad: ""
        attr: ""
        connection: muxed
        desc: ""
        glob_idx: 68
      }
      {
        name: sysrst_ctrl_aon_bat_disable
        width: 1
        type: output
        idx: -1
        pad: ""
        attr: ""
        connection: muxed
        desc: ""
        glob_idx: 69
      }
      {
        name: sysrst_ctrl_aon_key0_out
        width: 1
        type: output
        idx: -1
        pad: ""
        attr: ""
        connection: muxed
        desc: ""
        glob_idx: 70
      }
      {
        name: sysrst_ctrl_aon_key1_out
        width: 1
        type: output
        idx: -1
        pad: ""
        attr: ""
        connection: muxed
        desc: ""
        glob_idx: 71
      }
      {
        name: sysrst_ctrl_aon_key2_out
        width: 1
        type: output
        idx: -1
        pad: ""
        attr: ""
        connection: muxed
        desc: ""
        glob_idx: 72
      }
      {
        name: sysrst_ctrl_aon_pwrb_out
        width: 1
        type: output
        idx: -1
        pad: ""
        attr: ""
        connection: muxed
        desc: ""
        glob_idx: 73
      }
      {
        name: sysrst_ctrl_aon_z3_wakeup
        width: 1
        type: output
        idx: -1
        pad: ""
        attr: ""
        connection: muxed
        desc: ""
        glob_idx: 74
      }
    ]
    io_counts:
    {
      dedicated:
      {
        inouts: 12
        inputs: 2
        outputs: 2
        pads: 23
      }
      muxed:
      {
        inouts: 42
        inputs: 15
        outputs: 33
        pads: 47
      }
    }
  }
  targets:
  [
    {
      name: asic
      pinout:
      {
        remove_ports: []
        remove_pads: []
        add_pads: []
      }
      pinmux:
      {
        special_signals:
        [
          {
            name: tap0
            pad: IOC8
            desc: TAP strap signal.
            idx: 30
          }
          {
            name: tap1
            pad: IOC5
            desc: TAP strap signal.
            idx: 27
          }
          {
            name: dft0
            pad: IOR5
            desc: DFT strap signal.
            idx: 40
          }
          {
            name: dft1
            pad: IOR7
            desc: DFT strap signal.
            idx: 42
          }
          {
            name: tck
            pad: IOR3
            desc: JTAG tck signal.
            idx: 38
          }
          {
            name: tms
            pad: IOR0
            desc: JTAG tms signal.
            idx: 35
          }
          {
            name: trst_n
            pad: IOR4
            desc: JTAG trst_n signal.
            idx: 39
          }
          {
            name: tdi
            pad: IOR2
            desc: JTAG tdi signal.
            idx: 37
          }
          {
            name: tdo
            pad: IOR1
            desc: JTAG tdo signal.
            idx: 36
          }
        ]
      }
    }
    {
      name: cw310
      pinout:
      {
        remove_ports: []
        remove_pads:
        [
          CC1
          CC2
          FLASH_TEST_VOLT
          OTP_EXT_VOLT
          FLASH_TEST_MODE0
          FLASH_TEST_MODE1
          USB_P
          USB_N
        ]
        add_pads:
        [
          {
            name: IO_CLK
            type: InputStd
            bank: VCC
            connection: manual
            desc: Extra clock input for FPGA target
            port_type: inout
          }
          {
            name: POR_BUTTON_N
            type: InputStd
            bank: VCC
            connection: manual
            desc: Power-on reset button input
            port_type: inout
          }
          {
            name: IO_USB_CONNECT
            type: BidirStd
            bank: VCC
            connection: manual
            desc: Manual USB UPHY signal for FPGA target
            port_type: inout
          }
          {
            name: IO_USB_DP_TX
            type: BidirStd
            bank: VCC
            connection: manual
            desc: Manual USB UPHY signal for FPGA target
            port_type: inout
          }
          {
            name: IO_USB_DN_TX
            type: BidirStd
            bank: VCC
            connection: manual
            desc: Manual USB UPHY signal for FPGA target
            port_type: inout
          }
          {
            name: IO_USB_D_RX
            type: BidirStd
            bank: VCC
            connection: manual
            desc: Manual USB UPHY signal for FPGA target
            port_type: inout
          }
          {
            name: IO_USB_DP_RX
            type: BidirStd
            bank: VCC
            connection: manual
            desc: Manual USB UPHY signal for FPGA target
            port_type: inout
          }
          {
            name: IO_USB_DN_RX
            type: BidirStd
            bank: VCC
            connection: manual
            desc: Manual USB UPHY signal for FPGA target
            port_type: inout
          }
          {
            name: IO_USB_OE_N
            type: BidirStd
            bank: VCC
            connection: manual
            desc: Manual USB UPHY signal for FPGA target
            port_type: inout
          }
          {
            name: IO_USB_SPEED
            type: BidirStd
            bank: VCC
            connection: manual
            desc: Manual USB UPHY signal for FPGA target
            port_type: inout
          }
          {
            name: IO_USB_SUSPEND
            type: BidirStd
            bank: VCC
            connection: manual
            desc: Manual USB UPHY signal for FPGA target
            port_type: inout
          }
          {
            name: IO_CLKOUT
            type: BidirStd
            bank: VCC
            connection: manual
            desc: Manual clock output for SCA setup
            port_type: inout
          }
          {
            name: IO_TRIGGER
            type: BidirStd
            bank: VCC
            connection: manual
            desc: Manual trigger output for SCA setup
            port_type: inout
          }
        ]
      }
      pinmux:
      {
        special_signals:
        [
          {
            name: tap0
            pad: IOC8
            desc: TAP strap signal.
            idx: 30
          }
          {
            name: tap1
            pad: IOC5
            desc: TAP strap signal.
            idx: 27
          }
          {
            name: dft0
            pad: IOR5
            desc: DFT strap signal.
            idx: 40
          }
          {
            name: dft1
            pad: IOR7
            desc: DFT strap signal.
            idx: 42
          }
          {
            name: tck
            pad: IOR3
            desc: JTAG tck signal.
            idx: 38
          }
          {
            name: tms
            pad: IOR0
            desc: JTAG tms signal.
            idx: 35
          }
          {
            name: trst_n
            pad: IOR4
            desc: JTAG trst_n signal.
            idx: 39
          }
          {
            name: tdi
            pad: IOR2
            desc: JTAG tdi signal.
            idx: 37
          }
          {
            name: tdo
            pad: IOR1
            desc: JTAG tdo signal.
            idx: 36
          }
        ]
      }
    }
    {
      name: cw340
      pinout:
      {
        remove_ports: []
        remove_pads:
        [
          CC1
          CC2
          FLASH_TEST_VOLT
          OTP_EXT_VOLT
          FLASH_TEST_MODE0
          FLASH_TEST_MODE1
          USB_P
          USB_N
        ]
        add_pads:
        [
          {
            name: IO_CLK
            type: InputStd
            bank: VCC
            connection: manual
            desc: Extra clock input for FPGA target
            port_type: inout
          }
          {
            name: IO_USB_CONNECT
            type: BidirStd
            bank: VCC
            connection: manual
            desc: Manual USB UPHY signal for FPGA target
            port_type: inout
          }
          {
            name: IO_USB_DP_TX
            type: BidirStd
            bank: VCC
            connection: manual
            desc: Manual USB UPHY signal for FPGA target
            port_type: inout
          }
          {
            name: IO_USB_DN_TX
            type: BidirStd
            bank: VCC
            connection: manual
            desc: Manual USB UPHY signal for FPGA target
            port_type: inout
          }
          {
            name: IO_USB_D_RX
            type: BidirStd
            bank: VCC
            connection: manual
            desc: Manual USB UPHY signal for FPGA target
            port_type: inout
          }
          {
            name: IO_USB_DP_RX
            type: BidirStd
            bank: VCC
            connection: manual
            desc: Manual USB UPHY signal for FPGA target
            port_type: inout
          }
          {
            name: IO_USB_DN_RX
            type: BidirStd
            bank: VCC
            connection: manual
            desc: Manual USB UPHY signal for FPGA target
            port_type: inout
          }
          {
            name: IO_USB_OE_N
            type: BidirStd
            bank: VCC
            connection: manual
            desc: Manual USB UPHY signal for FPGA target
            port_type: inout
          }
          {
            name: IO_USB_SPEED
            type: BidirStd
            bank: VCC
            connection: manual
            desc: Manual USB UPHY signal for FPGA target
            port_type: inout
          }
          {
            name: IO_USB_SUSPEND
            type: BidirStd
            bank: VCC
            connection: manual
            desc: Manual USB UPHY signal for FPGA target
            port_type: inout
          }
          {
            name: IO_CLKOUT
            type: BidirStd
            bank: VCC
            connection: manual
            desc: Manual clock output for SCA setup
            port_type: inout
          }
          {
            name: IO_TRIGGER
            type: BidirStd
            bank: VCC
            connection: manual
            desc: Manual trigger output for SCA setup
            port_type: inout
          }
        ]
      }
      pinmux:
      {
        special_signals:
        [
          {
            name: tap0
            pad: IOC8
            desc: TAP strap signal.
            idx: 30
          }
          {
            name: tap1
            pad: IOC5
            desc: TAP strap signal.
            idx: 27
          }
          {
            name: dft0
            pad: IOR5
            desc: DFT strap signal.
            idx: 40
          }
          {
            name: dft1
            pad: IOR7
            desc: DFT strap signal.
            idx: 42
          }
          {
            name: tck
            pad: IOR3
            desc: JTAG tck signal.
            idx: 38
          }
          {
            name: tms
            pad: IOR0
            desc: JTAG tms signal.
            idx: 35
          }
          {
            name: trst_n
            pad: IOR4
            desc: JTAG trst_n signal.
            idx: 39
          }
          {
            name: tdi
            pad: IOR2
            desc: JTAG tdi signal.
            idx: 37
          }
          {
            name: tdo
            pad: IOR1
            desc: JTAG tdo signal.
            idx: 36
          }
        ]
      }
    }
  ]
  incoming_alert: {}
  incoming_interrupt: {}
  exported_clks: {}
  wakeups:
  [
    {
      name: wkup_req
      width: "1"
      module: sysrst_ctrl_aon
    }
    {
      name: wkup_req
      width: "1"
      module: adc_ctrl_aon
    }
    {
      name: pin_wkup_req
      width: "1"
      module: pinmux_aon
    }
    {
      name: usb_wkup_req
      width: "1"
      module: pinmux_aon
    }
    {
      name: wkup_req
      width: "1"
      module: aon_timer_aon
    }
    {
      name: wkup_req
      width: "1"
      module: sensor_ctrl_aon
    }
  ]
  unmanaged_resets: {}
  exported_rsts: {}
  alert:
  [
    {
      name: uart0_fatal_fault
      width: 1
      type: alert
      async: "1"
      module_name: uart0
      desc: uart0 fatal_fault alert
      lpg_name: peri_lc_io_div4_0
      lpg_idx: 0
    }
    {
      name: uart1_fatal_fault
      width: 1
      type: alert
      async: "1"
      module_name: uart1
      desc: uart1 fatal_fault alert
      lpg_name: peri_lc_io_div4_0
      lpg_idx: 0
    }
    {
      name: uart2_fatal_fault
      width: 1
      type: alert
      async: "1"
      module_name: uart2
      desc: uart2 fatal_fault alert
      lpg_name: peri_lc_io_div4_0
      lpg_idx: 0
    }
    {
      name: uart3_fatal_fault
      width: 1
      type: alert
      async: "1"
      module_name: uart3
      desc: uart3 fatal_fault alert
      lpg_name: peri_lc_io_div4_0
      lpg_idx: 0
    }
    {
      name: gpio_fatal_fault
      width: 1
      type: alert
      async: "1"
      module_name: gpio
      desc: gpio fatal_fault alert
      lpg_name: peri_lc_io_div4_0
      lpg_idx: 0
    }
    {
      name: spi_device_fatal_fault
      width: 1
      type: alert
      async: "1"
      module_name: spi_device
      desc: spi_device fatal_fault alert
      lpg_name: peri_spi_device_0
      lpg_idx: 1
    }
    {
      name: i2c0_fatal_fault
      width: 1
      type: alert
      async: "1"
      module_name: i2c0
      desc: i2c0 fatal_fault alert
      lpg_name: peri_i2c0_0
      lpg_idx: 2
    }
    {
      name: i2c1_fatal_fault
      width: 1
      type: alert
      async: "1"
      module_name: i2c1
      desc: i2c1 fatal_fault alert
      lpg_name: peri_i2c1_0
      lpg_idx: 3
    }
    {
      name: i2c2_fatal_fault
      width: 1
      type: alert
      async: "1"
      module_name: i2c2
      desc: i2c2 fatal_fault alert
      lpg_name: peri_i2c2_0
      lpg_idx: 4
    }
    {
      name: pattgen_fatal_fault
      width: 1
      type: alert
      async: "1"
      module_name: pattgen
      desc: pattgen fatal_fault alert
      lpg_name: peri_lc_io_div4_0
      lpg_idx: 0
    }
    {
      name: rv_timer_fatal_fault
      width: 1
      type: alert
      async: "1"
      module_name: rv_timer
      desc: rv_timer fatal_fault alert
      lpg_name: timers_lc_io_div4_0
      lpg_idx: 5
    }
    {
      name: otp_ctrl_fatal_macro_error
      width: 1
      type: alert
      async: "1"
      module_name: otp_ctrl
      desc: otp_ctrl fatal_macro_error alert
      lpg_name: secure_lc_io_div4_0
      lpg_idx: 6
    }
    {
      name: otp_ctrl_fatal_check_error
      width: 1
      type: alert
      async: "1"
      module_name: otp_ctrl
      desc: otp_ctrl fatal_check_error alert
      lpg_name: secure_lc_io_div4_0
      lpg_idx: 6
    }
    {
      name: otp_ctrl_fatal_bus_integ_error
      width: 1
      type: alert
      async: "1"
      module_name: otp_ctrl
      desc: otp_ctrl fatal_bus_integ_error alert
      lpg_name: secure_lc_io_div4_0
      lpg_idx: 6
    }
    {
      name: otp_ctrl_fatal_prim_otp_alert
      width: 1
      type: alert
      async: "1"
      module_name: otp_ctrl
      desc: otp_ctrl fatal_prim_otp_alert alert
      lpg_name: secure_lc_io_div4_0
      lpg_idx: 6
    }
    {
      name: otp_ctrl_recov_prim_otp_alert
      width: 1
      type: alert
      async: "1"
      module_name: otp_ctrl
      desc: otp_ctrl recov_prim_otp_alert alert
      lpg_name: secure_lc_io_div4_0
      lpg_idx: 6
    }
    {
      name: lc_ctrl_fatal_prog_error
      width: 1
      type: alert
      async: "1"
      module_name: lc_ctrl
      desc: lc_ctrl fatal_prog_error alert
      lpg_name: secure_lc_io_div4_0
      lpg_idx: 6
    }
    {
      name: lc_ctrl_fatal_state_error
      width: 1
      type: alert
      async: "1"
      module_name: lc_ctrl
      desc: lc_ctrl fatal_state_error alert
      lpg_name: secure_lc_io_div4_0
      lpg_idx: 6
    }
    {
      name: lc_ctrl_fatal_bus_integ_error
      width: 1
      type: alert
      async: "1"
      module_name: lc_ctrl
      desc: lc_ctrl fatal_bus_integ_error alert
      lpg_name: secure_lc_io_div4_0
      lpg_idx: 6
    }
    {
      name: spi_host0_fatal_fault
      width: 1
      type: alert
      async: "1"
      module_name: spi_host0
      desc: spi_host0 fatal_fault alert
      lpg_name: peri_spi_host0_0
      lpg_idx: 7
    }
    {
      name: spi_host1_fatal_fault
      width: 1
      type: alert
      async: "1"
      module_name: spi_host1
      desc: spi_host1 fatal_fault alert
      lpg_name: peri_spi_host1_0
      lpg_idx: 8
    }
    {
      name: usbdev_fatal_fault
      width: 1
      type: alert
      async: "1"
      module_name: usbdev
      desc: usbdev fatal_fault alert
      lpg_name: peri_usb_0
      lpg_idx: 9
    }
    {
      name: pwrmgr_aon_fatal_fault
      width: 1
      type: alert
      async: "1"
      module_name: pwrmgr_aon
      desc: pwrmgr_aon fatal_fault alert
      lpg_name: powerup_por_io_div4_Aon
      lpg_idx: 10
    }
    {
      name: rstmgr_aon_fatal_fault
      width: 1
      type: alert
      async: "1"
      module_name: rstmgr_aon
      desc: rstmgr_aon fatal_fault alert
      lpg_name: powerup_lc_io_div4_Aon
      lpg_idx: 11
    }
    {
      name: rstmgr_aon_fatal_cnsty_fault
      width: 1
      type: alert
      async: "1"
      module_name: rstmgr_aon
      desc: rstmgr_aon fatal_cnsty_fault alert
      lpg_name: powerup_lc_io_div4_Aon
      lpg_idx: 11
    }
    {
      name: clkmgr_aon_recov_fault
      width: 1
      type: alert
      async: "1"
      module_name: clkmgr_aon
      desc: clkmgr_aon recov_fault alert
      lpg_name: powerup_lc_io_div4_Aon
      lpg_idx: 11
    }
    {
      name: clkmgr_aon_fatal_fault
      width: 1
      type: alert
      async: "1"
      module_name: clkmgr_aon
      desc: clkmgr_aon fatal_fault alert
      lpg_name: powerup_lc_io_div4_Aon
      lpg_idx: 11
    }
    {
      name: sysrst_ctrl_aon_fatal_fault
      width: 1
      type: alert
      async: "1"
      module_name: sysrst_ctrl_aon
      desc: sysrst_ctrl_aon fatal_fault alert
      lpg_name: secure_lc_io_div4_Aon
      lpg_idx: 12
    }
    {
      name: adc_ctrl_aon_fatal_fault
      width: 1
      type: alert
      async: "1"
      module_name: adc_ctrl_aon
      desc: adc_ctrl_aon fatal_fault alert
      lpg_name: peri_lc_io_div4_Aon
      lpg_idx: 13
    }
    {
      name: pwm_aon_fatal_fault
      width: 1
      type: alert
      async: "1"
      module_name: pwm_aon
      desc: pwm_aon fatal_fault alert
      lpg_name: peri_lc_io_div4_Aon
      lpg_idx: 13
    }
    {
      name: pinmux_aon_fatal_fault
      width: 1
      type: alert
      async: "1"
      module_name: pinmux_aon
      desc: pinmux_aon fatal_fault alert
      lpg_name: powerup_lc_io_div4_Aon
      lpg_idx: 11
    }
    {
      name: aon_timer_aon_fatal_fault
      width: 1
      type: alert
      async: "1"
      module_name: aon_timer_aon
      desc: aon_timer_aon fatal_fault alert
      lpg_name: timers_lc_io_div4_Aon
      lpg_idx: 14
    }
    {
      name: sensor_ctrl_aon_recov_alert
      width: 1
      type: alert
      async: "1"
      module_name: sensor_ctrl_aon
      desc: sensor_ctrl_aon recov_alert alert
      lpg_name: secure_lc_io_div4_Aon
      lpg_idx: 12
    }
    {
      name: sensor_ctrl_aon_fatal_alert
      width: 1
      type: alert
      async: "1"
      module_name: sensor_ctrl_aon
      desc: sensor_ctrl_aon fatal_alert alert
      lpg_name: secure_lc_io_div4_Aon
      lpg_idx: 12
    }
    {
      name: sram_ctrl_ret_aon_fatal_error
      width: 1
      type: alert
      async: "1"
      module_name: sram_ctrl_ret_aon
      desc: sram_ctrl_ret_aon fatal_error alert
      lpg_name: infra_lc_io_div4_Aon
      lpg_idx: 16
    }
    {
      name: flash_ctrl_recov_err
      width: 1
      type: alert
      async: "1"
      module_name: flash_ctrl
      desc: flash_ctrl recov_err alert
      lpg_name: infra_lc_0
      lpg_idx: 17
    }
    {
      name: flash_ctrl_fatal_std_err
      width: 1
      type: alert
      async: "1"
      module_name: flash_ctrl
      desc: flash_ctrl fatal_std_err alert
      lpg_name: infra_lc_0
      lpg_idx: 17
    }
    {
      name: flash_ctrl_fatal_err
      width: 1
      type: alert
      async: "1"
      module_name: flash_ctrl
      desc: flash_ctrl fatal_err alert
      lpg_name: infra_lc_0
      lpg_idx: 17
    }
    {
      name: flash_ctrl_fatal_prim_flash_alert
      width: 1
      type: alert
      async: "1"
      module_name: flash_ctrl
      desc: flash_ctrl fatal_prim_flash_alert alert
      lpg_name: infra_lc_0
      lpg_idx: 17
    }
    {
      name: flash_ctrl_recov_prim_flash_alert
      width: 1
      type: alert
      async: "1"
      module_name: flash_ctrl
      desc: flash_ctrl recov_prim_flash_alert alert
      lpg_name: infra_lc_0
      lpg_idx: 17
    }
    {
      name: rv_dm_fatal_fault
      width: 1
      type: alert
      async: "1"
      module_name: rv_dm
      desc: rv_dm fatal_fault alert
      lpg_name: infra_sys_0
      lpg_idx: 18
    }
    {
      name: rv_plic_fatal_fault
      width: 1
      type: alert
      async: "1"
      module_name: rv_plic
      desc: rv_plic fatal_fault alert
      lpg_name: secure_lc_0
      lpg_idx: 19
    }
    {
      name: aes_recov_ctrl_update_err
      width: 1
      type: alert
      async: "1"
      module_name: aes
      desc: aes recov_ctrl_update_err alert
      lpg_name: aes_trans_lc_0
      lpg_idx: 20
    }
    {
      name: aes_fatal_fault
      width: 1
      type: alert
      async: "1"
      module_name: aes
      desc: aes fatal_fault alert
      lpg_name: aes_trans_lc_0
      lpg_idx: 20
    }
    {
      name: hmac_fatal_fault
      width: 1
      type: alert
      async: "1"
      module_name: hmac
      desc: hmac fatal_fault alert
      lpg_name: hmac_trans_lc_0
      lpg_idx: 21
    }
    {
      name: kmac_recov_operation_err
      width: 1
      type: alert
      async: "1"
      module_name: kmac
      desc: kmac recov_operation_err alert
      lpg_name: kmac_trans_lc_0
      lpg_idx: 22
    }
    {
      name: kmac_fatal_fault_err
      width: 1
      type: alert
      async: "1"
      module_name: kmac
      desc: kmac fatal_fault_err alert
      lpg_name: kmac_trans_lc_0
      lpg_idx: 22
    }
    {
      name: otbn_fatal
      width: 1
      type: alert
      async: "1"
      module_name: otbn
      desc: otbn fatal alert
      lpg_name: otbn_trans_lc_0
      lpg_idx: 23
    }
    {
      name: otbn_recov
      width: 1
      type: alert
      async: "1"
      module_name: otbn
      desc: otbn recov alert
      lpg_name: otbn_trans_lc_0
      lpg_idx: 23
    }
    {
      name: keymgr_recov_operation_err
      width: 1
      type: alert
      async: "1"
      module_name: keymgr
      desc: keymgr recov_operation_err alert
      lpg_name: secure_lc_0
      lpg_idx: 19
    }
    {
      name: keymgr_fatal_fault_err
      width: 1
      type: alert
      async: "1"
      module_name: keymgr
      desc: keymgr fatal_fault_err alert
      lpg_name: secure_lc_0
      lpg_idx: 19
    }
    {
      name: csrng_recov_alert
      width: 1
      type: alert
      async: "1"
      module_name: csrng
      desc: csrng recov_alert alert
      lpg_name: secure_lc_0
      lpg_idx: 19
    }
    {
      name: csrng_fatal_alert
      width: 1
      type: alert
      async: "1"
      module_name: csrng
      desc: csrng fatal_alert alert
      lpg_name: secure_lc_0
      lpg_idx: 19
    }
    {
      name: entropy_src_recov_alert
      width: 1
      type: alert
      async: "1"
      module_name: entropy_src
      desc: entropy_src recov_alert alert
      lpg_name: secure_lc_0
      lpg_idx: 19
    }
    {
      name: entropy_src_fatal_alert
      width: 1
      type: alert
      async: "1"
      module_name: entropy_src
      desc: entropy_src fatal_alert alert
      lpg_name: secure_lc_0
      lpg_idx: 19
    }
    {
      name: edn0_recov_alert
      width: 1
      type: alert
      async: "1"
      module_name: edn0
      desc: edn0 recov_alert alert
      lpg_name: secure_lc_0
      lpg_idx: 19
    }
    {
      name: edn0_fatal_alert
      width: 1
      type: alert
      async: "1"
      module_name: edn0
      desc: edn0 fatal_alert alert
      lpg_name: secure_lc_0
      lpg_idx: 19
    }
    {
      name: edn1_recov_alert
      width: 1
      type: alert
      async: "1"
      module_name: edn1
      desc: edn1 recov_alert alert
      lpg_name: secure_lc_0
      lpg_idx: 19
    }
    {
      name: edn1_fatal_alert
      width: 1
      type: alert
      async: "1"
      module_name: edn1
      desc: edn1 fatal_alert alert
      lpg_name: secure_lc_0
      lpg_idx: 19
    }
    {
      name: sram_ctrl_main_fatal_error
      width: 1
      type: alert
      async: "1"
      module_name: sram_ctrl_main
      desc: sram_ctrl_main fatal_error alert
      lpg_name: infra_lc_0
      lpg_idx: 17
    }
    {
      name: rom_ctrl_fatal
      width: 1
      type: alert
      async: "1"
      module_name: rom_ctrl
      desc: rom_ctrl fatal alert
      lpg_name: infra_lc_0
      lpg_idx: 17
    }
    {
      name: rv_core_ibex_fatal_sw_err
      width: 1
      type: alert
      async: "1"
      module_name: rv_core_ibex
      desc: rv_core_ibex fatal_sw_err alert
      lpg_name: infra_lc_0
      lpg_idx: 17
    }
    {
      name: rv_core_ibex_recov_sw_err
      width: 1
      type: alert
      async: "1"
      module_name: rv_core_ibex
      desc: rv_core_ibex recov_sw_err alert
      lpg_name: infra_lc_0
      lpg_idx: 17
    }
    {
      name: rv_core_ibex_fatal_hw_err
      width: 1
      type: alert
      async: "1"
      module_name: rv_core_ibex
      desc: rv_core_ibex fatal_hw_err alert
      lpg_name: infra_lc_0
      lpg_idx: 17
    }
    {
      name: rv_core_ibex_recov_hw_err
      width: 1
      type: alert
      async: "1"
      module_name: rv_core_ibex
      desc: rv_core_ibex recov_hw_err alert
      lpg_name: infra_lc_0
      lpg_idx: 17
    }
  ]
  outgoing_alert: {}
  interrupt:
  [
    {
      name: uart0_tx_watermark
      width: 1
      type: interrupt
      module_name: uart0
      desc: uart0 tx_watermark interrupt
      intr_type: IntrType.Status
      default_val: true
      incoming: false
    }
    {
      name: uart0_rx_watermark
      width: 1
      type: interrupt
      module_name: uart0
      desc: uart0 rx_watermark interrupt
      intr_type: IntrType.Status
      default_val: false
      incoming: false
    }
    {
      name: uart0_tx_done
      width: 1
      type: interrupt
      module_name: uart0
      desc: uart0 tx_done interrupt
      intr_type: IntrType.Event
      default_val: false
      incoming: false
    }
    {
      name: uart0_rx_overflow
      width: 1
      type: interrupt
      module_name: uart0
      desc: uart0 rx_overflow interrupt
      intr_type: IntrType.Event
      default_val: false
      incoming: false
    }
    {
      name: uart0_rx_frame_err
      width: 1
      type: interrupt
      module_name: uart0
      desc: uart0 rx_frame_err interrupt
      intr_type: IntrType.Event
      default_val: false
      incoming: false
    }
    {
      name: uart0_rx_break_err
      width: 1
      type: interrupt
      module_name: uart0
      desc: uart0 rx_break_err interrupt
      intr_type: IntrType.Event
      default_val: false
      incoming: false
    }
    {
      name: uart0_rx_timeout
      width: 1
      type: interrupt
      module_name: uart0
      desc: uart0 rx_timeout interrupt
      intr_type: IntrType.Event
      default_val: false
      incoming: false
    }
    {
      name: uart0_rx_parity_err
      width: 1
      type: interrupt
      module_name: uart0
      desc: uart0 rx_parity_err interrupt
      intr_type: IntrType.Event
      default_val: false
      incoming: false
    }
    {
      name: uart0_tx_empty
      width: 1
      type: interrupt
      module_name: uart0
      desc: uart0 tx_empty interrupt
      intr_type: IntrType.Status
      default_val: true
      incoming: false
    }
    {
      name: uart1_tx_watermark
      width: 1
      type: interrupt
      module_name: uart1
      desc: uart1 tx_watermark interrupt
      intr_type: IntrType.Status
      default_val: true
      incoming: false
    }
    {
      name: uart1_rx_watermark
      width: 1
      type: interrupt
      module_name: uart1
      desc: uart1 rx_watermark interrupt
      intr_type: IntrType.Status
      default_val: false
      incoming: false
    }
    {
      name: uart1_tx_done
      width: 1
      type: interrupt
      module_name: uart1
      desc: uart1 tx_done interrupt
      intr_type: IntrType.Event
      default_val: false
      incoming: false
    }
    {
      name: uart1_rx_overflow
      width: 1
      type: interrupt
      module_name: uart1
      desc: uart1 rx_overflow interrupt
      intr_type: IntrType.Event
      default_val: false
      incoming: false
    }
    {
      name: uart1_rx_frame_err
      width: 1
      type: interrupt
      module_name: uart1
      desc: uart1 rx_frame_err interrupt
      intr_type: IntrType.Event
      default_val: false
      incoming: false
    }
    {
      name: uart1_rx_break_err
      width: 1
      type: interrupt
      module_name: uart1
      desc: uart1 rx_break_err interrupt
      intr_type: IntrType.Event
      default_val: false
      incoming: false
    }
    {
      name: uart1_rx_timeout
      width: 1
      type: interrupt
      module_name: uart1
      desc: uart1 rx_timeout interrupt
      intr_type: IntrType.Event
      default_val: false
      incoming: false
    }
    {
      name: uart1_rx_parity_err
      width: 1
      type: interrupt
      module_name: uart1
      desc: uart1 rx_parity_err interrupt
      intr_type: IntrType.Event
      default_val: false
      incoming: false
    }
    {
      name: uart1_tx_empty
      width: 1
      type: interrupt
      module_name: uart1
      desc: uart1 tx_empty interrupt
      intr_type: IntrType.Status
      default_val: true
      incoming: false
    }
    {
      name: uart2_tx_watermark
      width: 1
      type: interrupt
      module_name: uart2
      desc: uart2 tx_watermark interrupt
      intr_type: IntrType.Status
      default_val: true
      incoming: false
    }
    {
      name: uart2_rx_watermark
      width: 1
      type: interrupt
      module_name: uart2
      desc: uart2 rx_watermark interrupt
      intr_type: IntrType.Status
      default_val: false
      incoming: false
    }
    {
      name: uart2_tx_done
      width: 1
      type: interrupt
      module_name: uart2
      desc: uart2 tx_done interrupt
      intr_type: IntrType.Event
      default_val: false
      incoming: false
    }
    {
      name: uart2_rx_overflow
      width: 1
      type: interrupt
      module_name: uart2
      desc: uart2 rx_overflow interrupt
      intr_type: IntrType.Event
      default_val: false
      incoming: false
    }
    {
      name: uart2_rx_frame_err
      width: 1
      type: interrupt
      module_name: uart2
      desc: uart2 rx_frame_err interrupt
      intr_type: IntrType.Event
      default_val: false
      incoming: false
    }
    {
      name: uart2_rx_break_err
      width: 1
      type: interrupt
      module_name: uart2
      desc: uart2 rx_break_err interrupt
      intr_type: IntrType.Event
      default_val: false
      incoming: false
    }
    {
      name: uart2_rx_timeout
      width: 1
      type: interrupt
      module_name: uart2
      desc: uart2 rx_timeout interrupt
      intr_type: IntrType.Event
      default_val: false
      incoming: false
    }
    {
      name: uart2_rx_parity_err
      width: 1
      type: interrupt
      module_name: uart2
      desc: uart2 rx_parity_err interrupt
      intr_type: IntrType.Event
      default_val: false
      incoming: false
    }
    {
      name: uart2_tx_empty
      width: 1
      type: interrupt
      module_name: uart2
      desc: uart2 tx_empty interrupt
      intr_type: IntrType.Status
      default_val: true
      incoming: false
    }
    {
      name: uart3_tx_watermark
      width: 1
      type: interrupt
      module_name: uart3
      desc: uart3 tx_watermark interrupt
      intr_type: IntrType.Status
      default_val: true
      incoming: false
    }
    {
      name: uart3_rx_watermark
      width: 1
      type: interrupt
      module_name: uart3
      desc: uart3 rx_watermark interrupt
      intr_type: IntrType.Status
      default_val: false
      incoming: false
    }
    {
      name: uart3_tx_done
      width: 1
      type: interrupt
      module_name: uart3
      desc: uart3 tx_done interrupt
      intr_type: IntrType.Event
      default_val: false
      incoming: false
    }
    {
      name: uart3_rx_overflow
      width: 1
      type: interrupt
      module_name: uart3
      desc: uart3 rx_overflow interrupt
      intr_type: IntrType.Event
      default_val: false
      incoming: false
    }
    {
      name: uart3_rx_frame_err
      width: 1
      type: interrupt
      module_name: uart3
      desc: uart3 rx_frame_err interrupt
      intr_type: IntrType.Event
      default_val: false
      incoming: false
    }
    {
      name: uart3_rx_break_err
      width: 1
      type: interrupt
      module_name: uart3
      desc: uart3 rx_break_err interrupt
      intr_type: IntrType.Event
      default_val: false
      incoming: false
    }
    {
      name: uart3_rx_timeout
      width: 1
      type: interrupt
      module_name: uart3
      desc: uart3 rx_timeout interrupt
      intr_type: IntrType.Event
      default_val: false
      incoming: false
    }
    {
      name: uart3_rx_parity_err
      width: 1
      type: interrupt
      module_name: uart3
      desc: uart3 rx_parity_err interrupt
      intr_type: IntrType.Event
      default_val: false
      incoming: false
    }
    {
      name: uart3_tx_empty
      width: 1
      type: interrupt
      module_name: uart3
      desc: uart3 tx_empty interrupt
      intr_type: IntrType.Status
      default_val: true
      incoming: false
    }
    {
      name: gpio_gpio
      width: 32
      type: interrupt
      module_name: gpio
      desc: gpio gpio interrupt
      intr_type: IntrType.Event
      default_val: false
      incoming: false
    }
    {
      name: spi_device_upload_cmdfifo_not_empty
      width: 1
      type: interrupt
      module_name: spi_device
      desc: spi_device upload_cmdfifo_not_empty interrupt
      intr_type: IntrType.Event
      default_val: false
      incoming: false
    }
    {
      name: spi_device_upload_payload_not_empty
      width: 1
      type: interrupt
      module_name: spi_device
      desc: spi_device upload_payload_not_empty interrupt
      intr_type: IntrType.Event
      default_val: false
      incoming: false
    }
    {
      name: spi_device_upload_payload_overflow
      width: 1
      type: interrupt
      module_name: spi_device
      desc: spi_device upload_payload_overflow interrupt
      intr_type: IntrType.Event
      default_val: false
      incoming: false
    }
    {
      name: spi_device_readbuf_watermark
      width: 1
      type: interrupt
      module_name: spi_device
      desc: spi_device readbuf_watermark interrupt
      intr_type: IntrType.Event
      default_val: false
      incoming: false
    }
    {
      name: spi_device_readbuf_flip
      width: 1
      type: interrupt
      module_name: spi_device
      desc: spi_device readbuf_flip interrupt
      intr_type: IntrType.Event
      default_val: false
      incoming: false
    }
    {
      name: spi_device_tpm_header_not_empty
      width: 1
      type: interrupt
      module_name: spi_device
      desc: spi_device tpm_header_not_empty interrupt
      intr_type: IntrType.Status
      default_val: false
      incoming: false
    }
    {
      name: spi_device_tpm_rdfifo_cmd_end
      width: 1
      type: interrupt
      module_name: spi_device
      desc: spi_device tpm_rdfifo_cmd_end interrupt
      intr_type: IntrType.Event
      default_val: false
      incoming: false
    }
    {
      name: spi_device_tpm_rdfifo_drop
      width: 1
      type: interrupt
      module_name: spi_device
      desc: spi_device tpm_rdfifo_drop interrupt
      intr_type: IntrType.Event
      default_val: false
      incoming: false
    }
    {
      name: i2c0_fmt_threshold
      width: 1
      type: interrupt
      module_name: i2c0
      desc: i2c0 fmt_threshold interrupt
      intr_type: IntrType.Status
      default_val: false
      incoming: false
    }
    {
      name: i2c0_rx_threshold
      width: 1
      type: interrupt
      module_name: i2c0
      desc: i2c0 rx_threshold interrupt
      intr_type: IntrType.Status
      default_val: false
      incoming: false
    }
    {
      name: i2c0_acq_threshold
      width: 1
      type: interrupt
      module_name: i2c0
      desc: i2c0 acq_threshold interrupt
      intr_type: IntrType.Status
      default_val: false
      incoming: false
    }
    {
      name: i2c0_rx_overflow
      width: 1
      type: interrupt
      module_name: i2c0
      desc: i2c0 rx_overflow interrupt
      intr_type: IntrType.Event
      default_val: false
      incoming: false
    }
    {
      name: i2c0_controller_halt
      width: 1
      type: interrupt
      module_name: i2c0
      desc: i2c0 controller_halt interrupt
      intr_type: IntrType.Status
      default_val: false
      incoming: false
    }
    {
      name: i2c0_scl_interference
      width: 1
      type: interrupt
      module_name: i2c0
      desc: i2c0 scl_interference interrupt
      intr_type: IntrType.Event
      default_val: false
      incoming: false
    }
    {
      name: i2c0_sda_interference
      width: 1
      type: interrupt
      module_name: i2c0
      desc: i2c0 sda_interference interrupt
      intr_type: IntrType.Event
      default_val: false
      incoming: false
    }
    {
      name: i2c0_stretch_timeout
      width: 1
      type: interrupt
      module_name: i2c0
      desc: i2c0 stretch_timeout interrupt
      intr_type: IntrType.Event
      default_val: false
      incoming: false
    }
    {
      name: i2c0_sda_unstable
      width: 1
      type: interrupt
      module_name: i2c0
      desc: i2c0 sda_unstable interrupt
      intr_type: IntrType.Event
      default_val: false
      incoming: false
    }
    {
      name: i2c0_cmd_complete
      width: 1
      type: interrupt
      module_name: i2c0
      desc: i2c0 cmd_complete interrupt
      intr_type: IntrType.Event
      default_val: false
      incoming: false
    }
    {
      name: i2c0_tx_stretch
      width: 1
      type: interrupt
      module_name: i2c0
      desc: i2c0 tx_stretch interrupt
      intr_type: IntrType.Status
      default_val: false
      incoming: false
    }
    {
      name: i2c0_tx_threshold
      width: 1
      type: interrupt
      module_name: i2c0
      desc: i2c0 tx_threshold interrupt
      intr_type: IntrType.Status
      default_val: false
      incoming: false
    }
    {
      name: i2c0_acq_stretch
      width: 1
      type: interrupt
      module_name: i2c0
      desc: i2c0 acq_stretch interrupt
      intr_type: IntrType.Status
      default_val: false
      incoming: false
    }
    {
      name: i2c0_unexp_stop
      width: 1
      type: interrupt
      module_name: i2c0
      desc: i2c0 unexp_stop interrupt
      intr_type: IntrType.Event
      default_val: false
      incoming: false
    }
    {
      name: i2c0_host_timeout
      width: 1
      type: interrupt
      module_name: i2c0
      desc: i2c0 host_timeout interrupt
      intr_type: IntrType.Event
      default_val: false
      incoming: false
    }
    {
      name: i2c1_fmt_threshold
      width: 1
      type: interrupt
      module_name: i2c1
      desc: i2c1 fmt_threshold interrupt
      intr_type: IntrType.Status
      default_val: false
      incoming: false
    }
    {
      name: i2c1_rx_threshold
      width: 1
      type: interrupt
      module_name: i2c1
      desc: i2c1 rx_threshold interrupt
      intr_type: IntrType.Status
      default_val: false
      incoming: false
    }
    {
      name: i2c1_acq_threshold
      width: 1
      type: interrupt
      module_name: i2c1
      desc: i2c1 acq_threshold interrupt
      intr_type: IntrType.Status
      default_val: false
      incoming: false
    }
    {
      name: i2c1_rx_overflow
      width: 1
      type: interrupt
      module_name: i2c1
      desc: i2c1 rx_overflow interrupt
      intr_type: IntrType.Event
      default_val: false
      incoming: false
    }
    {
      name: i2c1_controller_halt
      width: 1
      type: interrupt
      module_name: i2c1
      desc: i2c1 controller_halt interrupt
      intr_type: IntrType.Status
      default_val: false
      incoming: false
    }
    {
      name: i2c1_scl_interference
      width: 1
      type: interrupt
      module_name: i2c1
      desc: i2c1 scl_interference interrupt
      intr_type: IntrType.Event
      default_val: false
      incoming: false
    }
    {
      name: i2c1_sda_interference
      width: 1
      type: interrupt
      module_name: i2c1
      desc: i2c1 sda_interference interrupt
      intr_type: IntrType.Event
      default_val: false
      incoming: false
    }
    {
      name: i2c1_stretch_timeout
      width: 1
      type: interrupt
      module_name: i2c1
      desc: i2c1 stretch_timeout interrupt
      intr_type: IntrType.Event
      default_val: false
      incoming: false
    }
    {
      name: i2c1_sda_unstable
      width: 1
      type: interrupt
      module_name: i2c1
      desc: i2c1 sda_unstable interrupt
      intr_type: IntrType.Event
      default_val: false
      incoming: false
    }
    {
      name: i2c1_cmd_complete
      width: 1
      type: interrupt
      module_name: i2c1
      desc: i2c1 cmd_complete interrupt
      intr_type: IntrType.Event
      default_val: false
      incoming: false
    }
    {
      name: i2c1_tx_stretch
      width: 1
      type: interrupt
      module_name: i2c1
      desc: i2c1 tx_stretch interrupt
      intr_type: IntrType.Status
      default_val: false
      incoming: false
    }
    {
      name: i2c1_tx_threshold
      width: 1
      type: interrupt
      module_name: i2c1
      desc: i2c1 tx_threshold interrupt
      intr_type: IntrType.Status
      default_val: false
      incoming: false
    }
    {
      name: i2c1_acq_stretch
      width: 1
      type: interrupt
      module_name: i2c1
      desc: i2c1 acq_stretch interrupt
      intr_type: IntrType.Status
      default_val: false
      incoming: false
    }
    {
      name: i2c1_unexp_stop
      width: 1
      type: interrupt
      module_name: i2c1
      desc: i2c1 unexp_stop interrupt
      intr_type: IntrType.Event
      default_val: false
      incoming: false
    }
    {
      name: i2c1_host_timeout
      width: 1
      type: interrupt
      module_name: i2c1
      desc: i2c1 host_timeout interrupt
      intr_type: IntrType.Event
      default_val: false
      incoming: false
    }
    {
      name: i2c2_fmt_threshold
      width: 1
      type: interrupt
      module_name: i2c2
      desc: i2c2 fmt_threshold interrupt
      intr_type: IntrType.Status
      default_val: false
      incoming: false
    }
    {
      name: i2c2_rx_threshold
      width: 1
      type: interrupt
      module_name: i2c2
      desc: i2c2 rx_threshold interrupt
      intr_type: IntrType.Status
      default_val: false
      incoming: false
    }
    {
      name: i2c2_acq_threshold
      width: 1
      type: interrupt
      module_name: i2c2
      desc: i2c2 acq_threshold interrupt
      intr_type: IntrType.Status
      default_val: false
      incoming: false
    }
    {
      name: i2c2_rx_overflow
      width: 1
      type: interrupt
      module_name: i2c2
      desc: i2c2 rx_overflow interrupt
      intr_type: IntrType.Event
      default_val: false
      incoming: false
    }
    {
      name: i2c2_controller_halt
      width: 1
      type: interrupt
      module_name: i2c2
      desc: i2c2 controller_halt interrupt
      intr_type: IntrType.Status
      default_val: false
      incoming: false
    }
    {
      name: i2c2_scl_interference
      width: 1
      type: interrupt
      module_name: i2c2
      desc: i2c2 scl_interference interrupt
      intr_type: IntrType.Event
      default_val: false
      incoming: false
    }
    {
      name: i2c2_sda_interference
      width: 1
      type: interrupt
      module_name: i2c2
      desc: i2c2 sda_interference interrupt
      intr_type: IntrType.Event
      default_val: false
      incoming: false
    }
    {
      name: i2c2_stretch_timeout
      width: 1
      type: interrupt
      module_name: i2c2
      desc: i2c2 stretch_timeout interrupt
      intr_type: IntrType.Event
      default_val: false
      incoming: false
    }
    {
      name: i2c2_sda_unstable
      width: 1
      type: interrupt
      module_name: i2c2
      desc: i2c2 sda_unstable interrupt
      intr_type: IntrType.Event
      default_val: false
      incoming: false
    }
    {
      name: i2c2_cmd_complete
      width: 1
      type: interrupt
      module_name: i2c2
      desc: i2c2 cmd_complete interrupt
      intr_type: IntrType.Event
      default_val: false
      incoming: false
    }
    {
      name: i2c2_tx_stretch
      width: 1
      type: interrupt
      module_name: i2c2
      desc: i2c2 tx_stretch interrupt
      intr_type: IntrType.Status
      default_val: false
      incoming: false
    }
    {
      name: i2c2_tx_threshold
      width: 1
      type: interrupt
      module_name: i2c2
      desc: i2c2 tx_threshold interrupt
      intr_type: IntrType.Status
      default_val: false
      incoming: false
    }
    {
      name: i2c2_acq_stretch
      width: 1
      type: interrupt
      module_name: i2c2
      desc: i2c2 acq_stretch interrupt
      intr_type: IntrType.Status
      default_val: false
      incoming: false
    }
    {
      name: i2c2_unexp_stop
      width: 1
      type: interrupt
      module_name: i2c2
      desc: i2c2 unexp_stop interrupt
      intr_type: IntrType.Event
      default_val: false
      incoming: false
    }
    {
      name: i2c2_host_timeout
      width: 1
      type: interrupt
      module_name: i2c2
      desc: i2c2 host_timeout interrupt
      intr_type: IntrType.Event
      default_val: false
      incoming: false
    }
    {
      name: pattgen_done_ch0
      width: 1
      type: interrupt
      module_name: pattgen
      desc: pattgen done_ch0 interrupt
      intr_type: IntrType.Event
      default_val: false
      incoming: false
    }
    {
      name: pattgen_done_ch1
      width: 1
      type: interrupt
      module_name: pattgen
      desc: pattgen done_ch1 interrupt
      intr_type: IntrType.Event
      default_val: false
      incoming: false
    }
    {
      name: rv_timer_timer_expired_hart0_timer0
      width: 1
      type: interrupt
      module_name: rv_timer
      desc: rv_timer timer_expired_hart0_timer0 interrupt
      intr_type: IntrType.Event
      default_val: false
      incoming: false
    }
    {
      name: otp_ctrl_otp_operation_done
      width: 1
      type: interrupt
      module_name: otp_ctrl
      desc: otp_ctrl otp_operation_done interrupt
      intr_type: IntrType.Event
      default_val: false
      incoming: false
    }
    {
      name: otp_ctrl_otp_error
      width: 1
      type: interrupt
      module_name: otp_ctrl
      desc: otp_ctrl otp_error interrupt
      intr_type: IntrType.Event
      default_val: false
      incoming: false
    }
    {
      name: alert_handler_classa
      width: 1
      type: interrupt
      module_name: alert_handler
      desc: alert_handler classa interrupt
      intr_type: IntrType.Event
      default_val: false
      incoming: false
    }
    {
      name: alert_handler_classb
      width: 1
      type: interrupt
      module_name: alert_handler
      desc: alert_handler classb interrupt
      intr_type: IntrType.Event
      default_val: false
      incoming: false
    }
    {
      name: alert_handler_classc
      width: 1
      type: interrupt
      module_name: alert_handler
      desc: alert_handler classc interrupt
      intr_type: IntrType.Event
      default_val: false
      incoming: false
    }
    {
      name: alert_handler_classd
      width: 1
      type: interrupt
      module_name: alert_handler
      desc: alert_handler classd interrupt
      intr_type: IntrType.Event
      default_val: false
      incoming: false
    }
    {
      name: spi_host0_error
      width: 1
      type: interrupt
      module_name: spi_host0
      desc: spi_host0 error interrupt
      intr_type: IntrType.Event
      default_val: false
      incoming: false
    }
    {
      name: spi_host0_spi_event
      width: 1
      type: interrupt
      module_name: spi_host0
      desc: spi_host0 spi_event interrupt
      intr_type: IntrType.Status
      default_val: false
      incoming: false
    }
    {
      name: spi_host1_error
      width: 1
      type: interrupt
      module_name: spi_host1
      desc: spi_host1 error interrupt
      intr_type: IntrType.Event
      default_val: false
      incoming: false
    }
    {
      name: spi_host1_spi_event
      width: 1
      type: interrupt
      module_name: spi_host1
      desc: spi_host1 spi_event interrupt
      intr_type: IntrType.Status
      default_val: false
      incoming: false
    }
    {
      name: usbdev_pkt_received
      width: 1
      type: interrupt
      module_name: usbdev
      desc: usbdev pkt_received interrupt
      intr_type: IntrType.Status
      default_val: false
      incoming: false
    }
    {
      name: usbdev_pkt_sent
      width: 1
      type: interrupt
      module_name: usbdev
      desc: usbdev pkt_sent interrupt
      intr_type: IntrType.Status
      default_val: false
      incoming: false
    }
    {
      name: usbdev_disconnected
      width: 1
      type: interrupt
      module_name: usbdev
      desc: usbdev disconnected interrupt
      intr_type: IntrType.Event
      default_val: false
      incoming: false
    }
    {
      name: usbdev_host_lost
      width: 1
      type: interrupt
      module_name: usbdev
      desc: usbdev host_lost interrupt
      intr_type: IntrType.Event
      default_val: false
      incoming: false
    }
    {
      name: usbdev_link_reset
      width: 1
      type: interrupt
      module_name: usbdev
      desc: usbdev link_reset interrupt
      intr_type: IntrType.Event
      default_val: false
      incoming: false
    }
    {
      name: usbdev_link_suspend
      width: 1
      type: interrupt
      module_name: usbdev
      desc: usbdev link_suspend interrupt
      intr_type: IntrType.Event
      default_val: false
      incoming: false
    }
    {
      name: usbdev_link_resume
      width: 1
      type: interrupt
      module_name: usbdev
      desc: usbdev link_resume interrupt
      intr_type: IntrType.Event
      default_val: false
      incoming: false
    }
    {
      name: usbdev_av_out_empty
      width: 1
      type: interrupt
      module_name: usbdev
      desc: usbdev av_out_empty interrupt
      intr_type: IntrType.Status
      default_val: false
      incoming: false
    }
    {
      name: usbdev_rx_full
      width: 1
      type: interrupt
      module_name: usbdev
      desc: usbdev rx_full interrupt
      intr_type: IntrType.Status
      default_val: false
      incoming: false
    }
    {
      name: usbdev_av_overflow
      width: 1
      type: interrupt
      module_name: usbdev
      desc: usbdev av_overflow interrupt
      intr_type: IntrType.Event
      default_val: false
      incoming: false
    }
    {
      name: usbdev_link_in_err
      width: 1
      type: interrupt
      module_name: usbdev
      desc: usbdev link_in_err interrupt
      intr_type: IntrType.Event
      default_val: false
      incoming: false
    }
    {
      name: usbdev_rx_crc_err
      width: 1
      type: interrupt
      module_name: usbdev
      desc: usbdev rx_crc_err interrupt
      intr_type: IntrType.Event
      default_val: false
      incoming: false
    }
    {
      name: usbdev_rx_pid_err
      width: 1
      type: interrupt
      module_name: usbdev
      desc: usbdev rx_pid_err interrupt
      intr_type: IntrType.Event
      default_val: false
      incoming: false
    }
    {
      name: usbdev_rx_bitstuff_err
      width: 1
      type: interrupt
      module_name: usbdev
      desc: usbdev rx_bitstuff_err interrupt
      intr_type: IntrType.Event
      default_val: false
      incoming: false
    }
    {
      name: usbdev_frame
      width: 1
      type: interrupt
      module_name: usbdev
      desc: usbdev frame interrupt
      intr_type: IntrType.Event
      default_val: false
      incoming: false
    }
    {
      name: usbdev_powered
      width: 1
      type: interrupt
      module_name: usbdev
      desc: usbdev powered interrupt
      intr_type: IntrType.Event
      default_val: false
      incoming: false
    }
    {
      name: usbdev_link_out_err
      width: 1
      type: interrupt
      module_name: usbdev
      desc: usbdev link_out_err interrupt
      intr_type: IntrType.Event
      default_val: false
      incoming: false
    }
    {
      name: usbdev_av_setup_empty
      width: 1
      type: interrupt
      module_name: usbdev
      desc: usbdev av_setup_empty interrupt
      intr_type: IntrType.Status
      default_val: false
      incoming: false
    }
    {
      name: pwrmgr_aon_wakeup
      width: 1
      type: interrupt
      module_name: pwrmgr_aon
      desc: pwrmgr_aon wakeup interrupt
      intr_type: IntrType.Event
      default_val: false
      incoming: false
    }
    {
      name: sysrst_ctrl_aon_event_detected
      width: 1
      type: interrupt
      module_name: sysrst_ctrl_aon
      desc: sysrst_ctrl_aon event_detected interrupt
      intr_type: IntrType.Status
      default_val: false
      incoming: false
    }
    {
      name: adc_ctrl_aon_match_pending
      width: 1
      type: interrupt
      module_name: adc_ctrl_aon
      desc: adc_ctrl_aon match_pending interrupt
      intr_type: IntrType.Status
      default_val: false
      incoming: false
    }
    {
      name: aon_timer_aon_wkup_timer_expired
      width: 1
      type: interrupt
      module_name: aon_timer_aon
      desc: aon_timer_aon wkup_timer_expired interrupt
      intr_type: IntrType.Event
      default_val: false
      incoming: false
    }
    {
      name: aon_timer_aon_wdog_timer_bark
      width: 1
      type: interrupt
      module_name: aon_timer_aon
      desc: aon_timer_aon wdog_timer_bark interrupt
      intr_type: IntrType.Event
      default_val: false
      incoming: false
    }
    {
      name: sensor_ctrl_aon_io_status_change
      width: 1
      type: interrupt
      module_name: sensor_ctrl_aon
      desc: sensor_ctrl_aon io_status_change interrupt
      intr_type: IntrType.Event
      default_val: false
      incoming: false
    }
    {
      name: sensor_ctrl_aon_init_status_change
      width: 1
      type: interrupt
      module_name: sensor_ctrl_aon
      desc: sensor_ctrl_aon init_status_change interrupt
      intr_type: IntrType.Event
      default_val: false
      incoming: false
    }
    {
      name: flash_ctrl_prog_empty
      width: 1
      type: interrupt
      module_name: flash_ctrl
      desc: flash_ctrl prog_empty interrupt
      intr_type: IntrType.Status
      default_val: true
      incoming: false
    }
    {
      name: flash_ctrl_prog_lvl
      width: 1
      type: interrupt
      module_name: flash_ctrl
      desc: flash_ctrl prog_lvl interrupt
      intr_type: IntrType.Status
      default_val: true
      incoming: false
    }
    {
      name: flash_ctrl_rd_full
      width: 1
      type: interrupt
      module_name: flash_ctrl
      desc: flash_ctrl rd_full interrupt
      intr_type: IntrType.Status
      default_val: false
      incoming: false
    }
    {
      name: flash_ctrl_rd_lvl
      width: 1
      type: interrupt
      module_name: flash_ctrl
      desc: flash_ctrl rd_lvl interrupt
      intr_type: IntrType.Status
      default_val: false
      incoming: false
    }
    {
      name: flash_ctrl_op_done
      width: 1
      type: interrupt
      module_name: flash_ctrl
      desc: flash_ctrl op_done interrupt
      intr_type: IntrType.Event
      default_val: false
      incoming: false
    }
    {
      name: flash_ctrl_corr_err
      width: 1
      type: interrupt
      module_name: flash_ctrl
      desc: flash_ctrl corr_err interrupt
      intr_type: IntrType.Event
      default_val: false
      incoming: false
    }
    {
      name: hmac_hmac_done
      width: 1
      type: interrupt
      module_name: hmac
      desc: hmac hmac_done interrupt
      intr_type: IntrType.Event
      default_val: false
      incoming: false
    }
    {
      name: hmac_fifo_empty
      width: 1
      type: interrupt
      module_name: hmac
      desc: hmac fifo_empty interrupt
      intr_type: IntrType.Status
      default_val: false
      incoming: false
    }
    {
      name: hmac_hmac_err
      width: 1
      type: interrupt
      module_name: hmac
      desc: hmac hmac_err interrupt
      intr_type: IntrType.Event
      default_val: false
      incoming: false
    }
    {
      name: kmac_kmac_done
      width: 1
      type: interrupt
      module_name: kmac
      desc: kmac kmac_done interrupt
      intr_type: IntrType.Event
      default_val: false
      incoming: false
    }
    {
      name: kmac_fifo_empty
      width: 1
      type: interrupt
      module_name: kmac
      desc: kmac fifo_empty interrupt
      intr_type: IntrType.Status
      default_val: false
      incoming: false
    }
    {
      name: kmac_kmac_err
      width: 1
      type: interrupt
      module_name: kmac
      desc: kmac kmac_err interrupt
      intr_type: IntrType.Event
      default_val: false
      incoming: false
    }
    {
      name: otbn_done
      width: 1
      type: interrupt
      module_name: otbn
      desc: otbn done interrupt
      intr_type: IntrType.Event
      default_val: false
      incoming: false
    }
    {
      name: keymgr_op_done
      width: 1
      type: interrupt
      module_name: keymgr
      desc: keymgr op_done interrupt
      intr_type: IntrType.Event
      default_val: false
      incoming: false
    }
    {
      name: csrng_cs_cmd_req_done
      width: 1
      type: interrupt
      module_name: csrng
      desc: csrng cs_cmd_req_done interrupt
      intr_type: IntrType.Event
      default_val: false
      incoming: false
    }
    {
      name: csrng_cs_entropy_req
      width: 1
      type: interrupt
      module_name: csrng
      desc: csrng cs_entropy_req interrupt
      intr_type: IntrType.Event
      default_val: false
      incoming: false
    }
    {
      name: csrng_cs_hw_inst_exc
      width: 1
      type: interrupt
      module_name: csrng
      desc: csrng cs_hw_inst_exc interrupt
      intr_type: IntrType.Event
      default_val: false
      incoming: false
    }
    {
      name: csrng_cs_fatal_err
      width: 1
      type: interrupt
      module_name: csrng
      desc: csrng cs_fatal_err interrupt
      intr_type: IntrType.Event
      default_val: false
      incoming: false
    }
    {
      name: entropy_src_es_entropy_valid
      width: 1
      type: interrupt
      module_name: entropy_src
      desc: entropy_src es_entropy_valid interrupt
      intr_type: IntrType.Event
      default_val: false
      incoming: false
    }
    {
      name: entropy_src_es_health_test_failed
      width: 1
      type: interrupt
      module_name: entropy_src
      desc: entropy_src es_health_test_failed interrupt
      intr_type: IntrType.Event
      default_val: false
      incoming: false
    }
    {
      name: entropy_src_es_observe_fifo_ready
      width: 1
      type: interrupt
      module_name: entropy_src
      desc: entropy_src es_observe_fifo_ready interrupt
      intr_type: IntrType.Event
      default_val: false
      incoming: false
    }
    {
      name: entropy_src_es_fatal_err
      width: 1
      type: interrupt
      module_name: entropy_src
      desc: entropy_src es_fatal_err interrupt
      intr_type: IntrType.Event
      default_val: false
      incoming: false
    }
    {
      name: edn0_edn_cmd_req_done
      width: 1
      type: interrupt
      module_name: edn0
      desc: edn0 edn_cmd_req_done interrupt
      intr_type: IntrType.Event
      default_val: false
      incoming: false
    }
    {
      name: edn0_edn_fatal_err
      width: 1
      type: interrupt
      module_name: edn0
      desc: edn0 edn_fatal_err interrupt
      intr_type: IntrType.Event
      default_val: false
      incoming: false
    }
    {
      name: edn1_edn_cmd_req_done
      width: 1
      type: interrupt
      module_name: edn1
      desc: edn1 edn_cmd_req_done interrupt
      intr_type: IntrType.Event
      default_val: false
      incoming: false
    }
    {
      name: edn1_edn_fatal_err
      width: 1
      type: interrupt
      module_name: edn1
      desc: edn1 edn_fatal_err interrupt
      intr_type: IntrType.Event
      default_val: false
      incoming: false
    }
  ]
  outgoing_interrupt: {}
  alert_module:
  [
    uart0
    uart1
    uart2
    uart3
    gpio
    spi_device
    i2c0
    i2c1
    i2c2
    pattgen
    rv_timer
    otp_ctrl
    lc_ctrl
    spi_host0
    spi_host1
    usbdev
    pwrmgr_aon
    rstmgr_aon
    clkmgr_aon
    sysrst_ctrl_aon
    adc_ctrl_aon
    pwm_aon
    pinmux_aon
    aon_timer_aon
    sensor_ctrl_aon
    sram_ctrl_ret_aon
    flash_ctrl
    rv_dm
    rv_plic
    aes
    hmac
    kmac
    otbn
    keymgr
    csrng
    entropy_src
    edn0
    edn1
    sram_ctrl_main
    rom_ctrl
    rv_core_ibex
  ]
  interrupt_module:
  [
    uart0
    uart1
    uart2
    uart3
    gpio
    spi_device
    i2c0
    i2c1
    i2c2
    pattgen
    rv_timer
    otp_ctrl
    alert_handler
    spi_host0
    spi_host1
    usbdev
    pwrmgr_aon
    sysrst_ctrl_aon
    adc_ctrl_aon
    aon_timer_aon
    sensor_ctrl_aon
    flash_ctrl
    hmac
    kmac
    otbn
    keymgr
    csrng
    entropy_src
    edn0
    edn1
  ]
  outgoing_alert_module: {}
  outgoing_interrupt_module: {}
  alert_lpgs:
  [
    {
      name: peri_lc_io_div4_0
      clock_group:
      {
        name: peri
        src: top
        sw_cg: yes
        unique: no
        clocks:
        {
          clk_io_div4_peri: io_div4
          clk_io_div2_peri: io_div2
          clk_io_peri: io
          clk_usb_peri: usb
          clk_aon_peri: aon
        }
      }
      clock_connection: clkmgr_aon_clocks.clk_io_div4_peri
      unmanaged_clock: false
      unmanaged_reset: false
      reset_connection:
      {
        name: lc_io_div4
        domain: "0"
      }
    }
    {
      name: peri_spi_device_0
      clock_group:
      {
        name: peri
        src: top
        sw_cg: yes
        unique: no
        clocks:
        {
          clk_io_div4_peri: io_div4
          clk_io_div2_peri: io_div2
          clk_io_peri: io
          clk_usb_peri: usb
          clk_aon_peri: aon
        }
      }
      clock_connection: clkmgr_aon_clocks.clk_io_div4_peri
      unmanaged_clock: false
      unmanaged_reset: false
      reset_connection:
      {
        name: spi_device
        domain: "0"
      }
    }
    {
      name: peri_i2c0_0
      clock_group:
      {
        name: peri
        src: top
        sw_cg: yes
        unique: no
        clocks:
        {
          clk_io_div4_peri: io_div4
          clk_io_div2_peri: io_div2
          clk_io_peri: io
          clk_usb_peri: usb
          clk_aon_peri: aon
        }
      }
      clock_connection: clkmgr_aon_clocks.clk_io_div4_peri
      unmanaged_clock: false
      unmanaged_reset: false
      reset_connection:
      {
        name: i2c0
        domain: "0"
      }
    }
    {
      name: peri_i2c1_0
      clock_group:
      {
        name: peri
        src: top
        sw_cg: yes
        unique: no
        clocks:
        {
          clk_io_div4_peri: io_div4
          clk_io_div2_peri: io_div2
          clk_io_peri: io
          clk_usb_peri: usb
          clk_aon_peri: aon
        }
      }
      clock_connection: clkmgr_aon_clocks.clk_io_div4_peri
      unmanaged_clock: false
      unmanaged_reset: false
      reset_connection:
      {
        name: i2c1
        domain: "0"
      }
    }
    {
      name: peri_i2c2_0
      clock_group:
      {
        name: peri
        src: top
        sw_cg: yes
        unique: no
        clocks:
        {
          clk_io_div4_peri: io_div4
          clk_io_div2_peri: io_div2
          clk_io_peri: io
          clk_usb_peri: usb
          clk_aon_peri: aon
        }
      }
      clock_connection: clkmgr_aon_clocks.clk_io_div4_peri
      unmanaged_clock: false
      unmanaged_reset: false
      reset_connection:
      {
        name: i2c2
        domain: "0"
      }
    }
    {
      name: timers_lc_io_div4_0
      clock_group:
      {
        name: timers
        src: top
        sw_cg: no
        unique: no
        clocks:
        {
          clk_io_div4_timers: io_div4
          clk_aon_timers: aon
        }
      }
      clock_connection: clkmgr_aon_clocks.clk_io_div4_timers
      unmanaged_clock: false
      unmanaged_reset: false
      reset_connection:
      {
        name: lc_io_div4
        domain: "0"
      }
    }
    {
      name: secure_lc_io_div4_0
      clock_group:
      {
        name: secure
        src: top
        sw_cg: no
        unique: no
        clocks:
        {
          clk_io_div4_secure: io_div4
          clk_main_secure: main
          clk_aon_secure: aon
        }
      }
      clock_connection: clkmgr_aon_clocks.clk_io_div4_secure
      unmanaged_clock: false
      unmanaged_reset: false
      reset_connection:
      {
        name: lc_io_div4
        domain: "0"
      }
    }
    {
      name: peri_spi_host0_0
      clock_group:
      {
        name: peri
        src: top
        sw_cg: yes
        unique: no
        clocks:
        {
          clk_io_div4_peri: io_div4
          clk_io_div2_peri: io_div2
          clk_io_peri: io
          clk_usb_peri: usb
          clk_aon_peri: aon
        }
      }
      clock_connection: clkmgr_aon_clocks.clk_io_peri
      unmanaged_clock: false
      unmanaged_reset: false
      reset_connection:
      {
        name: spi_host0
        domain: "0"
      }
    }
    {
      name: peri_spi_host1_0
      clock_group:
      {
        name: peri
        src: top
        sw_cg: yes
        unique: no
        clocks:
        {
          clk_io_div4_peri: io_div4
          clk_io_div2_peri: io_div2
          clk_io_peri: io
          clk_usb_peri: usb
          clk_aon_peri: aon
        }
      }
      clock_connection: clkmgr_aon_clocks.clk_io_div2_peri
      unmanaged_clock: false
      unmanaged_reset: false
      reset_connection:
      {
        name: spi_host1
        domain: "0"
      }
    }
    {
      name: peri_usb_0
      clock_group:
      {
        name: peri
        src: top
        sw_cg: yes
        unique: no
        clocks:
        {
          clk_io_div4_peri: io_div4
          clk_io_div2_peri: io_div2
          clk_io_peri: io
          clk_usb_peri: usb
          clk_aon_peri: aon
        }
      }
      clock_connection: clkmgr_aon_clocks.clk_usb_peri
      unmanaged_clock: false
      unmanaged_reset: false
      reset_connection:
      {
        name: usb
        domain: "0"
      }
    }
    {
      name: powerup_por_io_div4_Aon
      clock_group:
      {
        name: powerup
        src: top
        sw_cg: no
        unique: no
        clocks:
        {
          clk_io_div4_powerup: io_div4
          clk_aon_powerup: aon
          clk_main_powerup: main
          clk_io_powerup: io
          clk_usb_powerup: usb
          clk_io_div2_powerup: io_div2
        }
      }
      clock_connection: clkmgr_aon_clocks.clk_io_div4_powerup
      unmanaged_clock: false
      unmanaged_reset: false
      reset_connection:
      {
        name: por_io_div4
        domain: Aon
      }
    }
    {
      name: powerup_lc_io_div4_Aon
      clock_group:
      {
        name: powerup
        src: top
        sw_cg: no
        unique: no
        clocks:
        {
          clk_io_div4_powerup: io_div4
          clk_aon_powerup: aon
          clk_main_powerup: main
          clk_io_powerup: io
          clk_usb_powerup: usb
          clk_io_div2_powerup: io_div2
        }
      }
      clock_connection: clkmgr_aon_clocks.clk_io_div4_powerup
      unmanaged_clock: false
      unmanaged_reset: false
      reset_connection:
      {
        name: lc_io_div4
        domain: Aon
      }
    }
    {
      name: secure_lc_io_div4_Aon
      clock_group:
      {
        name: secure
        src: top
        sw_cg: no
        unique: no
        clocks:
        {
          clk_io_div4_secure: io_div4
          clk_main_secure: main
          clk_aon_secure: aon
        }
      }
      clock_connection: clkmgr_aon_clocks.clk_io_div4_secure
      unmanaged_clock: false
      unmanaged_reset: false
      reset_connection:
      {
        name: lc_io_div4
        domain: Aon
      }
    }
    {
      name: peri_lc_io_div4_Aon
      clock_group:
      {
        name: peri
        src: top
        sw_cg: yes
        unique: no
        clocks:
        {
          clk_io_div4_peri: io_div4
          clk_io_div2_peri: io_div2
          clk_io_peri: io
          clk_usb_peri: usb
          clk_aon_peri: aon
        }
      }
      clock_connection: clkmgr_aon_clocks.clk_io_div4_peri
      unmanaged_clock: false
      unmanaged_reset: false
      reset_connection:
      {
        name: lc_io_div4
        domain: Aon
      }
    }
    {
      name: timers_lc_io_div4_Aon
      clock_group:
      {
        name: timers
        src: top
        sw_cg: no
        unique: no
        clocks:
        {
          clk_io_div4_timers: io_div4
          clk_aon_timers: aon
        }
      }
      clock_connection: clkmgr_aon_clocks.clk_io_div4_timers
      unmanaged_clock: false
      unmanaged_reset: false
      reset_connection:
      {
        name: lc_io_div4
        domain: Aon
      }
    }
    {
      name: infra_lc_io_div4_0
      clock_group:
      {
        name: infra
        src: top
        sw_cg: no
        unique: no
        clocks:
        {
          clk_io_div4_infra: io_div4
          clk_main_infra: main
          clk_usb_infra: usb
          clk_io_infra: io
          clk_io_div2_infra: io_div2
        }
      }
      clock_connection: clkmgr_aon_clocks.clk_io_div4_infra
      unmanaged_clock: false
      unmanaged_reset: false
      reset_connection:
      {
        name: lc_io_div4
        domain: "0"
      }
    }
    {
      name: infra_lc_io_div4_Aon
      clock_group:
      {
        name: infra
        src: top
        sw_cg: no
        unique: no
        clocks:
        {
          clk_io_div4_infra: io_div4
          clk_main_infra: main
          clk_usb_infra: usb
          clk_io_infra: io
          clk_io_div2_infra: io_div2
        }
      }
      clock_connection: clkmgr_aon_clocks.clk_io_div4_infra
      unmanaged_clock: false
      unmanaged_reset: false
      reset_connection:
      {
        name: lc_io_div4
        domain: Aon
      }
    }
    {
      name: infra_lc_0
      clock_group:
      {
        name: infra
        src: top
        sw_cg: no
        unique: no
        clocks:
        {
          clk_io_div4_infra: io_div4
          clk_main_infra: main
          clk_usb_infra: usb
          clk_io_infra: io
          clk_io_div2_infra: io_div2
        }
      }
      clock_connection: clkmgr_aon_clocks.clk_main_infra
      unmanaged_clock: false
      unmanaged_reset: false
      reset_connection:
      {
        name: lc
        domain: "0"
      }
    }
    {
      name: infra_sys_0
      clock_group:
      {
        name: infra
        src: top
        sw_cg: no
        unique: no
        clocks:
        {
          clk_io_div4_infra: io_div4
          clk_main_infra: main
          clk_usb_infra: usb
          clk_io_infra: io
          clk_io_div2_infra: io_div2
        }
      }
      clock_connection: clkmgr_aon_clocks.clk_main_infra
      unmanaged_clock: false
      unmanaged_reset: false
      reset_connection:
      {
        name: sys
        domain: "0"
      }
    }
    {
      name: secure_lc_0
      clock_group:
      {
        name: secure
        src: top
        sw_cg: no
        unique: no
        clocks:
        {
          clk_io_div4_secure: io_div4
          clk_main_secure: main
          clk_aon_secure: aon
        }
      }
      clock_connection: clkmgr_aon_clocks.clk_main_secure
      unmanaged_clock: false
      unmanaged_reset: false
      reset_connection:
      {
        name: lc
        domain: "0"
      }
    }
    {
      name: aes_trans_lc_0
      clock_group:
      {
        name: trans
        src: top
        sw_cg: hint
        unique: yes
        clocks:
        {
          clk_main_aes: main
          clk_main_hmac: main
          clk_main_kmac: main
          clk_main_otbn: main
        }
      }
      clock_connection: clkmgr_aon_clocks.clk_main_aes
      unmanaged_clock: false
      unmanaged_reset: false
      reset_connection:
      {
        name: lc
        domain: "0"
      }
    }
    {
      name: hmac_trans_lc_0
      clock_group:
      {
        name: trans
        src: top
        sw_cg: hint
        unique: yes
        clocks:
        {
          clk_main_aes: main
          clk_main_hmac: main
          clk_main_kmac: main
          clk_main_otbn: main
        }
      }
      clock_connection: clkmgr_aon_clocks.clk_main_hmac
      unmanaged_clock: false
      unmanaged_reset: false
      reset_connection:
      {
        name: lc
        domain: "0"
      }
    }
    {
      name: kmac_trans_lc_0
      clock_group:
      {
        name: trans
        src: top
        sw_cg: hint
        unique: yes
        clocks:
        {
          clk_main_aes: main
          clk_main_hmac: main
          clk_main_kmac: main
          clk_main_otbn: main
        }
      }
      clock_connection: clkmgr_aon_clocks.clk_main_kmac
      unmanaged_clock: false
      unmanaged_reset: false
      reset_connection:
      {
        name: lc
        domain: "0"
      }
    }
    {
      name: otbn_trans_lc_0
      clock_group:
      {
        name: trans
        src: top
        sw_cg: hint
        unique: yes
        clocks:
        {
          clk_main_aes: main
          clk_main_hmac: main
          clk_main_kmac: main
          clk_main_otbn: main
        }
      }
      clock_connection: clkmgr_aon_clocks.clk_main_otbn
      unmanaged_clock: false
      unmanaged_reset: false
      reset_connection:
      {
        name: lc
        domain: "0"
      }
    }
  ]
  outgoing_alert_lpgs: {}
  inter_signal:
  {
    signals:
    [
      {
        name: lsio_trigger
        desc:
          '''
          Self-clearing status trigger for the DMA.
          Set when RX or TX FIFOs are past their configured watermarks matching watermark interrupt behaviour.
          '''
        struct: logic
        type: uni
        act: req
        width: 1
        inst_name: uart0
        index: -1
      }
      {
        name: racl_policies
        desc:
          '''
          Incoming RACL policy vector from a racl_ctrl instance.
          The policy selection vector (parameter) selects the policy for each register.
          '''
        struct: racl_policy_vec
        package: top_racl_pkg
        type: uni
        act: rcv
        width: 1
        inst_name: uart0
        index: -1
      }
      {
        name: racl_error
        desc: RACL error log information of this module.
        struct: racl_error_log
        package: top_racl_pkg
        type: uni
        act: req
        width: 1
        inst_name: uart0
        index: -1
      }
      {
        name: tl
        struct: tl
        package: tlul_pkg
        type: req_rsp
        act: rsp
        width: 1
        inst_name: uart0
        default: ""
        end_idx: -1
        top_signame: uart0_tl
        index: -1
      }
      {
        name: lsio_trigger
        desc:
          '''
          Self-clearing status trigger for the DMA.
          Set when RX or TX FIFOs are past their configured watermarks matching watermark interrupt behaviour.
          '''
        struct: logic
        type: uni
        act: req
        width: 1
        inst_name: uart1
        index: -1
      }
      {
        name: racl_policies
        desc:
          '''
          Incoming RACL policy vector from a racl_ctrl instance.
          The policy selection vector (parameter) selects the policy for each register.
          '''
        struct: racl_policy_vec
        package: top_racl_pkg
        type: uni
        act: rcv
        width: 1
        inst_name: uart1
        index: -1
      }
      {
        name: racl_error
        desc: RACL error log information of this module.
        struct: racl_error_log
        package: top_racl_pkg
        type: uni
        act: req
        width: 1
        inst_name: uart1
        index: -1
      }
      {
        name: tl
        struct: tl
        package: tlul_pkg
        type: req_rsp
        act: rsp
        width: 1
        inst_name: uart1
        default: ""
        end_idx: -1
        top_signame: uart1_tl
        index: -1
      }
      {
        name: lsio_trigger
        desc:
          '''
          Self-clearing status trigger for the DMA.
          Set when RX or TX FIFOs are past their configured watermarks matching watermark interrupt behaviour.
          '''
        struct: logic
        type: uni
        act: req
        width: 1
        inst_name: uart2
        index: -1
      }
      {
        name: racl_policies
        desc:
          '''
          Incoming RACL policy vector from a racl_ctrl instance.
          The policy selection vector (parameter) selects the policy for each register.
          '''
        struct: racl_policy_vec
        package: top_racl_pkg
        type: uni
        act: rcv
        width: 1
        inst_name: uart2
        index: -1
      }
      {
        name: racl_error
        desc: RACL error log information of this module.
        struct: racl_error_log
        package: top_racl_pkg
        type: uni
        act: req
        width: 1
        inst_name: uart2
        index: -1
      }
      {
        name: tl
        struct: tl
        package: tlul_pkg
        type: req_rsp
        act: rsp
        width: 1
        inst_name: uart2
        default: ""
        end_idx: -1
        top_signame: uart2_tl
        index: -1
      }
      {
        name: lsio_trigger
        desc:
          '''
          Self-clearing status trigger for the DMA.
          Set when RX or TX FIFOs are past their configured watermarks matching watermark interrupt behaviour.
          '''
        struct: logic
        type: uni
        act: req
        width: 1
        inst_name: uart3
        index: -1
      }
      {
        name: racl_policies
        desc:
          '''
          Incoming RACL policy vector from a racl_ctrl instance.
          The policy selection vector (parameter) selects the policy for each register.
          '''
        struct: racl_policy_vec
        package: top_racl_pkg
        type: uni
        act: rcv
        width: 1
        inst_name: uart3
        index: -1
      }
      {
        name: racl_error
        desc: RACL error log information of this module.
        struct: racl_error_log
        package: top_racl_pkg
        type: uni
        act: req
        width: 1
        inst_name: uart3
        index: -1
      }
      {
        name: tl
        struct: tl
        package: tlul_pkg
        type: req_rsp
        act: rsp
        width: 1
        inst_name: uart3
        default: ""
        end_idx: -1
        top_signame: uart3_tl
        index: -1
      }
      {
        name: strap_en
        desc:
          '''
          The strap enable signal tells gpio to take a snapshot of the input pins.
          The behaviour of this signal after that event will have no effect.
          '''
        struct: logic
        type: uni
        act: rcv
        width: 1
        default: 1'b0
        inst_name: gpio
        index: -1
      }
      {
        name: sampled_straps
        desc: This vector contains the sampled strap values.
        struct: gpio_straps
        package: gpio_pkg
        type: uni
        act: req
        width: 1
        default: "'0"
        inst_name: gpio
        index: -1
      }
      {
        name: racl_policies
        desc:
          '''
          Incoming RACL policy vector from a racl_ctrl instance.
          The policy selection vector (parameter) selects the policy for each register.
          '''
        struct: racl_policy_vec
        package: top_racl_pkg
        type: uni
        act: rcv
        width: 1
        inst_name: gpio
        index: -1
      }
      {
        name: racl_error
        desc: RACL error log information of this module.
        struct: racl_error_log
        package: top_racl_pkg
        type: uni
        act: req
        width: 1
        inst_name: gpio
        index: -1
      }
      {
        name: tl
        struct: tl
        package: tlul_pkg
        type: req_rsp
        act: rsp
        width: 1
        inst_name: gpio
        default: ""
        end_idx: -1
        top_signame: gpio_tl
        index: -1
      }
      {
        name: ram_cfg_sys2spi
        struct: ram_2p_cfg
        package: prim_ram_2p_pkg
        type: uni
        act: rcv
        width: 1
        inst_name: spi_device
        default: ""
        top_signame: ast_spi_ram_2p_cfg
        index: -1
      }
      {
        name: ram_cfg_rsp_sys2spi
        struct: ram_2p_cfg_rsp
        package: prim_ram_2p_pkg
        type: uni
        act: req
        width: 1
        inst_name: spi_device
        index: -1
      }
      {
        name: ram_cfg_spi2sys
        struct: ram_2p_cfg
        package: prim_ram_2p_pkg
        type: uni
        act: rcv
        width: 1
        inst_name: spi_device
        default: ""
        top_signame: ast_spi_ram_2p_cfg
        index: -1
      }
      {
        name: ram_cfg_rsp_spi2sys
        struct: ram_2p_cfg_rsp
        package: prim_ram_2p_pkg
        type: uni
        act: req
        width: 1
        inst_name: spi_device
        index: -1
      }
      {
        name: passthrough
        struct: passthrough
        package: spi_device_pkg
        type: req_rsp
        act: req
        width: 1
        inst_name: spi_device
        default: ""
        end_idx: -1
        top_signame: spi_device_passthrough
        index: -1
      }
      {
        name: mbist_en
        struct: logic
        type: uni
        act: rcv
        width: 1
        inst_name: spi_device
        index: -1
      }
      {
        name: sck_monitor
        struct: logic
        type: uni
        act: req
        width: 1
        inst_name: spi_device
        default: ""
        package: ""
        external: true
        top_signame: sck_monitor
        conn_type: false
        index: -1
      }
      {
        name: racl_policies
        desc:
          '''
          Incoming RACL policy vector from a racl_ctrl instance.
          The policy selection vector (parameter) selects the policy for each register.
          '''
        struct: racl_policy_vec
        package: top_racl_pkg
        type: uni
        act: rcv
        width: 1
        inst_name: spi_device
        index: -1
      }
      {
        name: racl_error
        desc: RACL error log information of this module.
        struct: racl_error_log
        package: top_racl_pkg
        type: uni
        act: req
        width: 1
        inst_name: spi_device
        index: -1
      }
      {
        name: tl
        struct: tl
        package: tlul_pkg
        type: req_rsp
        act: rsp
        width: 1
        inst_name: spi_device
        default: ""
        end_idx: -1
        top_signame: spi_device_tl
        index: -1
      }
      {
        name: ram_cfg
        struct: ram_1p_cfg
        package: prim_ram_1p_pkg
        type: uni
        act: rcv
        width: 1
        inst_name: i2c0
        default: ""
        top_signame: ast_ram_1p_cfg
        index: -1
      }
      {
        name: ram_cfg_rsp
        struct: ram_1p_cfg_rsp
        package: prim_ram_1p_pkg
        type: uni
        act: req
        width: 1
        inst_name: i2c0
        index: -1
      }
      {
        name: lsio_trigger
        desc:
          '''
          Self-clearing status trigger for the DMA.
          Set when RX TX FIFO is past their configured watermark matching watermark interrupt behaviour.
          '''
        struct: logic
        type: uni
        act: req
        width: 1
        inst_name: i2c0
        index: -1
      }
      {
        name: racl_policies
        desc:
          '''
          Incoming RACL policy vector from a racl_ctrl instance.
          The policy selection vector (parameter) selects the policy for each register.
          '''
        struct: racl_policy_vec
        package: top_racl_pkg
        type: uni
        act: rcv
        width: 1
        inst_name: i2c0
        index: -1
      }
      {
        name: racl_error
        desc: RACL error log information of this module.
        struct: racl_error_log
        package: top_racl_pkg
        type: uni
        act: req
        width: 1
        inst_name: i2c0
        index: -1
      }
      {
        name: tl
        struct: tl
        package: tlul_pkg
        type: req_rsp
        act: rsp
        width: 1
        inst_name: i2c0
        default: ""
        end_idx: -1
        top_signame: i2c0_tl
        index: -1
      }
      {
        name: ram_cfg
        struct: ram_1p_cfg
        package: prim_ram_1p_pkg
        type: uni
        act: rcv
        width: 1
        inst_name: i2c1
        default: ""
        top_signame: ast_ram_1p_cfg
        index: -1
      }
      {
        name: ram_cfg_rsp
        struct: ram_1p_cfg_rsp
        package: prim_ram_1p_pkg
        type: uni
        act: req
        width: 1
        inst_name: i2c1
        index: -1
      }
      {
        name: lsio_trigger
        desc:
          '''
          Self-clearing status trigger for the DMA.
          Set when RX TX FIFO is past their configured watermark matching watermark interrupt behaviour.
          '''
        struct: logic
        type: uni
        act: req
        width: 1
        inst_name: i2c1
        index: -1
      }
      {
        name: racl_policies
        desc:
          '''
          Incoming RACL policy vector from a racl_ctrl instance.
          The policy selection vector (parameter) selects the policy for each register.
          '''
        struct: racl_policy_vec
        package: top_racl_pkg
        type: uni
        act: rcv
        width: 1
        inst_name: i2c1
        index: -1
      }
      {
        name: racl_error
        desc: RACL error log information of this module.
        struct: racl_error_log
        package: top_racl_pkg
        type: uni
        act: req
        width: 1
        inst_name: i2c1
        index: -1
      }
      {
        name: tl
        struct: tl
        package: tlul_pkg
        type: req_rsp
        act: rsp
        width: 1
        inst_name: i2c1
        default: ""
        end_idx: -1
        top_signame: i2c1_tl
        index: -1
      }
      {
        name: ram_cfg
        struct: ram_1p_cfg
        package: prim_ram_1p_pkg
        type: uni
        act: rcv
        width: 1
        inst_name: i2c2
        default: ""
        top_signame: ast_ram_1p_cfg
        index: -1
      }
      {
        name: ram_cfg_rsp
        struct: ram_1p_cfg_rsp
        package: prim_ram_1p_pkg
        type: uni
        act: req
        width: 1
        inst_name: i2c2
        index: -1
      }
      {
        name: lsio_trigger
        desc:
          '''
          Self-clearing status trigger for the DMA.
          Set when RX TX FIFO is past their configured watermark matching watermark interrupt behaviour.
          '''
        struct: logic
        type: uni
        act: req
        width: 1
        inst_name: i2c2
        index: -1
      }
      {
        name: racl_policies
        desc:
          '''
          Incoming RACL policy vector from a racl_ctrl instance.
          The policy selection vector (parameter) selects the policy for each register.
          '''
        struct: racl_policy_vec
        package: top_racl_pkg
        type: uni
        act: rcv
        width: 1
        inst_name: i2c2
        index: -1
      }
      {
        name: racl_error
        desc: RACL error log information of this module.
        struct: racl_error_log
        package: top_racl_pkg
        type: uni
        act: req
        width: 1
        inst_name: i2c2
        index: -1
      }
      {
        name: tl
        struct: tl
        package: tlul_pkg
        type: req_rsp
        act: rsp
        width: 1
        inst_name: i2c2
        default: ""
        end_idx: -1
        top_signame: i2c2_tl
        index: -1
      }
      {
        name: tl
        struct: tl
        package: tlul_pkg
        type: req_rsp
        act: rsp
        width: 1
        inst_name: pattgen
        default: ""
        end_idx: -1
        top_signame: pattgen_tl
        index: -1
      }
      {
        name: racl_policies
        desc:
          '''
          Incoming RACL policy vector from a racl_ctrl instance.
          The policy selection vector (parameter) selects the policy for each register.
          '''
        struct: racl_policy_vec
        package: top_racl_pkg
        type: uni
        act: rcv
        width: 1
        inst_name: rv_timer
        index: -1
      }
      {
        name: racl_error
        desc: RACL error log information of this module.
        struct: racl_error_log
        package: top_racl_pkg
        type: uni
        act: req
        width: 1
        inst_name: rv_timer
        index: -1
      }
      {
        name: tl
        struct: tl
        package: tlul_pkg
        type: req_rsp
        act: rsp
        width: 1
        inst_name: rv_timer
        default: ""
        end_idx: -1
        top_signame: rv_timer_tl
        index: -1
      }
      {
        name: edn
        desc: Entropy request to the entropy distribution network for LFSR reseeding and ephemeral key derivation.
        struct: edn
        package: edn_pkg
        type: req_rsp
        act: req
        width: 1
        inst_name: otp_ctrl
        default: ""
        top_signame: edn0_edn
        index: 1
      }
      {
        name: pwr_otp
        desc: Initialization request/acknowledge from/to power manager.
        struct: pwr_otp
        package: pwrmgr_pkg
        type: req_rsp
        act: rsp
        width: 1
        default: "'0"
        inst_name: otp_ctrl
        top_signame: pwrmgr_aon_pwr_otp
        index: -1
      }
      {
        name: lc_otp_program
        desc: Life cycle state transition interface.
        struct: lc_otp_program
        package: otp_ctrl_pkg
        type: req_rsp
        act: rsp
        width: 1
        default: "'0"
        inst_name: otp_ctrl
        top_signame: lc_ctrl_lc_otp_program
        index: -1
      }
      {
        name: otp_lc_data
        desc:
          '''
          Life cycle state output holding the current life cycle state,
          the value of the transition counter and the tokens needed for life cycle transitions.
          '''
        struct: otp_lc_data
        package: otp_ctrl_pkg
        type: uni
        act: req
        width: 1
        default: "'0"
        inst_name: otp_ctrl
        end_idx: -1
        top_type: broadcast
        top_signame: otp_ctrl_otp_lc_data
        index: -1
      }
      {
        name: lc_escalate_en
        desc:
          '''
          Life cycle escalation enable coming from life cycle controller.
          This signal moves all FSMs within OTP into the error state.
          '''
        struct: lc_tx
        package: lc_ctrl_pkg
        type: uni
        act: rcv
        width: 1
        default: lc_ctrl_pkg::Off
        inst_name: otp_ctrl
        top_signame: lc_ctrl_lc_escalate_en
        index: -1
      }
      {
        name: lc_creator_seed_sw_rw_en
        desc:
          '''
          Provision enable qualifier coming from life cycle controller.
          This signal enables SW read / write access to the RMA_TOKEN and CREATOR_ROOT_KEY_SHARE0 and CREATOR_ROOT_KEY_SHARE1.
          '''
        struct: lc_tx
        package: lc_ctrl_pkg
        type: uni
        act: rcv
        width: 1
        default: lc_ctrl_pkg::Off
        inst_name: otp_ctrl
        top_signame: lc_ctrl_lc_creator_seed_sw_rw_en
        index: -1
      }
      {
        name: lc_owner_seed_sw_rw_en
        desc:
          '''
          Provision enable qualifier coming from life cycle controller.
          This signal enables SW read / write access to the OWNER_SEED.
          '''
        struct: lc_tx
        package: lc_ctrl_pkg
        type: uni
        act: rcv
        width: 1
        default: lc_ctrl_pkg::Off
        inst_name: otp_ctrl
        index: -1
      }
      {
        name: lc_seed_hw_rd_en
        desc:
          '''
          Seed read enable coming from life cycle controller.
          This signal enables HW read access to the CREATOR_ROOT_KEY_SHARE0 and CREATOR_ROOT_KEY_SHARE1.
          '''
        struct: lc_tx
        package: lc_ctrl_pkg
        type: uni
        act: rcv
        width: 1
        default: lc_ctrl_pkg::Off
        inst_name: otp_ctrl
        top_signame: lc_ctrl_lc_seed_hw_rd_en
        index: -1
      }
      {
        name: lc_check_byp_en
        desc:
          '''
          Life cycle partition check bypass signal.
          This signal causes the life cycle partition to bypass consistency checks during life cycle state transitions in order to prevent spurious consistency check failures.
          '''
        struct: lc_tx
        package: lc_ctrl_pkg
        type: uni
        act: rcv
        width: 1
        default: lc_ctrl_pkg::Off
        inst_name: otp_ctrl
        top_signame: lc_ctrl_lc_check_byp_en
        index: -1
      }
      {
        name: otp_keymgr_key
        desc: Key output to the key manager holding CREATOR_ROOT_KEY_SHARE0 and CREATOR_ROOT_KEY_SHARE1.
        struct: otp_keymgr_key
        package: otp_ctrl_pkg
        type: uni
        act: req
        width: 1
        default: "'0"
        inst_name: otp_ctrl
        end_idx: -1
        top_type: broadcast
        top_signame: otp_ctrl_otp_keymgr_key
        index: -1
      }
      {
        name: flash_otp_key
        desc: Key derivation interface for FLASH scrambling.
        struct: flash_otp_key
        package: otp_ctrl_pkg
        type: req_rsp
        act: rsp
        width: 1
        default: "'0"
        inst_name: otp_ctrl
        top_signame: flash_ctrl_otp
        index: -1
      }
      {
        name: sram_otp_key
        desc: Array with key derivation interfaces for SRAM scrambling devices.
        struct: sram_otp_key
        package: otp_ctrl_pkg
        type: req_rsp
        act: rsp
        width: 4
        default: "'0"
        inst_name: otp_ctrl
        end_idx: 3
        top_type: partial-one-to-N
        top_signame: otp_ctrl_sram_otp_key
        index: -1
      }
      {
        name: otbn_otp_key
        desc: Key derivation interface for OTBN scrambling devices.
        struct: otbn_otp_key
        package: otp_ctrl_pkg
        type: req_rsp
        act: rsp
        width: 1
        default: "'0"
        inst_name: otp_ctrl
        end_idx: -1
        top_signame: otp_ctrl_otbn_otp_key
        index: -1
      }
      {
        name: otp_broadcast
        desc: Output of the HW partitions with breakout data types.
        struct: otp_broadcast
        package: otp_ctrl_part_pkg
        type: uni
        act: req
        width: 1
        default: "'0"
        inst_name: otp_ctrl
        top_signame: otp_ctrl_otp_broadcast
        index: -1
      }
      {
        name: otp_macro
        desc: Data interface for the OTP macro.
        struct: otp_ctrl_macro
        package: otp_ctrl_macro_pkg
        type: req_rsp
        act: req
        width: 1
        default: "'0"
        inst_name: otp_ctrl
        end_idx: -1
        top_signame: otp_ctrl_otp_macro
        index: -1
      }
      {
        name: core_tl
        struct: tl
        package: tlul_pkg
        type: req_rsp
        act: rsp
        width: 1
        inst_name: otp_ctrl
        default: ""
        end_idx: -1
        top_signame: otp_ctrl_core_tl
        index: -1
      }
      {
        name: obs_ctrl
        desc: AST observability control signals.
        struct: ast_obs_ctrl
        package: ast_pkg
        type: uni
        act: rcv
        width: 1
        inst_name: otp_macro
        default: ""
        top_signame: ast_obs_ctrl
        index: -1
      }
      {
        name: otp_obs
        desc: AST observability bus.
        struct: logic
        type: uni
        act: req
        width: 8
        inst_name: otp_macro
        default: ""
        package: ""
        external: true
        top_signame: otp_obs
        conn_type: false
        index: -1
      }
      {
        name: pwr_seq
        desc: Power sequencing signals to AST (VDD domain).
        struct: pwr_seq
        package: otp_macro_pkg
        type: uni
        act: req
        width: 1
        default: "'0"
        inst_name: otp_macro
        external: true
        top_signame: otp_macro_pwr_seq
        conn_type: false
        index: -1
      }
      {
        name: pwr_seq_h
        desc: Power sequencing signals coming from AST (VCC domain).
        struct: pwr_seq
        package: otp_macro_pkg
        type: uni
        act: rcv
        width: 1
        default: "'0"
        inst_name: otp_macro
        external: true
        top_signame: otp_macro_pwr_seq_h
        conn_type: false
        index: -1
      }
      {
        name: ext_voltage_h
        struct: ""
        type: io
        act: none
        width: 1
        default: "'0"
        inst_name: otp_macro
        package: ""
        external: true
        top_signame: otp_ext_voltage_h
        conn_type: false
        index: -1
      }
      {
        name: lc_dft_en
        desc:
          '''
          Test enable qualifier coming from life cycle controller.
          This signals enables the TL-UL access port.
          '''
        struct: lc_tx
        package: lc_ctrl_pkg
        type: uni
        act: rcv
        width: 1
        default: lc_ctrl_pkg::Off
        inst_name: otp_macro
        top_signame: lc_ctrl_lc_dft_en
        index: -1
      }
      {
        name: test
        desc: Vendor test control signals from/to the life cycle TAP.
        struct: otp_test
        package: otp_macro_pkg
        type: req_rsp
        act: rsp
        width: 1
        default: "'0"
        inst_name: otp_macro
        top_signame: lc_ctrl_lc_otp_vendor_test
        index: -1
      }
      {
        name: otp
        desc: Data interface for the OTP macro.
        struct: otp_ctrl_macro
        package: otp_ctrl_macro_pkg
        type: req_rsp
        act: rsp
        width: 1
        default: "'0"
        inst_name: otp_macro
        top_signame: otp_ctrl_otp_macro
        index: -1
      }
      {
        name: cfg
        struct: otp_cfg
        package: otp_macro_pkg
        type: uni
        act: rcv
        width: 1
        default: "'0"
        inst_name: otp_macro
        index: -1
      }
      {
        name: cfg_rsp
        struct: otp_cfg_rsp
        package: otp_macro_pkg
        type: uni
        act: req
        width: 1
        default: "'0"
        inst_name: otp_macro
        index: -1
      }
      {
        name: tl
        struct: tl
        package: tlul_pkg
        type: req_rsp
        act: rsp
        width: 1
        inst_name: otp_macro
        default: ""
        end_idx: -1
        top_signame: otp_macro_tl
        index: -1
      }
      {
        name: jtag
        struct: jtag
        package: jtag_pkg
        type: req_rsp
        act: rsp
        width: 1
        inst_name: lc_ctrl
        default: ""
        top_signame: pinmux_aon_lc_jtag
        index: -1
      }
      {
        name: esc_scrap_state0_tx
        struct: esc_tx
        package: prim_esc_pkg
        type: uni
        act: rcv
        width: 1
        inst_name: lc_ctrl
        default: ""
        top_signame: alert_handler_esc_tx
        index: 1
      }
      {
        name: esc_scrap_state0_rx
        struct: esc_rx
        package: prim_esc_pkg
        type: uni
        act: req
        width: 1
        inst_name: lc_ctrl
        default: ""
        top_signame: alert_handler_esc_rx
        index: 1
      }
      {
        name: esc_scrap_state1_tx
        struct: esc_tx
        package: prim_esc_pkg
        type: uni
        act: rcv
        width: 1
        inst_name: lc_ctrl
        default: ""
        top_signame: alert_handler_esc_tx
        index: 2
      }
      {
        name: esc_scrap_state1_rx
        struct: esc_rx
        package: prim_esc_pkg
        type: uni
        act: req
        width: 1
        inst_name: lc_ctrl
        default: ""
        top_signame: alert_handler_esc_rx
        index: 2
      }
      {
        name: pwr_lc
        struct: pwr_lc
        package: lc_ctrl_pkg
        type: req_rsp
        act: rsp
        width: 1
        inst_name: lc_ctrl
        default: ""
        top_signame: pwrmgr_aon_pwr_lc
        index: -1
      }
      {
        name: lc_otp_vendor_test
        struct: otp_test
        package: otp_macro_pkg
        type: req_rsp
        act: req
        width: 1
        default: "'0"
        inst_name: lc_ctrl
        end_idx: -1
        top_signame: lc_ctrl_lc_otp_vendor_test
        index: -1
      }
      {
        name: otp_lc_data
        struct: otp_lc_data
        package: otp_ctrl_pkg
        type: uni
        act: rcv
        width: 1
        default: otp_ctrl_pkg::OTP_LC_DATA_DEFAULT
        inst_name: lc_ctrl
        top_signame: otp_ctrl_otp_lc_data
        index: -1
      }
      {
        name: lc_otp_program
        struct: lc_otp_program
        package: otp_ctrl_pkg
        type: req_rsp
        act: req
        width: 1
        default: "'0"
        inst_name: lc_ctrl
        end_idx: -1
        top_signame: lc_ctrl_lc_otp_program
        index: -1
      }
      {
        name: kmac_data
        struct: app
        package: kmac_pkg
        type: req_rsp
        act: req
        width: 1
        default: "'0"
        inst_name: lc_ctrl
        top_signame: kmac_app
        index: 1
      }
      {
        name: lc_raw_test_rma
        struct: lc_tx
        package: lc_ctrl_pkg
        type: uni
        act: req
        width: 1
        default: lc_ctrl_pkg::Off
        inst_name: lc_ctrl
        index: -1
      }
      {
        name: lc_dft_en
        struct: lc_tx
        package: lc_ctrl_pkg
        type: uni
        act: req
        width: 1
        default: lc_ctrl_pkg::Off
        inst_name: lc_ctrl
        end_idx: -1
        top_type: broadcast
        top_signame: lc_ctrl_lc_dft_en
        index: -1
      }
      {
        name: lc_nvm_debug_en
        struct: lc_tx
        package: lc_ctrl_pkg
        type: uni
        act: req
        width: 1
        default: lc_ctrl_pkg::Off
        inst_name: lc_ctrl
        end_idx: -1
        top_type: broadcast
        top_signame: lc_ctrl_lc_nvm_debug_en
        index: -1
      }
      {
        name: lc_hw_debug_en
        struct: lc_tx
        package: lc_ctrl_pkg
        type: uni
        act: req
        width: 1
        default: lc_ctrl_pkg::Off
        inst_name: lc_ctrl
        end_idx: -1
        top_type: broadcast
        top_signame: lc_ctrl_lc_hw_debug_en
        index: -1
      }
      {
        name: lc_cpu_en
        struct: lc_tx
        package: lc_ctrl_pkg
        type: uni
        act: req
        width: 1
        default: lc_ctrl_pkg::Off
        inst_name: lc_ctrl
        end_idx: -1
        top_type: broadcast
        top_signame: lc_ctrl_lc_cpu_en
        index: -1
      }
      {
        name: lc_keymgr_en
        struct: lc_tx
        package: lc_ctrl_pkg
        type: uni
        act: req
        width: 1
        default: lc_ctrl_pkg::Off
        inst_name: lc_ctrl
        end_idx: -1
        top_type: broadcast
        top_signame: lc_ctrl_lc_keymgr_en
        index: -1
      }
      {
        name: lc_escalate_en
        struct: lc_tx
        package: lc_ctrl_pkg
        type: uni
        act: req
        width: 1
        default: lc_ctrl_pkg::Off
        inst_name: lc_ctrl
        end_idx: -1
        top_type: broadcast
        top_signame: lc_ctrl_lc_escalate_en
        index: -1
      }
      {
        name: lc_clk_byp_req
        struct: lc_tx
        package: lc_ctrl_pkg
        type: uni
        act: req
        width: 1
        default: lc_ctrl_pkg::Off
        inst_name: lc_ctrl
        end_idx: -1
        top_type: broadcast
        top_signame: lc_ctrl_lc_clk_byp_req
        index: -1
      }
      {
        name: lc_clk_byp_ack
        struct: lc_tx
        package: lc_ctrl_pkg
        type: uni
        act: rcv
        width: 1
        default: lc_ctrl_pkg::Off
        inst_name: lc_ctrl
        end_idx: -1
        top_type: broadcast
        top_signame: lc_ctrl_lc_clk_byp_ack
        index: -1
      }
      {
        name: lc_flash_rma_req
        struct: lc_tx
        package: lc_ctrl_pkg
        type: uni
        act: req
        width: 1
        default: lc_ctrl_pkg::Off
        inst_name: lc_ctrl
        end_idx: -1
        top_type: broadcast
        top_signame: lc_ctrl_lc_flash_rma_req
        index: -1
      }
      {
        name: lc_flash_rma_ack
        struct: lc_tx
        package: lc_ctrl_pkg
        type: uni
        act: rcv
        width: 2
        default: lc_ctrl_pkg::On
        inst_name: lc_ctrl
        end_idx: -1
        top_type: one-to-N
        top_signame: lc_ctrl_lc_flash_rma_ack
        index: -1
      }
      {
        name: lc_flash_rma_seed
        struct: lc_flash_rma_seed
        package: lc_ctrl_pkg
        type: uni
        act: req
        width: 1
        default: "'0"
        inst_name: lc_ctrl
        top_signame: flash_ctrl_rma_seed
        index: -1
      }
      {
        name: lc_check_byp_en
        struct: lc_tx
        package: lc_ctrl_pkg
        type: uni
        act: req
        width: 1
        default: lc_ctrl_pkg::Off
        inst_name: lc_ctrl
        end_idx: -1
        top_type: broadcast
        top_signame: lc_ctrl_lc_check_byp_en
        index: -1
      }
      {
        name: lc_creator_seed_sw_rw_en
        struct: lc_tx
        package: lc_ctrl_pkg
        type: uni
        act: req
        width: 1
        default: lc_ctrl_pkg::Off
        inst_name: lc_ctrl
        end_idx: -1
        top_type: broadcast
        top_signame: lc_ctrl_lc_creator_seed_sw_rw_en
        index: -1
      }
      {
        name: lc_owner_seed_sw_rw_en
        struct: lc_tx
        package: lc_ctrl_pkg
        type: uni
        act: req
        width: 1
        default: lc_ctrl_pkg::Off
        inst_name: lc_ctrl
        end_idx: -1
        top_type: broadcast
        top_signame: lc_ctrl_lc_owner_seed_sw_rw_en
        index: -1
      }
      {
        name: lc_iso_part_sw_rd_en
        struct: lc_tx
        package: lc_ctrl_pkg
        type: uni
        act: req
        width: 1
        default: lc_ctrl_pkg::Off
        inst_name: lc_ctrl
        end_idx: -1
        top_type: broadcast
        top_signame: lc_ctrl_lc_iso_part_sw_rd_en
        index: -1
      }
      {
        name: lc_iso_part_sw_wr_en
        struct: lc_tx
        package: lc_ctrl_pkg
        type: uni
        act: req
        width: 1
        default: lc_ctrl_pkg::Off
        inst_name: lc_ctrl
        end_idx: -1
        top_type: broadcast
        top_signame: lc_ctrl_lc_iso_part_sw_wr_en
        index: -1
      }
      {
        name: lc_seed_hw_rd_en
        struct: lc_tx
        package: lc_ctrl_pkg
        type: uni
        act: req
        width: 1
        default: lc_ctrl_pkg::Off
        inst_name: lc_ctrl
        end_idx: -1
        top_type: broadcast
        top_signame: lc_ctrl_lc_seed_hw_rd_en
        index: -1
      }
      {
        name: lc_keymgr_div
        struct: lc_keymgr_div
        package: lc_ctrl_pkg
        type: uni
        act: req
        width: 1
        default: "'0"
        inst_name: lc_ctrl
        end_idx: -1
        top_type: broadcast
        top_signame: lc_ctrl_lc_keymgr_div
        index: -1
      }
      {
        name: otp_device_id
        struct: otp_device_id
        package: otp_ctrl_pkg
        type: uni
        act: rcv
        width: 1
        default: "'0"
        inst_name: lc_ctrl
        top_signame: lc_ctrl_otp_device_id
        index: -1
      }
      {
        name: otp_manuf_state
        struct: otp_manuf_state
        package: otp_ctrl_pkg
        type: uni
        act: rcv
        width: 1
        default: "'0"
        inst_name: lc_ctrl
        top_signame: lc_ctrl_otp_manuf_state
        index: -1
      }
      {
        name: hw_rev
        struct: lc_hw_rev
        package: lc_ctrl_pkg
        type: uni
        act: req
        width: 1
        default: "'0"
        inst_name: lc_ctrl
        index: -1
      }
      {
        name: strap_en_override
        desc:
          '''
          This signal transitions from 0 -> 1 by the lc_ctrl manager after volatile RAW_UNLOCK in order to re-sample the HW straps.
          The signal stays at 1 until reset.
          Note that this is only used in test chips when SecVolatileRawUnlockEn = 1.
          Otherwise this signal is tied off to 0.
          '''
        struct: logic
        type: uni
        act: req
        width: 1
        default: 1'b0
        inst_name: lc_ctrl
        package: ""
        end_idx: -1
        top_type: broadcast
        top_signame: lc_ctrl_strap_en_override
        index: -1
      }
      {
        name: regs_tl
        struct: tl
        package: tlul_pkg
        type: req_rsp
        act: rsp
        width: 1
        inst_name: lc_ctrl
        default: ""
        end_idx: -1
        top_signame: lc_ctrl_regs_tl
        index: -1
      }
      {
        name: dmi_tl
        struct: tl
        package: tlul_pkg
        type: req_rsp
        act: rsp
        width: 1
        inst_name: lc_ctrl
        index: -1
      }
      {
        name: crashdump
        struct: alert_crashdump
        package: alert_handler_pkg
        type: uni
        act: req
        width: 1
        inst_name: alert_handler
        default: ""
        end_idx: -1
        top_type: broadcast
        top_signame: alert_handler_crashdump
        index: -1
      }
      {
        name: edn
        struct: edn
        package: edn_pkg
        type: req_rsp
        act: req
        width: 1
        inst_name: alert_handler
        default: ""
        top_signame: edn0_edn
        index: 4
      }
      {
        name: esc_rx
        struct: esc_rx
        package: prim_esc_pkg
        type: uni
        act: rcv
        width: 4
        inst_name: alert_handler
        default: ""
        end_idx: -1
        top_type: one-to-N
        top_signame: alert_handler_esc_rx
        index: -1
      }
      {
        name: esc_tx
        struct: esc_tx
        package: prim_esc_pkg
        type: uni
        act: req
        width: 4
        inst_name: alert_handler
        default: ""
        end_idx: -1
        top_type: one-to-N
        top_signame: alert_handler_esc_tx
        index: -1
      }
      {
        name: tl
        struct: tl
        package: tlul_pkg
        type: req_rsp
        act: rsp
        width: 1
        inst_name: alert_handler
        default: ""
        end_idx: -1
        top_signame: alert_handler_tl
        index: -1
      }
      {
        name: passthrough
        struct: passthrough
        package: spi_device_pkg
        type: req_rsp
        act: rsp
        width: 1
        inst_name: spi_host0
        default: ""
        top_signame: spi_device_passthrough
        index: -1
      }
      {
        name: lsio_trigger
        desc:
          '''
          Self-clearing status trigger for the DMA.
          Set when RX or TX FIFOs are past their configured watermarks matching watermark interrupt behaviour.
          '''
        struct: logic
        type: uni
        act: req
        width: 1
        inst_name: spi_host0
        index: -1
      }
      {
        name: racl_policies
        desc:
          '''
          Incoming RACL policy vector from a racl_ctrl instance.
          The policy selection vector (parameter) selects the policy for each register.
          '''
        struct: racl_policy_vec
        package: top_racl_pkg
        type: uni
        act: rcv
        width: 1
        inst_name: spi_host0
        index: -1
      }
      {
        name: racl_error
        desc: RACL error log information of this module.
        struct: racl_error_log
        package: top_racl_pkg
        type: uni
        act: req
        width: 1
        inst_name: spi_host0
        index: -1
      }
      {
        name: tl
        struct: tl
        package: tlul_pkg
        type: req_rsp
        act: rsp
        width: 1
        inst_name: spi_host0
        default: ""
        end_idx: -1
        top_signame: spi_host0_tl
        index: -1
      }
      {
        name: passthrough
        struct: passthrough
        package: spi_device_pkg
        type: req_rsp
        act: rsp
        width: 1
        inst_name: spi_host1
        index: -1
      }
      {
        name: lsio_trigger
        desc:
          '''
          Self-clearing status trigger for the DMA.
          Set when RX or TX FIFOs are past their configured watermarks matching watermark interrupt behaviour.
          '''
        struct: logic
        type: uni
        act: req
        width: 1
        inst_name: spi_host1
        index: -1
      }
      {
        name: racl_policies
        desc:
          '''
          Incoming RACL policy vector from a racl_ctrl instance.
          The policy selection vector (parameter) selects the policy for each register.
          '''
        struct: racl_policy_vec
        package: top_racl_pkg
        type: uni
        act: rcv
        width: 1
        inst_name: spi_host1
        index: -1
      }
      {
        name: racl_error
        desc: RACL error log information of this module.
        struct: racl_error_log
        package: top_racl_pkg
        type: uni
        act: req
        width: 1
        inst_name: spi_host1
        index: -1
      }
      {
        name: tl
        struct: tl
        package: tlul_pkg
        type: req_rsp
        act: rsp
        width: 1
        inst_name: spi_host1
        default: ""
        end_idx: -1
        top_signame: spi_host1_tl
        index: -1
      }
      {
        name: usb_rx_d
        desc: USB RX data from an external differential receiver, if available
        struct: logic
        type: uni
        act: rcv
        width: 1
        inst_name: usbdev
        default: ""
        package: ""
        external: true
        top_signame: usbdev_usb_rx_d
        conn_type: false
        index: -1
      }
      {
        name: usb_tx_d
        desc: USB transmit data value (not used if usb_tx_se0 is set)
        struct: logic
        type: uni
        act: req
        width: 1
        inst_name: usbdev
        default: ""
        package: ""
        external: true
        top_signame: usbdev_usb_tx_d
        conn_type: false
        index: -1
      }
      {
        name: usb_tx_se0
        desc: Force transmission of a USB single-ended zero (i.e. both D+ and D- are low) regardless of usb_tx_d
        struct: logic
        type: uni
        act: req
        width: 1
        inst_name: usbdev
        default: ""
        package: ""
        external: true
        top_signame: usbdev_usb_tx_se0
        conn_type: false
        index: -1
      }
      {
        name: usb_tx_use_d_se0
        desc: Use the usb_tx_d and usb_tx_se0 TX interface, instead of usb_dp_o and usb_dn_o
        struct: logic
        type: uni
        act: req
        width: 1
        inst_name: usbdev
        default: ""
        package: ""
        external: true
        top_signame: usbdev_usb_tx_use_d_se0
        conn_type: false
        index: -1
      }
      {
        name: usb_dp_pullup
        desc: USB D+ pullup control
        struct: logic
        type: uni
        act: req
        width: 1
        inst_name: usbdev
        default: ""
        package: ""
        end_idx: -1
        top_type: broadcast
        top_signame: usbdev_usb_dp_pullup
        index: -1
      }
      {
        name: usb_dn_pullup
        desc: USB D- pullup control
        struct: logic
        type: uni
        act: req
        width: 1
        inst_name: usbdev
        default: ""
        package: ""
        end_idx: -1
        top_type: broadcast
        top_signame: usbdev_usb_dn_pullup
        index: -1
      }
      {
        name: usb_rx_enable
        desc: USB differential receiver enable
        struct: logic
        type: uni
        act: req
        width: 1
        inst_name: usbdev
        default: ""
        package: ""
        external: true
        top_signame: usbdev_usb_rx_enable
        conn_type: false
        index: -1
      }
      {
        name: usb_ref_val
        desc: This indicates that USB timing reference signal 'usb_ref_pulse' is valid
        struct: logic
        type: uni
        act: req
        width: 1
        inst_name: usbdev
        default: ""
        package: ""
        external: true
        top_signame: usbdev_usb_ref_val
        conn_type: false
        index: -1
      }
      {
        name: usb_ref_pulse
        desc: USB timing reference signal. This signal pulses for a single 48MHz clock every 1ms USB frame
        struct: logic
        type: uni
        act: req
        width: 1
        inst_name: usbdev
        default: ""
        package: ""
        external: true
        top_signame: usbdev_usb_ref_pulse
        conn_type: false
        index: -1
      }
      {
        name: usb_aon_suspend_req
        desc: Request to activate the AON/Wake module and take control of the USB pullups
        struct: logic
        type: uni
        act: req
        width: 1
        inst_name: usbdev
        default: ""
        package: ""
        end_idx: -1
        top_type: broadcast
        top_signame: usbdev_usb_aon_suspend_req
        index: -1
      }
      {
        name: usb_aon_wake_ack
        desc: Acknowledge a wake signal from the AON/Wake and relinquish control of the USB pullups
        struct: logic
        type: uni
        act: req
        width: 1
        inst_name: usbdev
        default: ""
        package: ""
        end_idx: -1
        top_type: broadcast
        top_signame: usbdev_usb_aon_wake_ack
        index: -1
      }
      {
        name: usb_aon_bus_reset
        desc: Indicates that the reason for waking was that a USB Bus Reset occurred
        struct: logic
        type: uni
        act: rcv
        width: 1
        inst_name: usbdev
        default: ""
        package: ""
        end_idx: -1
        top_type: broadcast
        top_signame: usbdev_usb_aon_bus_reset
        index: -1
      }
      {
        name: usb_aon_sense_lost
        desc: Indicates that the reason for waking was that the VBUS/SENSE signal became deasserted
        struct: logic
        type: uni
        act: rcv
        width: 1
        inst_name: usbdev
        default: ""
        package: ""
        end_idx: -1
        top_type: broadcast
        top_signame: usbdev_usb_aon_sense_lost
        index: -1
      }
      {
        name: usb_aon_bus_not_idle
        desc: Indicates that the reason for waking was that the USB is in a non-idle state
        struct: logic
        type: uni
        act: rcv
        width: 1
        inst_name: usbdev
        default: ""
        package: ""
        end_idx: -1
        top_type: broadcast
        top_signame: usbdev_usb_aon_bus_not_idle
        index: -1
      }
      {
        name: usb_aon_wake_detect_active
        desc: Indicates that the external AON/Wake module is active and controlling the USB pullups
        struct: logic
        type: uni
        act: rcv
        width: 1
        inst_name: usbdev
        default: ""
        package: ""
        top_signame: pinmux_aon_usbdev_wake_detect_active
        index: -1
      }
      {
        name: ram_cfg
        struct: ram_1p_cfg
        package: prim_ram_1p_pkg
        type: uni
        act: rcv
        width: 1
        inst_name: usbdev
        default: ""
        top_signame: ast_usb_ram_1p_cfg
        index: -1
      }
      {
        name: ram_cfg_rsp
        struct: ram_1p_cfg_rsp
        package: prim_ram_1p_pkg
        type: uni
        act: req
        width: 1
        inst_name: usbdev
        index: -1
      }
      {
        name: tl
        struct: tl
        package: tlul_pkg
        type: req_rsp
        act: rsp
        width: 1
        inst_name: usbdev
        default: ""
        end_idx: -1
        top_signame: usbdev_tl
        index: -1
      }
      {
        name: pwr_ast
        struct: pwr_ast
        package: pwrmgr_pkg
        type: req_rsp
        act: req
        width: 1
        inst_name: pwrmgr_aon
        default: ""
        external: true
        top_signame: pwrmgr_ast
        conn_type: false
        index: -1
      }
      {
        name: pwr_rst
        struct: pwr_rst
        package: pwrmgr_pkg
        type: req_rsp
        act: req
        width: 1
        inst_name: pwrmgr_aon
        default: ""
        end_idx: -1
        top_signame: pwrmgr_aon_pwr_rst
        index: -1
      }
      {
        name: pwr_clk
        struct: pwr_clk
        package: pwrmgr_pkg
        type: req_rsp
        act: req
        width: 1
        inst_name: pwrmgr_aon
        default: ""
        end_idx: -1
        top_signame: pwrmgr_aon_pwr_clk
        index: -1
      }
      {
        name: pwr_otp
        struct: pwr_otp
        package: pwrmgr_pkg
        type: req_rsp
        act: req
        width: 1
        inst_name: pwrmgr_aon
        default: ""
        end_idx: -1
        top_signame: pwrmgr_aon_pwr_otp
        index: -1
      }
      {
        name: pwr_lc
        struct: pwr_lc
        package: lc_ctrl_pkg
        type: req_rsp
        act: req
        width: 1
        inst_name: pwrmgr_aon
        default: ""
        end_idx: -1
        top_signame: pwrmgr_aon_pwr_lc
        index: -1
      }
      {
        name: pwr_flash
        struct: pwr_flash
        package: pwrmgr_pkg
        type: uni
        act: rcv
        width: 1
        inst_name: pwrmgr_aon
        default: ""
        end_idx: -1
        top_type: broadcast
        top_signame: pwrmgr_aon_pwr_flash
        index: -1
      }
      {
        name: esc_rst_tx
        struct: esc_tx
        package: prim_esc_pkg
        type: uni
        act: rcv
        width: 1
        inst_name: pwrmgr_aon
        default: ""
        top_signame: alert_handler_esc_tx
        index: 3
      }
      {
        name: esc_rst_rx
        struct: esc_rx
        package: prim_esc_pkg
        type: uni
        act: req
        width: 1
        inst_name: pwrmgr_aon
        default: ""
        top_signame: alert_handler_esc_rx
        index: 3
      }
      {
        name: pwr_cpu
        struct: cpu_pwrmgr
        package: rv_core_ibex_pkg
        type: uni
        act: rcv
        width: 1
        inst_name: pwrmgr_aon
        default: ""
        top_signame: rv_core_ibex_pwrmgr
        index: -1
      }
      {
        name: wakeups
        struct: logic
        type: uni
        act: rcv
        width: 6
        inst_name: pwrmgr_aon
        default: ""
        package: ""
        end_idx: -1
        top_type: one-to-N
        top_signame: pwrmgr_aon_wakeups
        index: -1
      }
      {
        name: rstreqs
        struct: logic
        type: uni
        act: rcv
        width: 2
        inst_name: pwrmgr_aon
        default: ""
        package: ""
        end_idx: -1
        top_type: one-to-N
        top_signame: pwrmgr_aon_rstreqs
        index: -1
      }
      {
        name: ndmreset_req
        struct: logic
        type: uni
        act: rcv
        width: 1
        inst_name: pwrmgr_aon
        default: ""
        package: ""
        top_signame: rv_dm_ndmreset_req
        index: -1
      }
      {
        name: strap
        struct: logic
        type: uni
        act: req
        width: 1
        inst_name: pwrmgr_aon
        default: ""
        package: ""
        end_idx: -1
        top_type: broadcast
        top_signame: pwrmgr_aon_strap
        index: -1
      }
      {
        name: low_power
        struct: logic
        type: uni
        act: req
        width: 1
        inst_name: pwrmgr_aon
        default: ""
        package: ""
        end_idx: -1
        top_type: broadcast
        top_signame: pwrmgr_aon_low_power
        index: -1
      }
      {
        name: rom_ctrl
        struct: pwrmgr_data
        package: rom_ctrl_pkg
        type: uni
        act: rcv
        width: 1
        default: rom_ctrl_pkg::PWRMGR_DATA_DEFAULT
        inst_name: pwrmgr_aon
        top_signame: rom_ctrl_pwrmgr_data
        index: -1
      }
      {
        name: fetch_en
        struct: lc_tx
        package: lc_ctrl_pkg
        type: uni
        act: req
        width: 1
        inst_name: pwrmgr_aon
        default: ""
        end_idx: -1
        top_type: broadcast
        top_signame: pwrmgr_aon_fetch_en
        index: -1
      }
      {
        name: lc_dft_en
        struct: lc_tx
        package: lc_ctrl_pkg
        type: uni
        act: rcv
        width: 1
        inst_name: pwrmgr_aon
        default: ""
        top_signame: lc_ctrl_lc_dft_en
        index: -1
      }
      {
        name: lc_hw_debug_en
        struct: lc_tx
        package: lc_ctrl_pkg
        type: uni
        act: rcv
        width: 1
        inst_name: pwrmgr_aon
        default: ""
        top_signame: lc_ctrl_lc_hw_debug_en
        index: -1
      }
      {
        name: sw_rst_req
        struct: mubi4
        package: prim_mubi_pkg
        type: uni
        act: rcv
        width: 1
        inst_name: pwrmgr_aon
        default: ""
        top_signame: rstmgr_aon_sw_rst_req
        index: -1
      }
      {
        name: tl
        struct: tl
        package: tlul_pkg
        type: req_rsp
        act: rsp
        width: 1
        inst_name: pwrmgr_aon
        default: ""
        end_idx: -1
        top_signame: pwrmgr_aon_tl
        index: -1
      }
      {
        name: por_n
        desc:
          '''
          Root power on reset signals from ast.
          There is one root reset signal for each core power domain.
          '''
        struct: logic
        type: uni
        act: rcv
        width: 2
        inst_name: rstmgr_aon
        default: ""
        package: ""
        external: true
        top_signame: por_n
        conn_type: false
        index: -1
      }
      {
        name: pwr
        desc:
          '''
          Reset request signals from power manager.
          Power manager can request for specific domains of the lc/sys reset tree to assert.
          '''
        struct: pwr_rst
        type: req_rsp
        act: rsp
        width: 1
        inst_name: rstmgr_aon
        default: ""
        package: pwrmgr_pkg
        top_signame: pwrmgr_aon_pwr_rst
        index: -1
      }
      {
        name: resets
        desc: Leaf resets fed to the system.
        struct: rstmgr_out
        package: rstmgr_pkg
        type: uni
        act: req
        width: 1
        inst_name: rstmgr_aon
        default: ""
        top_signame: rstmgr_aon_resets
        index: -1
      }
      {
        name: rst_en
        desc: Low-power-group outputs used by alert handler.
        struct: rstmgr_rst_en
        package: rstmgr_pkg
        type: uni
        act: req
        width: 1
        inst_name: rstmgr_aon
        default: ""
        top_signame: rstmgr_aon_rst_en
        index: -1
      }
      {
        name: alert_dump
        desc: Alert handler crash dump information.
        struct: alert_crashdump
        package: alert_handler_pkg
        type: uni
        act: rcv
        width: 1
        inst_name: rstmgr_aon
        default: ""
        top_signame: alert_handler_crashdump
        index: -1
      }
      {
        name: cpu_dump
        desc: Main processing element crash dump information.
        struct: cpu_crash_dump
        package: rv_core_ibex_pkg
        type: uni
        act: rcv
        width: 1
        inst_name: rstmgr_aon
        default: ""
        top_signame: rv_core_ibex_crash_dump
        index: -1
      }
      {
        name: sw_rst_req
        desc: Software requested system reset to pwrmgr.
        struct: mubi4
        package: prim_mubi_pkg
        type: uni
        act: req
        width: 1
        inst_name: rstmgr_aon
        default: ""
        end_idx: -1
        top_type: broadcast
        top_signame: rstmgr_aon_sw_rst_req
        index: -1
      }
      {
        name: tl
        struct: tl
        package: tlul_pkg
        type: req_rsp
        act: rsp
        width: 1
        inst_name: rstmgr_aon
        default: ""
        end_idx: -1
        top_signame: rstmgr_aon_tl
        index: -1
      }
      {
        name: clocks
        struct: clkmgr_out
        package: clkmgr_pkg
        type: uni
        act: req
        width: 1
        inst_name: clkmgr_aon
        default: ""
        top_signame: clkmgr_aon_clocks
        index: -1
      }
      {
        name: cg_en
        struct: clkmgr_cg_en
        package: clkmgr_pkg
        type: uni
        act: req
        width: 1
        inst_name: clkmgr_aon
        default: ""
        top_signame: clkmgr_aon_cg_en
        index: -1
      }
      {
        name: lc_hw_debug_en
        struct: lc_tx
        package: lc_ctrl_pkg
        type: uni
        act: rcv
        width: 1
        inst_name: clkmgr_aon
        default: ""
        top_signame: lc_ctrl_lc_hw_debug_en
        index: -1
      }
      {
        name: io_clk_byp_req
        struct: mubi4
        package: prim_mubi_pkg
        type: uni
        act: req
        width: 1
        inst_name: clkmgr_aon
        default: ""
        external: true
        top_signame: io_clk_byp_req
        conn_type: false
        index: -1
      }
      {
        name: io_clk_byp_ack
        struct: mubi4
        package: prim_mubi_pkg
        type: uni
        act: rcv
        width: 1
        inst_name: clkmgr_aon
        default: ""
        external: true
        top_signame: io_clk_byp_ack
        conn_type: false
        index: -1
      }
      {
        name: all_clk_byp_req
        struct: mubi4
        package: prim_mubi_pkg
        type: uni
        act: req
        width: 1
        inst_name: clkmgr_aon
        default: ""
        external: true
        top_signame: all_clk_byp_req
        conn_type: false
        index: -1
      }
      {
        name: all_clk_byp_ack
        struct: mubi4
        package: prim_mubi_pkg
        type: uni
        act: rcv
        width: 1
        inst_name: clkmgr_aon
        default: ""
        external: true
        top_signame: all_clk_byp_ack
        conn_type: false
        index: -1
      }
      {
        name: hi_speed_sel
        struct: mubi4
        package: prim_mubi_pkg
        type: uni
        act: req
        width: 1
        inst_name: clkmgr_aon
        default: ""
        external: true
        top_signame: hi_speed_sel
        conn_type: false
        index: -1
      }
      {
        name: div_step_down_req
        struct: mubi4
        package: prim_mubi_pkg
        type: uni
        act: rcv
        width: 1
        inst_name: clkmgr_aon
        default: ""
        external: true
        top_signame: div_step_down_req
        conn_type: false
        index: -1
      }
      {
        name: lc_clk_byp_req
        struct: lc_tx
        package: lc_ctrl_pkg
        type: uni
        act: rcv
        width: 1
        inst_name: clkmgr_aon
        default: ""
        top_signame: lc_ctrl_lc_clk_byp_req
        index: -1
      }
      {
        name: lc_clk_byp_ack
        struct: lc_tx
        package: lc_ctrl_pkg
        type: uni
        act: req
        width: 1
        inst_name: clkmgr_aon
        default: ""
        top_signame: lc_ctrl_lc_clk_byp_ack
        index: -1
      }
      {
        name: jitter_en
        struct: mubi4
        package: prim_mubi_pkg
        type: uni
        act: req
        width: 1
        inst_name: clkmgr_aon
        default: ""
        external: true
        top_signame: clk_main_jitter_en
        conn_type: false
        index: -1
      }
      {
        name: pwr
        struct: pwr_clk
        type: req_rsp
        act: rsp
        width: 1
        inst_name: clkmgr_aon
        default: ""
        package: pwrmgr_pkg
        top_signame: pwrmgr_aon_pwr_clk
        index: -1
      }
      {
        name: idle
        struct: mubi4
        package: prim_mubi_pkg
        type: uni
        act: rcv
        width: 4
        inst_name: clkmgr_aon
        default: ""
        end_idx: -1
        top_type: one-to-N
        top_signame: clkmgr_aon_idle
        index: -1
      }
      {
        name: calib_rdy
        desc: Indicates clocks are calibrated and frequencies accurate
        struct: mubi4
        package: prim_mubi_pkg
        type: uni
        act: rcv
        width: 1
        default: prim_mubi_pkg::MuBi4True
        inst_name: clkmgr_aon
        external: true
        top_signame: calib_rdy
        conn_type: false
        index: -1
      }
      {
        name: tl
        struct: tl
        package: tlul_pkg
        type: req_rsp
        act: rsp
        width: 1
        inst_name: clkmgr_aon
        default: ""
        end_idx: -1
        top_signame: clkmgr_aon_tl
        index: -1
      }
      {
        name: wkup_req
        struct: logic
        type: uni
        act: req
        width: 1
        inst_name: sysrst_ctrl_aon
        default: ""
        package: ""
        top_signame: pwrmgr_aon_wakeups
        index: 0
      }
      {
        name: rst_req
        struct: logic
        type: uni
        act: req
        width: 1
        inst_name: sysrst_ctrl_aon
        default: ""
        package: ""
        top_signame: pwrmgr_aon_rstreqs
        index: 0
      }
      {
        name: tl
        struct: tl
        package: tlul_pkg
        type: req_rsp
        act: rsp
        width: 1
        inst_name: sysrst_ctrl_aon
        default: ""
        end_idx: -1
        top_signame: sysrst_ctrl_aon_tl
        index: -1
      }
      {
        name: adc
        struct: adc_ast
        package: ast_pkg
        type: req_rsp
        act: req
        width: 1
        inst_name: adc_ctrl_aon
        default: ""
        external: true
        top_signame: adc
        conn_type: false
        index: -1
      }
      {
        name: wkup_req
        struct: logic
        type: uni
        act: req
        width: 1
        inst_name: adc_ctrl_aon
        default: ""
        package: ""
        top_signame: pwrmgr_aon_wakeups
        index: 1
      }
      {
        name: tl
        struct: tl
        package: tlul_pkg
        type: req_rsp
        act: rsp
        width: 1
        inst_name: adc_ctrl_aon
        default: ""
        end_idx: -1
        top_signame: adc_ctrl_aon_tl
        index: -1
      }
      {
        name: racl_policies
        desc:
          '''
          Incoming RACL policy vector from a racl_ctrl instance.
          The policy selection vector (parameter) selects the policy for each register.
          '''
        struct: racl_policy_vec
        package: top_racl_pkg
        type: uni
        act: rcv
        width: 1
        inst_name: pwm_aon
        index: -1
      }
      {
        name: racl_error
        desc: RACL error log information of this module.
        struct: racl_error_log
        package: top_racl_pkg
        type: uni
        act: req
        width: 1
        inst_name: pwm_aon
        index: -1
      }
      {
        name: tl
        struct: tl
        package: tlul_pkg
        type: req_rsp
        act: rsp
        width: 1
        inst_name: pwm_aon
        default: ""
        end_idx: -1
        top_signame: pwm_aon_tl
        index: -1
      }
      {
        name: lc_hw_debug_en
        desc: Debug enable qualifier coming from life cycle controller, used for HW strap qualification.
        struct: lc_tx
        package: lc_ctrl_pkg
        type: uni
        act: rcv
        width: 1
        default: lc_ctrl_pkg::Off
        inst_name: pinmux_aon
        top_signame: lc_ctrl_lc_hw_debug_en
        index: -1
      }
      {
        name: lc_dft_en
        desc: Test enable qualifier coming from life cycle controller, used for HW strap qualification.
        struct: lc_tx
        package: lc_ctrl_pkg
        type: uni
        act: rcv
        width: 1
        default: lc_ctrl_pkg::Off
        inst_name: pinmux_aon
        top_signame: lc_ctrl_lc_dft_en
        index: -1
      }
      {
        name: lc_escalate_en
        desc:
          '''
          Escalation enable signal coming from life cycle controller, used for invalidating
          the latched lc_hw_debug_en state inside the strap sampling logic.
          '''
        struct: lc_tx
        package: lc_ctrl_pkg
        type: uni
        act: rcv
        width: 1
        default: lc_ctrl_pkg::Off
        inst_name: pinmux_aon
        top_signame: lc_ctrl_lc_escalate_en
        index: -1
      }
      {
        name: lc_check_byp_en
        desc:
          '''
          Check bypass enable signal coming from life cycle controller, used for invalidating
          the latched lc_hw_debug_en state inside the strap sampling logic. This signal is asserted
          whenever the life cycle controller performs a life cycle transition. Its main use is
          to skip any background checks inside the life cycle partition of the OTP controller while
          a life cycle transition is in progress.
          '''
        struct: lc_tx
        package: lc_ctrl_pkg
        type: uni
        act: rcv
        width: 1
        default: lc_ctrl_pkg::Off
        inst_name: pinmux_aon
        top_signame: lc_ctrl_lc_check_byp_en
        index: -1
      }
      {
        name: pinmux_hw_debug_en
        desc:
          '''
          This is the latched version of lc_hw_debug_en_i. We use it exclusively to gate the JTAG
          signals and TAP side of the RV_DM so that RV_DM can remain live during an NDM reset cycle.
          '''
        struct: lc_tx
        package: lc_ctrl_pkg
        type: uni
        act: req
        width: 1
        default: lc_ctrl_pkg::Off
        inst_name: pinmux_aon
        end_idx: -1
        top_type: broadcast
        top_signame: pinmux_aon_pinmux_hw_debug_en
        index: -1
      }
      {
        name: lc_jtag
        desc: Qualified JTAG signals for life cycle controller TAP.
        struct: jtag
        package: jtag_pkg
        type: req_rsp
        act: req
        width: 1
        inst_name: pinmux_aon
        default: ""
        end_idx: -1
        top_signame: pinmux_aon_lc_jtag
        index: -1
      }
      {
        name: rv_jtag
        desc: Qualified JTAG signals for RISC-V processor TAP.
        struct: jtag
        package: jtag_pkg
        type: req_rsp
        act: req
        width: 1
        inst_name: pinmux_aon
        default: ""
        end_idx: -1
        top_signame: pinmux_aon_rv_jtag
        index: -1
      }
      {
        name: dft_jtag
        desc: Qualified JTAG signals for DFT TAP.
        struct: jtag
        package: jtag_pkg
        type: req_rsp
        act: req
        width: 1
        inst_name: pinmux_aon
        default: ""
        top_signame: pinmux_aon_dft_jtag
        index: -1
      }
      {
        name: dft_strap_test
        desc: Sampled DFT strap values, going to the DFT TAP.
        struct: dft_strap_test_req
        package: pinmux_pkg
        type: uni
        act: req
        width: 1
        default: "'0"
        inst_name: pinmux_aon
        external: true
        top_signame: dft_strap_test
        conn_type: false
        index: -1
      }
      {
        name: dft_hold_tap_sel
        desc: TAP selection hold indication, asserted by the DFT TAP during boundary scan.
        struct: logic
        type: uni
        act: rcv
        width: 1
        default: "'0"
        inst_name: pinmux_aon
        package: ""
        external: true
        top_signame: dft_hold_tap_sel
        conn_type: false
        index: -1
      }
      {
        name: sleep_en
        desc: Level signal that is asserted when the power manager enters sleep.
        struct: logic
        type: uni
        act: rcv
        width: 1
        default: 1'b0
        inst_name: pinmux_aon
        package: ""
        top_signame: pwrmgr_aon_low_power
        index: -1
      }
      {
        name: strap_en
        desc: This signal is pulsed high by the power manager after reset in order to sample the HW straps.
        struct: logic
        type: uni
        act: rcv
        width: 1
        default: 1'b0
        inst_name: pinmux_aon
        package: ""
        top_signame: pwrmgr_aon_strap
        index: -1
      }
      {
        name: strap_en_override
        desc:
          '''
          This signal transitions from 0 -> 1 by the lc_ctrl manager after volatile RAW_UNLOCK in order to re-sample the HW straps.
          The signal must stay at 1 until reset.
          Note that this is only used in test chips when SecVolatileRawUnlockEn = 1.
          Otherwise this signal is unused.
          '''
        struct: logic
        type: uni
        act: rcv
        width: 1
        default: 1'b0
        inst_name: pinmux_aon
        package: ""
        top_signame: lc_ctrl_strap_en_override
        index: -1
      }
      {
        name: pin_wkup_req
        desc: Wakeup request from wakeup detectors, to the power manager, running on the AON clock.
        struct: logic
        type: uni
        act: req
        width: 1
        default: 1'b0
        inst_name: pinmux_aon
        package: ""
        top_signame: pwrmgr_aon_wakeups
        index: 2
      }
      {
        name: usbdev_dppullup_en
        desc: Pullup enable signal coming from the USB IP.
        struct: logic
        type: uni
        act: rcv
        width: 1
        inst_name: pinmux_aon
        default: ""
        package: ""
        top_signame: usbdev_usb_dp_pullup
        index: -1
      }
      {
        name: usbdev_dnpullup_en
        desc: Pullup enable signal coming from the USB IP.
        struct: logic
        type: uni
        act: rcv
        width: 1
        inst_name: pinmux_aon
        default: ""
        package: ""
        top_signame: usbdev_usb_dn_pullup
        index: -1
      }
      {
        name: usb_dppullup_en
        desc: " Pullup enable signal going to USB PHY, needs to be maintained in low-power mode."
        struct: logic
        type: uni
        act: req
        width: 1
        default: 1'b0
        inst_name: pinmux_aon
        package: ""
        external: true
        top_signame: usb_dp_pullup_en
        conn_type: false
        index: -1
      }
      {
        name: usb_dnpullup_en
        desc: Pullup enable signal going to USB PHY, needs to be maintained in low-power mode.
        struct: logic
        type: uni
        act: req
        width: 1
        default: 1'b0
        inst_name: pinmux_aon
        package: ""
        external: true
        top_signame: usb_dn_pullup_en
        conn_type: false
        index: -1
      }
      {
        name: usb_wkup_req
        desc: Wakeup request from USB wakeup detector, going to the power manager, running on the AON clock.
        struct: logic
        type: uni
        act: req
        width: 1
        default: 1'b0
        inst_name: pinmux_aon
        package: ""
        top_signame: pwrmgr_aon_wakeups
        index: 3
      }
      {
        name: usbdev_suspend_req
        desc: Indicates whether USB is in suspended state, coming from the USB device.
        struct: logic
        type: uni
        act: rcv
        width: 1
        inst_name: pinmux_aon
        default: ""
        package: ""
        top_signame: usbdev_usb_aon_suspend_req
        index: -1
      }
      {
        name: usbdev_wake_ack
        desc: Acknowledges the USB wakeup request, coming from the USB device.
        struct: logic
        type: uni
        act: rcv
        width: 1
        inst_name: pinmux_aon
        default: ""
        package: ""
        top_signame: usbdev_usb_aon_wake_ack
        index: -1
      }
      {
        name: usbdev_bus_not_idle
        desc: Event signal that indicates that the USB was not idle while monitoring.
        struct: logic
        type: uni
        act: req
        width: 1
        default: 1'b0
        inst_name: pinmux_aon
        package: ""
        top_signame: usbdev_usb_aon_bus_not_idle
        index: -1
      }
      {
        name: usbdev_bus_reset
        desc: Event signal that indicates that the USB issued a Bus Reset while monitoring.
        struct: logic
        type: uni
        act: req
        width: 1
        default: 1'b0
        inst_name: pinmux_aon
        package: ""
        top_signame: usbdev_usb_aon_bus_reset
        index: -1
      }
      {
        name: usbdev_sense_lost
        desc: Event signal that indicates that USB SENSE signal was lost while monitoring.
        struct: logic
        type: uni
        act: req
        width: 1
        default: 1'b0
        inst_name: pinmux_aon
        package: ""
        top_signame: usbdev_usb_aon_sense_lost
        index: -1
      }
      {
        name: usbdev_wake_detect_active
        desc: State debug information.
        struct: logic
        type: uni
        act: req
        width: 1
        default: 1'b0
        inst_name: pinmux_aon
        package: ""
        end_idx: -1
        top_type: broadcast
        top_signame: pinmux_aon_usbdev_wake_detect_active
        index: -1
      }
      {
        name: tl
        struct: tl
        package: tlul_pkg
        type: req_rsp
        act: rsp
        width: 1
        inst_name: pinmux_aon
        default: ""
        end_idx: -1
        top_signame: pinmux_aon_tl
        index: -1
      }
      {
        name: nmi_wdog_timer_bark
        struct: logic
        type: uni
        act: req
        width: 1
        default: 1'b0
        inst_name: aon_timer_aon
        package: ""
        end_idx: -1
        top_type: broadcast
        top_signame: aon_timer_aon_nmi_wdog_timer_bark
        index: -1
      }
      {
        name: wkup_req
        struct: logic
        type: uni
        act: req
        width: 1
        default: 1'b0
        inst_name: aon_timer_aon
        package: ""
        top_signame: pwrmgr_aon_wakeups
        index: 4
      }
      {
        name: aon_timer_rst_req
        struct: logic
        type: uni
        act: req
        width: 1
        default: 1'b0
        inst_name: aon_timer_aon
        package: ""
        top_signame: pwrmgr_aon_rstreqs
        index: 1
      }
      {
        name: lc_escalate_en
        struct: lc_tx
        package: lc_ctrl_pkg
        type: uni
        act: rcv
        width: 1
        default: lc_ctrl_pkg::Off
        inst_name: aon_timer_aon
        top_signame: lc_ctrl_lc_escalate_en
        index: -1
      }
      {
        name: sleep_mode
        struct: logic
        type: uni
        act: rcv
        width: 1
        inst_name: aon_timer_aon
        default: ""
        package: ""
        top_signame: pwrmgr_aon_low_power
        index: -1
      }
      {
        name: racl_policies
        desc:
          '''
          Incoming RACL policy vector from a racl_ctrl instance.
          The policy selection vector (parameter) selects the policy for each register.
          '''
        struct: racl_policy_vec
        package: top_racl_pkg
        type: uni
        act: rcv
        width: 1
        inst_name: aon_timer_aon
        index: -1
      }
      {
        name: racl_error
        desc: RACL error log information of this module.
        struct: racl_error_log
        package: top_racl_pkg
        type: uni
        act: req
        width: 1
        inst_name: aon_timer_aon
        index: -1
      }
      {
        name: tl
        struct: tl
        package: tlul_pkg
        type: req_rsp
        act: rsp
        width: 1
        inst_name: aon_timer_aon
        default: ""
        end_idx: -1
        top_signame: aon_timer_aon_tl
        index: -1
      }
      {
        name: tl
        struct: tl
        package: tlul_pkg
        type: req_rsp
        act: rsp
        width: 1
        inst_name: ast
        index: -1
      }
      {
        name: ast_alert
        struct: ast_alert
        package: ast_pkg
        type: req_rsp
        act: rsp
        width: 1
        inst_name: sensor_ctrl_aon
        default: ""
        external: true
        top_signame: sensor_ctrl_ast_alert
        conn_type: false
        index: -1
      }
      {
        name: ast_status
        struct: ast_status
        package: ast_pkg
        type: uni
        act: rcv
        width: 1
        inst_name: sensor_ctrl_aon
        default: ""
        external: true
        top_signame: sensor_ctrl_ast_status
        conn_type: false
        index: -1
      }
      {
        name: ast_init_done
        struct: mubi4
        package: prim_mubi_pkg
        type: uni
        act: rcv
        width: 1
        default: prim_mubi_pkg::MuBi4True
        inst_name: sensor_ctrl_aon
        external: true
        top_signame: ast_init_done
        conn_type: false
        index: -1
      }
      {
        name: ast2pinmux
        struct: logic
        type: uni
        act: rcv
        width: 9
        inst_name: sensor_ctrl_aon
        default: ""
        package: ""
        external: true
        top_signame: ast2pinmux
        conn_type: false
        index: -1
      }
      {
        name: wkup_req
        struct: logic
        type: uni
        act: req
        width: 1
        inst_name: sensor_ctrl_aon
        default: ""
        package: ""
        top_signame: pwrmgr_aon_wakeups
        index: 5
      }
      {
        name: manual_pad_attr
        struct: pad_attr
        package: prim_pad_wrapper_pkg
        type: uni
        act: req
        width: 4
        default: "'0"
        inst_name: sensor_ctrl_aon
        external: true
        top_signame: sensor_ctrl_manual_pad_attr
        conn_type: false
        index: -1
      }
      {
        name: tl
        struct: tl
        package: tlul_pkg
        type: req_rsp
        act: rsp
        width: 1
        inst_name: sensor_ctrl_aon
        default: ""
        end_idx: -1
        top_signame: sensor_ctrl_aon_tl
        index: -1
      }
      {
        name: sram_otp_key
        struct: sram_otp_key
        package: otp_ctrl_pkg
        type: req_rsp
        act: req
        width: 1
        inst_name: sram_ctrl_ret_aon
        default: ""
        top_signame: otp_ctrl_sram_otp_key
        index: 1
      }
      {
        name: cfg
        struct: ram_1p_cfg
        package: prim_ram_1p_pkg
        type: uni
        act: rcv
        width:
        {
          name: NumRamInst
          desc: Number of internal RAM instances. Must be the same as ceil(MemSizeRam / InstSize) .
          param_type: int
          unpacked_dimensions: null
          default: 1
          local: false
          expose: true
          name_top: SramCtrlRetAonNumRamInst
        }
        default: "'0"
        inst_name: sram_ctrl_ret_aon
        external: true
        top_signame: sram_ctrl_ret_aon_cfg
        conn_type: false
        index: -1
      }
      {
        name: cfg_rsp
        struct: ram_1p_cfg_rsp
        package: prim_ram_1p_pkg
        type: uni
        act: req
        width:
        {
          name: NumRamInst
          desc: Number of internal RAM instances. Must be the same as ceil(MemSizeRam / InstSize) .
          param_type: int
          unpacked_dimensions: null
          default: 1
          local: false
          expose: true
          name_top: SramCtrlRetAonNumRamInst
        }
        default: "'0"
        inst_name: sram_ctrl_ret_aon
        index: -1
      }
      {
        name: lc_escalate_en
        struct: lc_tx
        package: lc_ctrl_pkg
        type: uni
        act: rcv
        width: 1
        default: lc_ctrl_pkg::Off
        inst_name: sram_ctrl_ret_aon
        top_signame: lc_ctrl_lc_escalate_en
        index: -1
      }
      {
        name: lc_hw_debug_en
        struct: lc_tx
        package: lc_ctrl_pkg
        type: uni
        act: rcv
        width: 1
        default: lc_ctrl_pkg::Off
        inst_name: sram_ctrl_ret_aon
        index: -1
      }
      {
        name: otp_en_sram_ifetch
        struct: mubi8
        package: prim_mubi_pkg
        type: uni
        act: rcv
        width: 1
        default: prim_mubi_pkg::MuBi8False
        inst_name: sram_ctrl_ret_aon
        index: -1
      }
      {
        name: racl_policies
        desc:
          '''
          Incoming RACL policy vector from a racl_ctrl instance.
          The policy selection vector (parameter) selects the policy for each register.
          '''
        struct: racl_policy_vec
        package: top_racl_pkg
        type: uni
        act: rcv
        width: 1
        inst_name: sram_ctrl_ret_aon
        index: -1
      }
      {
        name: racl_error
        desc: RACL error log information of this module.
        struct: racl_error_log
        package: top_racl_pkg
        type: uni
        act: req
        width: 1
        inst_name: sram_ctrl_ret_aon
        index: -1
      }
      {
        name: sram_rerror
        desc: SRAM read error indicating correctable and uncorrectable ECC errors.
        struct: sram_error_t
        package: sram_ctrl_pkg
        type: uni
        act: req
        width: 1
        inst_name: sram_ctrl_ret_aon
        index: -1
      }
      {
        name: regs_tl
        struct: tl
        package: tlul_pkg
        type: req_rsp
        act: rsp
        width: 1
        inst_name: sram_ctrl_ret_aon
        default: ""
        end_idx: -1
        top_signame: sram_ctrl_ret_aon_regs_tl
        index: -1
      }
      {
        name: ram_tl
        struct: tl
        package: tlul_pkg
        type: req_rsp
        act: rsp
        width: 1
        inst_name: sram_ctrl_ret_aon
        default: ""
        end_idx: -1
        top_signame: sram_ctrl_ret_aon_ram_tl
        index: -1
      }
      {
        name: otp
        struct: flash_otp_key
        package: otp_ctrl_pkg
        type: req_rsp
        act: req
        width: 1
        inst_name: flash_ctrl
        default: ""
        end_idx: -1
        top_signame: flash_ctrl_otp
        index: -1
      }
      {
        name: lc_nvm_debug_en
        struct: lc_tx
        package: lc_ctrl_pkg
        type: uni
        act: rcv
        width: 1
        inst_name: flash_ctrl
        default: ""
        top_signame: lc_ctrl_lc_nvm_debug_en
        index: -1
      }
      {
        name: flash_bist_enable
        struct: mubi4
        package: prim_mubi_pkg
        type: uni
        act: rcv
        width: 1
        inst_name: flash_ctrl
        default: ""
        external: true
        top_signame: flash_bist_enable
        conn_type: false
        index: -1
      }
      {
        name: flash_power_down_h
        struct: logic
        type: uni
        act: rcv
        width: 1
        inst_name: flash_ctrl
        default: ""
        package: ""
        external: true
        top_signame: flash_power_down_h
        conn_type: false
        index: -1
      }
      {
        name: flash_power_ready_h
        struct: logic
        type: uni
        act: rcv
        width: 1
        inst_name: flash_ctrl
        default: ""
        package: ""
        external: true
        top_signame: flash_power_ready_h
        conn_type: false
        index: -1
      }
      {
        name: flash_test_mode_a
        struct: ""
        type: io
        act: none
        width: 2
        inst_name: flash_ctrl
        default: ""
        package: ""
        external: true
        top_signame: flash_test_mode_a
        conn_type: false
        index: -1
      }
      {
        name: flash_test_voltage_h
        struct: ""
        type: io
        act: none
        width: 1
        inst_name: flash_ctrl
        default: ""
        package: ""
        external: true
        top_signame: flash_test_voltage_h
        conn_type: false
        index: -1
      }
      {
        name: lc_creator_seed_sw_rw_en
        struct: lc_tx
        package: lc_ctrl_pkg
        type: uni
        act: rcv
        width: 1
        inst_name: flash_ctrl
        default: ""
        top_signame: lc_ctrl_lc_creator_seed_sw_rw_en
        index: -1
      }
      {
        name: lc_owner_seed_sw_rw_en
        struct: lc_tx
        package: lc_ctrl_pkg
        type: uni
        act: rcv
        width: 1
        inst_name: flash_ctrl
        default: ""
        top_signame: lc_ctrl_lc_owner_seed_sw_rw_en
        index: -1
      }
      {
        name: lc_iso_part_sw_rd_en
        struct: lc_tx
        package: lc_ctrl_pkg
        type: uni
        act: rcv
        width: 1
        inst_name: flash_ctrl
        default: ""
        top_signame: lc_ctrl_lc_iso_part_sw_rd_en
        index: -1
      }
      {
        name: lc_iso_part_sw_wr_en
        struct: lc_tx
        package: lc_ctrl_pkg
        type: uni
        act: rcv
        width: 1
        inst_name: flash_ctrl
        default: ""
        top_signame: lc_ctrl_lc_iso_part_sw_wr_en
        index: -1
      }
      {
        name: lc_seed_hw_rd_en
        struct: lc_tx
        package: lc_ctrl_pkg
        type: uni
        act: rcv
        width: 1
        inst_name: flash_ctrl
        default: ""
        top_signame: lc_ctrl_lc_seed_hw_rd_en
        index: -1
      }
      {
        name: lc_escalate_en
        struct: lc_tx
        package: lc_ctrl_pkg
        type: uni
        act: rcv
        width: 1
        inst_name: flash_ctrl
        default: ""
        top_signame: lc_ctrl_lc_escalate_en
        index: -1
      }
      {
        name: rma_req
        struct: lc_tx
        package: lc_ctrl_pkg
        type: uni
        act: rcv
        width: 1
        inst_name: flash_ctrl
        default: ""
        top_signame: lc_ctrl_lc_flash_rma_req
        index: -1
      }
      {
        name: rma_ack
        struct: lc_tx
        package: lc_ctrl_pkg
        type: uni
        act: req
        width: 1
        inst_name: flash_ctrl
        default: ""
        top_signame: lc_ctrl_lc_flash_rma_ack
        index: 0
      }
      {
        name: rma_seed
        struct: lc_flash_rma_seed
        package: lc_ctrl_pkg
        type: uni
        act: rcv
        width: 1
        inst_name: flash_ctrl
        default: ""
        end_idx: -1
        top_type: broadcast
        top_signame: flash_ctrl_rma_seed
        index: -1
      }
      {
        name: pwrmgr
        struct: pwr_flash
        package: pwrmgr_pkg
        type: uni
        act: req
        width: 1
        inst_name: flash_ctrl
        default: ""
        top_signame: pwrmgr_aon_pwr_flash
        index: -1
      }
      {
        name: keymgr
        struct: keymgr_flash
        package: flash_ctrl_pkg
        type: uni
        act: req
        width: 1
        inst_name: flash_ctrl
        default: ""
        end_idx: -1
        top_type: broadcast
        top_signame: flash_ctrl_keymgr
        index: -1
      }
      {
        name: obs_ctrl
        struct: ast_obs_ctrl
        package: ast_pkg
        type: uni
        act: rcv
        width: 1
        inst_name: flash_ctrl
        default: ""
        top_signame: ast_obs_ctrl
        index: -1
      }
      {
        name: fla_obs
        struct: logic
        type: uni
        act: req
        width: 8
        inst_name: flash_ctrl
        default: ""
        package: ""
        external: true
        top_signame: flash_obs
        conn_type: false
        index: -1
      }
      {
        name: core_tl
        struct: tl
        package: tlul_pkg
        type: req_rsp
        act: rsp
        width: 1
        inst_name: flash_ctrl
        default: ""
        end_idx: -1
        top_signame: flash_ctrl_core_tl
        index: -1
      }
      {
        name: prim_tl
        struct: tl
        package: tlul_pkg
        type: req_rsp
        act: rsp
        width: 1
        inst_name: flash_ctrl
        default: ""
        end_idx: -1
        top_signame: flash_ctrl_prim_tl
        index: -1
      }
      {
        name: mem_tl
        struct: tl
        package: tlul_pkg
        type: req_rsp
        act: rsp
        width: 1
        inst_name: flash_ctrl
        default: ""
        end_idx: -1
        top_signame: flash_ctrl_mem_tl
        index: -1
      }
      {
        name: next_dm_addr
        desc:
          '''
          32bit word address of the next debug module.
          Set to 0x0 if this is the last debug module in the chain.
          '''
        struct: next_dm_addr
        package: rv_dm_pkg
        type: uni
        act: rcv
        width: 1
        default: "'0"
        inst_name: rv_dm
        index: -1
      }
      {
        name: jtag
        desc: JTAG signals for the RISC-V TAP.
        struct: jtag
        package: jtag_pkg
        type: req_rsp
        act: rsp
        width: 1
        inst_name: rv_dm
        default: ""
        top_signame: pinmux_aon_rv_jtag
        index: -1
      }
      {
        name: lc_hw_debug_en
        desc:
          '''
          Multibit life cycle hardware debug enable signal coming from life cycle controller,
          asserted when the hardware debug mechanisms are enabled in the system.
          '''
        struct: lc_tx
        package: lc_ctrl_pkg
        type: uni
        act: rcv
        width: 1
        default: lc_ctrl_pkg::Off
        inst_name: rv_dm
        top_signame: lc_ctrl_lc_hw_debug_en
        index: -1
      }
      {
        name: lc_dft_en
        desc:
          '''
          Multibit life cycle hardware debug enable signal coming from life cycle controller,
          asserted when the DFT mechanisms are enabled in the system.
          '''
        struct: lc_tx
        package: lc_ctrl_pkg
        type: uni
        act: rcv
        width: 1
        default: lc_ctrl_pkg::Off
        inst_name: rv_dm
        top_signame: lc_ctrl_lc_dft_en
        index: -1
      }
      {
        name: pinmux_hw_debug_en
        desc:
          '''
          Multibit life cycle hardware debug enable signal coming from pinmux.
          This is a latched version of the lc_hw_debug_en signal and is only used to
          gate the JTAG / TAP side of the RV_DM. It is used to keep a debug session live
          while the rest of the system undergoes an NDM reset.
          '''
        struct: lc_tx
        package: lc_ctrl_pkg
        type: uni
        act: rcv
        width: 1
        default: lc_ctrl_pkg::Off
        inst_name: rv_dm
        top_signame: pinmux_aon_pinmux_hw_debug_en
        index: -1
      }
      {
        name: otp_dis_rv_dm_late_debug
        struct: mubi8
        package: prim_mubi_pkg
        type: uni
        act: rcv
        width: 1
        default: prim_mubi_pkg::MuBi8False
        inst_name: rv_dm
        top_signame: rv_dm_otp_dis_rv_dm_late_debug
        index: -1
      }
      {
        name: unavailable
        desc:
          '''
          This signal indicates to the debug module that the main processor is not available
          for debug (e.g. due to a low-power state).
          '''
        struct: logic
        type: uni
        act: rcv
        width: 1
        default: 1'b0
        inst_name: rv_dm
        index: -1
      }
      {
        name: ndmreset_req
        desc: Non-debug module reset request going to the system reset infrastructure.
        struct: logic
        type: uni
        act: req
        width: 1
        inst_name: rv_dm
        default: ""
        package: ""
        end_idx: -1
        top_type: broadcast
        top_signame: rv_dm_ndmreset_req
        index: -1
      }
      {
        name: dmactive
        desc:
          '''
          This signal indicates whether the debug module is active and can be used to prevent
          power down of the core and bus-attached peripherals.
          '''
        struct: logic
        type: uni
        act: req
        width: 1
        inst_name: rv_dm
        index: -1
      }
      {
        name: debug_req
        desc: This is the debug request interrupt going to the main processor.
        struct: logic [rv_dm_reg_pkg::NrHarts-1:0]
        type: uni
        act: req
        width: 1
        inst_name: rv_dm
        default: ""
        package: ""
        end_idx: -1
        top_type: broadcast
        top_signame: rv_dm_debug_req
        index: -1
      }
      {
        name: lc_escalate_en
        desc:
          '''
          Escalation enable signal coming from life cycle controller, used for invalidating
          the latched lc_hw_debug_en state inside the strap sampling logic.
          '''
        struct: lc_tx
        package: lc_ctrl_pkg
        type: uni
        act: rcv
        width: 1
        default: lc_ctrl_pkg::Off
        inst_name: rv_dm
        index: -1
      }
      {
        name: lc_check_byp_en
        desc:
          '''
          Check bypass enable signal coming from life cycle controller, used for invalidating
          the latched lc_hw_debug_en state inside the strap sampling logic. This signal is asserted
          whenever the life cycle controller performs a life cycle transition. Its main use is
          to skip any background checks inside the life cycle partition of the OTP controller while
          a life cycle transition is in progress.
          '''
        struct: lc_tx
        package: lc_ctrl_pkg
        type: uni
        act: rcv
        width: 1
        default: lc_ctrl_pkg::Off
        inst_name: rv_dm
        index: -1
      }
      {
        name: strap_en
        desc: This signal is pulsed high by the power manager after reset in order to sample the HW straps.
        struct: logic
        type: uni
        act: rcv
        width: 1
        default: 1'b0
        inst_name: rv_dm
        index: -1
      }
      {
        name: strap_en_override
        desc:
          '''
          This signal transitions from 0 -> 1 by the lc_ctrl manager after volatile RAW_UNLOCK in order to re-sample the HW straps.
          The signal must stay at 1 until reset.
          Note that this is only used in test chips when SecVolatileRawUnlockEn = 1.
          Otherwise this signal is unused.
          '''
        struct: logic
        type: uni
        act: rcv
        width: 1
        default: 1'b0
        inst_name: rv_dm
        index: -1
      }
      {
        name: racl_policies
        desc:
          '''
          Incoming RACL policy vector from a racl_ctrl instance.
          The policy selection vector (parameter) selects the policy for each register.
          '''
        struct: racl_policy_vec
        package: top_racl_pkg
        type: uni
        act: rcv
        width: 1
        inst_name: rv_dm
        index: -1
      }
      {
        name: racl_error
        desc: RACL error log information of this module.
        struct: racl_error_log
        package: top_racl_pkg
        type: uni
        act: req
        width: 1
        inst_name: rv_dm
        index: -1
      }
      {
        name: sba_tl_h
        struct: tl
        package: tlul_pkg
        type: req_rsp
        act: req
        width: 1
        inst_name: rv_dm
        default: ""
        top_signame: main_tl_rv_dm__sba
        index: -1
      }
      {
        name: regs_tl_d
        struct: tl
        package: tlul_pkg
        type: req_rsp
        act: rsp
        width: 1
        inst_name: rv_dm
        default: ""
        end_idx: -1
        top_signame: rv_dm_regs_tl_d
        index: -1
      }
      {
        name: mem_tl_d
        struct: tl
        package: tlul_pkg
        type: req_rsp
        act: rsp
        width: 1
        inst_name: rv_dm
        default: ""
        end_idx: -1
        top_signame: rv_dm_mem_tl_d
        index: -1
      }
      {
        name: dbg_tl_d
        struct: tl
        package: tlul_pkg
        type: req_rsp
        act: rsp
        width: 1
        inst_name: rv_dm
        index: -1
      }
      {
        name: irq
        struct: logic
        type: uni
        act: req
        width: 1
        inst_name: rv_plic
        default: ""
        package: ""
        end_idx: -1
        top_type: broadcast
        top_signame: rv_plic_irq
        index: -1
      }
      {
        name: irq_id
        struct: logic
        type: uni
        act: req
        width: 1
        inst_name: rv_plic
        index: -1
      }
      {
        name: msip
        struct: logic
        type: uni
        act: req
        width: 1
        inst_name: rv_plic
        default: ""
        package: ""
        end_idx: -1
        top_type: broadcast
        top_signame: rv_plic_msip
        index: -1
      }
      {
        name: tl
        struct: tl
        package: tlul_pkg
        type: req_rsp
        act: rsp
        width: 1
        inst_name: rv_plic
        default: ""
        end_idx: -1
        top_signame: rv_plic_tl
        index: -1
      }
      {
        name: idle
        struct: mubi4
        package: prim_mubi_pkg
        type: uni
        act: req
        width: 1
        inst_name: aes
        default: ""
        top_signame: clkmgr_aon_idle
        index: 0
      }
      {
        name: lc_escalate_en
        struct: lc_tx
        package: lc_ctrl_pkg
        type: uni
        act: rcv
        width: 1
        default: lc_ctrl_pkg::Off
        inst_name: aes
        top_signame: lc_ctrl_lc_escalate_en
        index: -1
      }
      {
        name: edn
        struct: edn
        package: edn_pkg
        type: req_rsp
        act: req
        width: 1
        inst_name: aes
        default: ""
        top_signame: edn0_edn
        index: 5
      }
      {
        name: keymgr_key
        struct: hw_key_req
        package: keymgr_pkg
        type: uni
        act: rcv
        width: 1
        inst_name: aes
        default: ""
        top_signame: keymgr_aes_key
        index: -1
      }
      {
        name: tl
        struct: tl
        package: tlul_pkg
        type: req_rsp
        act: rsp
        width: 1
        inst_name: aes
        default: ""
        end_idx: -1
        top_signame: aes_tl
        index: -1
      }
      {
        name: idle
        struct: mubi4
        package: prim_mubi_pkg
        type: uni
        act: req
        width: 1
        inst_name: hmac
        default: ""
        top_signame: clkmgr_aon_idle
        index: 1
      }
      {
        name: tl
        struct: tl
        package: tlul_pkg
        type: req_rsp
        act: rsp
        width: 1
        inst_name: hmac
        default: ""
        end_idx: -1
        top_signame: hmac_tl
        index: -1
      }
      {
        name: keymgr_key
        struct: hw_key_req
        package: keymgr_pkg
        type: uni
        act: rcv
        width: 1
        inst_name: kmac
        default: ""
        top_signame: keymgr_kmac_key
        index: -1
      }
      {
        name: app
        struct: app
        package: kmac_pkg
        type: req_rsp
        act: rsp
        width:
        {
          name: NumAppIntf
          desc: Number of application interfaces
          param_type: int
          unpacked_dimensions: null
          default: 3
          local: false
          expose: true
          name_top: KmacNumAppIntf
        }
        inst_name: kmac
        default: ""
        end_idx: -1
        top_type: one-to-N
        top_signame: kmac_app
        index: -1
      }
      {
        name: entropy
        struct: edn
        package: edn_pkg
        type: req_rsp
        act: req
        width: 1
        inst_name: kmac
        default: ""
        top_signame: edn0_edn
        index: 3
      }
      {
        name: idle
        struct: mubi4
        package: prim_mubi_pkg
        type: uni
        act: req
        width: 1
        inst_name: kmac
        default: ""
        top_signame: clkmgr_aon_idle
        index: 2
      }
      {
        name: en_masking
        struct: logic
        type: uni
        act: req
        width: 1
        inst_name: kmac
        default: ""
        package: ""
        end_idx: -1
        top_type: broadcast
        top_signame: kmac_en_masking
        index: -1
      }
      {
        name: lc_escalate_en
        struct: lc_tx
        package: lc_ctrl_pkg
        type: uni
        act: rcv
        width: 1
        default: lc_ctrl_pkg::Off
        inst_name: kmac
        top_signame: lc_ctrl_lc_escalate_en
        index: -1
      }
      {
        name: tl
        struct: tl
        package: tlul_pkg
        type: req_rsp
        act: rsp
        width: 1
        inst_name: kmac
        default: ""
        end_idx: -1
        top_signame: kmac_tl
        index: -1
      }
      {
        name: otbn_otp_key
        struct: otbn_otp_key
        package: otp_ctrl_pkg
        type: req_rsp
        act: req
        width: 1
        default: "'0"
        inst_name: otbn
        top_signame: otp_ctrl_otbn_otp_key
        index: -1
      }
      {
        name: edn_rnd
        struct: edn
        package: edn_pkg
        type: req_rsp
        act: req
        width: 1
        inst_name: otbn
        default: ""
        top_signame: edn1_edn
        index: 0
      }
      {
        name: edn_urnd
        struct: edn
        package: edn_pkg
        type: req_rsp
        act: req
        width: 1
        inst_name: otbn
        default: ""
        top_signame: edn0_edn
        index: 6
      }
      {
        name: idle
        struct: mubi4
        package: prim_mubi_pkg
        type: uni
        act: req
        width: 1
        inst_name: otbn
        default: ""
        top_signame: clkmgr_aon_idle
        index: 3
      }
      {
        name: ram_cfg_imem
        struct: ram_1p_cfg
        package: prim_ram_1p_pkg
        type: uni
        act: rcv
        width: 1
        inst_name: otbn
        default: ""
        top_signame: ast_ram_1p_cfg
        index: -1
      }
      {
        name: ram_cfg_dmem
        struct: ram_1p_cfg
        package: prim_ram_1p_pkg
        type: uni
        act: rcv
        width: 1
        inst_name: otbn
        default: ""
        top_signame: ast_ram_1p_cfg
        index: -1
      }
      {
        name: ram_cfg_rsp_imem
        struct: ram_1p_cfg_rsp
        package: prim_ram_1p_pkg
        type: uni
        act: req
        width: 1
        inst_name: otbn
        index: -1
      }
      {
        name: ram_cfg_rsp_dmem
        struct: ram_1p_cfg_rsp
        package: prim_ram_1p_pkg
        type: uni
        act: req
        width: 1
        inst_name: otbn
        index: -1
      }
      {
        name: lc_escalate_en
        struct: lc_tx
        package: lc_ctrl_pkg
        type: uni
        act: rcv
        width: 1
        default: lc_ctrl_pkg::Off
        inst_name: otbn
        top_signame: lc_ctrl_lc_escalate_en
        index: -1
      }
      {
        name: lc_rma_req
        struct: lc_tx
        package: lc_ctrl_pkg
        type: uni
        act: rcv
        width: 1
        default: lc_ctrl_pkg::Off
        inst_name: otbn
        top_signame: lc_ctrl_lc_flash_rma_req
        index: -1
      }
      {
        name: lc_rma_ack
        struct: lc_tx
        package: lc_ctrl_pkg
        type: uni
        act: req
        width: 1
        default: lc_ctrl_pkg::Off
        inst_name: otbn
        top_signame: lc_ctrl_lc_flash_rma_ack
        index: 1
      }
      {
        name: keymgr_key
        struct: otbn_key_req
        package: keymgr_pkg
        type: uni
        act: rcv
        width: 1
        inst_name: otbn
        default: ""
        top_signame: keymgr_otbn_key
        index: -1
      }
      {
        name: tl
        struct: tl
        package: tlul_pkg
        type: req_rsp
        act: rsp
        width: 1
        inst_name: otbn
        default: ""
        end_idx: -1
        top_signame: otbn_tl
        index: -1
      }
      {
        name: edn
        struct: edn
        package: edn_pkg
        type: req_rsp
        act: req
        width: 1
        inst_name: keymgr
        default: ""
        top_signame: edn0_edn
        index: 0
      }
      {
        name: aes_key
        struct: hw_key_req
        package: keymgr_pkg
        type: uni
        act: req
        width: 1
        inst_name: keymgr
        default: ""
        end_idx: -1
        top_type: broadcast
        top_signame: keymgr_aes_key
        index: -1
      }
      {
        name: kmac_key
        struct: hw_key_req
        package: keymgr_pkg
        type: uni
        act: req
        width: 1
        inst_name: keymgr
        default: ""
        end_idx: -1
        top_type: broadcast
        top_signame: keymgr_kmac_key
        index: -1
      }
      {
        name: otbn_key
        struct: otbn_key_req
        package: keymgr_pkg
        type: uni
        act: req
        width: 1
        inst_name: keymgr
        default: ""
        end_idx: -1
        top_type: broadcast
        top_signame: keymgr_otbn_key
        index: -1
      }
      {
        name: kmac_data
        struct: app
        package: kmac_pkg
        type: req_rsp
        act: req
        width: 1
        inst_name: keymgr
        default: ""
        top_signame: kmac_app
        index: 0
      }
      {
        name: otp_key
        struct: otp_keymgr_key
        package: otp_ctrl_pkg
        type: uni
        act: rcv
        width: 1
        inst_name: keymgr
        default: ""
        top_signame: otp_ctrl_otp_keymgr_key
        index: -1
      }
      {
        name: otp_device_id
        struct: otp_device_id
        package: otp_ctrl_pkg
        type: uni
        act: rcv
        width: 1
        inst_name: keymgr
        default: ""
        top_signame: keymgr_otp_device_id
        index: -1
      }
      {
        name: flash
        struct: keymgr_flash
        package: flash_ctrl_pkg
        type: uni
        act: rcv
        width: 1
        inst_name: keymgr
        default: ""
        top_signame: flash_ctrl_keymgr
        index: -1
      }
      {
        name: lc_keymgr_en
        struct: lc_tx
        package: lc_ctrl_pkg
        type: uni
        act: rcv
        width: 1
        default: lc_ctrl_pkg::On
        inst_name: keymgr
        top_signame: lc_ctrl_lc_keymgr_en
        index: -1
      }
      {
        name: lc_keymgr_div
        struct: lc_keymgr_div
        package: lc_ctrl_pkg
        type: uni
        act: rcv
        width: 1
        inst_name: keymgr
        default: ""
        top_signame: lc_ctrl_lc_keymgr_div
        index: -1
      }
      {
        name: rom_digest
        struct: keymgr_data
        package: rom_ctrl_pkg
        type: uni
        act: rcv
        width: 1
        inst_name: keymgr
        default: ""
        top_signame: rom_ctrl_keymgr_data
        index: -1
      }
      {
        name: kmac_en_masking
        struct: logic
        type: uni
        act: rcv
        width: 1
        inst_name: keymgr
        default: ""
        package: ""
        top_signame: kmac_en_masking
        index: -1
      }
      {
        name: tl
        struct: tl
        package: tlul_pkg
        type: req_rsp
        act: rsp
        width: 1
        inst_name: keymgr
        default: ""
        end_idx: -1
        top_signame: keymgr_tl
        index: -1
      }
      {
        name: csrng_cmd
        struct: csrng
        package: csrng_pkg
        type: req_rsp
        act: rsp
        width: 2
        inst_name: csrng
        default: ""
        end_idx: -1
        top_type: one-to-N
        top_signame: csrng_csrng_cmd
        index: -1
      }
      {
        name: entropy_src_hw_if
        struct: entropy_src_hw_if
        package: entropy_src_pkg
        type: req_rsp
        act: req
        width: 1
        inst_name: csrng
        default: ""
        end_idx: -1
        top_signame: csrng_entropy_src_hw_if
        index: -1
      }
      {
        name: cs_aes_halt
        desc:
          '''
          Coordinate activity between CSRNG's AES and Entropy Source's SHA3.
          When CSRNG gets a request and its AES is not active, it acknowledges and until the request has dropped neither runs its AES nor drops the acknowledge.
          '''
        struct: cs_aes_halt
        package: entropy_src_pkg
        type: req_rsp
        act: rsp
        width: 1
        inst_name: csrng
        default: ""
        end_idx: -1
        top_signame: csrng_cs_aes_halt
        index: -1
      }
      {
        name: otp_en_csrng_sw_app_read
        struct: mubi8
        package: prim_mubi_pkg
        type: uni
        act: rcv
        width: 1
        default: prim_mubi_pkg::MuBi8True
        inst_name: csrng
        top_signame: csrng_otp_en_csrng_sw_app_read
        index: -1
      }
      {
        name: lc_hw_debug_en
        struct: lc_tx
        package: lc_ctrl_pkg
        type: uni
        act: rcv
        width: 1
        default: lc_ctrl_pkg::Off
        inst_name: csrng
        top_signame: lc_ctrl_lc_hw_debug_en
        index: -1
      }
      {
        name: tl
        struct: tl
        package: tlul_pkg
        type: req_rsp
        act: rsp
        width: 1
        inst_name: csrng
        default: ""
        end_idx: -1
        top_signame: csrng_tl
        index: -1
      }
      {
        name: entropy_src_hw_if
        struct: entropy_src_hw_if
        package: entropy_src_pkg
        type: req_rsp
        act: rsp
        width: 1
        inst_name: entropy_src
        default: ""
        top_signame: csrng_entropy_src_hw_if
        index: -1
      }
      {
        name: cs_aes_halt
        desc:
          '''
          Coordinate activity between CSRNG's AES and Entropy Source's SHA3.
          The idea is that Entropy Source requests CSRNG's AES to halt and waits for CSRNG to acknowledge before it starts its SHA3.
          While SHA3 runs, Entropy Source keeps the request high.
          CSRNG may not drop the acknowledge before Entropy Source drops the request.
          '''
        struct: cs_aes_halt
        package: entropy_src_pkg
        type: req_rsp
        act: req
        width: 1
        inst_name: entropy_src
        default: ""
        top_signame: csrng_cs_aes_halt
        index: -1
      }
      {
        name: entropy_src_rng
        struct: entropy_src_rng
        package: entropy_src_pkg
        type: req_rsp
        act: req
        width: 1
        inst_name: entropy_src
        default: ""
        external: true
        top_signame: es_rng
        conn_type: false
        index: -1
      }
      {
        name: entropy_src_xht
        struct: entropy_src_xht
        package: entropy_src_pkg
        type: req_rsp
        act: req
        width: 1
        inst_name: entropy_src
        index: -1
      }
      {
        name: otp_en_entropy_src_fw_read
        struct: mubi8
        package: prim_mubi_pkg
        type: uni
        act: rcv
        width: 1
        default: prim_mubi_pkg::MuBi8True
        inst_name: entropy_src
        index: -1
      }
      {
        name: otp_en_entropy_src_fw_over
        struct: mubi8
        package: prim_mubi_pkg
        type: uni
        act: rcv
        width: 1
        default: prim_mubi_pkg::MuBi8True
        inst_name: entropy_src
        index: -1
      }
      {
        name: rng_fips
        struct: logic
        type: uni
        act: req
        width: 1
        inst_name: entropy_src
        default: ""
        package: ""
        external: true
        top_signame: es_rng_fips
        conn_type: false
        index: -1
      }
      {
        name: tl
        struct: tl
        package: tlul_pkg
        type: req_rsp
        act: rsp
        width: 1
        inst_name: entropy_src
        default: ""
        end_idx: -1
        top_signame: entropy_src_tl
        index: -1
      }
      {
        name: csrng_cmd
        desc: EDN supports a signal CSRNG application interface.
        struct: csrng
        package: csrng_pkg
        type: req_rsp
        act: req
        width: 1
        inst_name: edn0
        default: ""
        top_signame: csrng_csrng_cmd
        index: 0
      }
      {
        name: edn
        desc:
          '''
          The collection of peripheral ports supported by edn. The width (4)
          indicates the number of peripheral ports on a single instance.
          Due to limitations in the parametrization of top-level interconnects
          this value is not currently parameterizable.  However, the number
          of peripheral ports may change in a future revision.
          '''
        struct: edn
        package: edn_pkg
        type: req_rsp
        act: rsp
        width: 8
        default: "'0"
        inst_name: edn0
        end_idx: -1
        top_type: one-to-N
        top_signame: edn0_edn
        index: -1
      }
      {
        name: tl
        struct: tl
        package: tlul_pkg
        type: req_rsp
        act: rsp
        width: 1
        inst_name: edn0
        default: ""
        end_idx: -1
        top_signame: edn0_tl
        index: -1
      }
      {
        name: csrng_cmd
        desc: EDN supports a signal CSRNG application interface.
        struct: csrng
        package: csrng_pkg
        type: req_rsp
        act: req
        width: 1
        inst_name: edn1
        default: ""
        top_signame: csrng_csrng_cmd
        index: 1
      }
      {
        name: edn
        desc:
          '''
          The collection of peripheral ports supported by edn. The width (4)
          indicates the number of peripheral ports on a single instance.
          Due to limitations in the parametrization of top-level interconnects
          this value is not currently parameterizable.  However, the number
          of peripheral ports may change in a future revision.
          '''
        struct: edn
        package: edn_pkg
        type: req_rsp
        act: rsp
        width: 8
        default: "'0"
        inst_name: edn1
        end_idx: 1
        top_type: partial-one-to-N
        top_signame: edn1_edn
        index: -1
      }
      {
        name: tl
        struct: tl
        package: tlul_pkg
        type: req_rsp
        act: rsp
        width: 1
        inst_name: edn1
        default: ""
        end_idx: -1
        top_signame: edn1_tl
        index: -1
      }
      {
        name: sram_otp_key
        struct: sram_otp_key
        package: otp_ctrl_pkg
        type: req_rsp
        act: req
        width: 1
        inst_name: sram_ctrl_main
        default: ""
        top_signame: otp_ctrl_sram_otp_key
        index: 0
      }
      {
        name: cfg
        struct: ram_1p_cfg
        package: prim_ram_1p_pkg
        type: uni
        act: rcv
        width:
        {
          name: NumRamInst
          desc: Number of internal RAM instances. Must be the same as ceil(MemSizeRam / InstSize) .
          param_type: int
          unpacked_dimensions: null
          default: 1
          local: false
          expose: true
          name_top: SramCtrlMainNumRamInst
        }
        default: "'0"
        inst_name: sram_ctrl_main
        external: true
        top_signame: sram_ctrl_main_cfg
        conn_type: false
        index: -1
      }
      {
        name: cfg_rsp
        struct: ram_1p_cfg_rsp
        package: prim_ram_1p_pkg
        type: uni
        act: req
        width:
        {
          name: NumRamInst
          desc: Number of internal RAM instances. Must be the same as ceil(MemSizeRam / InstSize) .
          param_type: int
          unpacked_dimensions: null
          default: 1
          local: false
          expose: true
          name_top: SramCtrlMainNumRamInst
        }
        default: "'0"
        inst_name: sram_ctrl_main
        index: -1
      }
      {
        name: lc_escalate_en
        struct: lc_tx
        package: lc_ctrl_pkg
        type: uni
        act: rcv
        width: 1
        default: lc_ctrl_pkg::Off
        inst_name: sram_ctrl_main
        top_signame: lc_ctrl_lc_escalate_en
        index: -1
      }
      {
        name: lc_hw_debug_en
        struct: lc_tx
        package: lc_ctrl_pkg
        type: uni
        act: rcv
        width: 1
        default: lc_ctrl_pkg::Off
        inst_name: sram_ctrl_main
        top_signame: lc_ctrl_lc_hw_debug_en
        index: -1
      }
      {
        name: otp_en_sram_ifetch
        struct: mubi8
        package: prim_mubi_pkg
        type: uni
        act: rcv
        width: 1
        default: prim_mubi_pkg::MuBi8False
        inst_name: sram_ctrl_main
        top_signame: sram_ctrl_main_otp_en_sram_ifetch
        index: -1
      }
      {
        name: racl_policies
        desc:
          '''
          Incoming RACL policy vector from a racl_ctrl instance.
          The policy selection vector (parameter) selects the policy for each register.
          '''
        struct: racl_policy_vec
        package: top_racl_pkg
        type: uni
        act: rcv
        width: 1
        inst_name: sram_ctrl_main
        index: -1
      }
      {
        name: racl_error
        desc: RACL error log information of this module.
        struct: racl_error_log
        package: top_racl_pkg
        type: uni
        act: req
        width: 1
        inst_name: sram_ctrl_main
        index: -1
      }
      {
        name: sram_rerror
        desc: SRAM read error indicating correctable and uncorrectable ECC errors.
        struct: sram_error_t
        package: sram_ctrl_pkg
        type: uni
        act: req
        width: 1
        inst_name: sram_ctrl_main
        index: -1
      }
      {
        name: regs_tl
        struct: tl
        package: tlul_pkg
        type: req_rsp
        act: rsp
        width: 1
        inst_name: sram_ctrl_main
        default: ""
        end_idx: -1
        top_signame: sram_ctrl_main_regs_tl
        index: -1
      }
      {
        name: ram_tl
        struct: tl
        package: tlul_pkg
        type: req_rsp
        act: rsp
        width: 1
        inst_name: sram_ctrl_main
        default: ""
        end_idx: -1
        top_signame: sram_ctrl_main_ram_tl
        index: -1
      }
      {
        name: rom_cfg
        struct: rom_cfg
        package: prim_rom_pkg
        type: uni
        act: rcv
        width: 1
        inst_name: rom_ctrl
        default: ""
        top_signame: ast_rom_cfg
        index: -1
      }
      {
        name: pwrmgr_data
        struct: pwrmgr_data
        package: rom_ctrl_pkg
        type: uni
        act: req
        width: 1
        inst_name: rom_ctrl
        default: ""
        end_idx: -1
        top_type: broadcast
        top_signame: rom_ctrl_pwrmgr_data
        index: -1
      }
      {
        name: keymgr_data
        struct: keymgr_data
        package: rom_ctrl_pkg
        type: uni
        act: req
        width: 1
        inst_name: rom_ctrl
        default: ""
        end_idx: -1
        top_type: broadcast
        top_signame: rom_ctrl_keymgr_data
        index: -1
      }
      {
        name: kmac_data
        struct: app
        package: kmac_pkg
        type: req_rsp
        act: req
        width: 1
        inst_name: rom_ctrl
        default: ""
        top_signame: kmac_app
        index: 2
      }
      {
        name: regs_tl
        struct: tl
        package: tlul_pkg
        type: req_rsp
        act: rsp
        width: 1
        inst_name: rom_ctrl
        default: ""
        end_idx: -1
        top_signame: rom_ctrl_regs_tl
        index: -1
      }
      {
        name: rom_tl
        struct: tl
        package: tlul_pkg
        type: req_rsp
        act: rsp
        width: 1
        inst_name: rom_ctrl
        default: ""
        end_idx: -1
        top_signame: rom_ctrl_rom_tl
        index: -1
      }
      {
        name: rst_cpu_n
        struct: logic
        type: uni
        act: req
        width: 1
        inst_name: rv_core_ibex
        index: -1
      }
      {
        name: ram_cfg_icache_tag
        struct: ram_1p_cfg
        package: prim_ram_1p_pkg
        type: uni
        act: rcv
        width: 1
        inst_name: rv_core_ibex
        default: ""
        top_signame: ast_ram_1p_cfg
        index: -1
      }
      {
        name: ram_cfg_rsp_icache_tag
        struct: ram_1p_cfg_rsp
        package: prim_ram_1p_pkg
        type: uni
        act: req
        width:
        {
          name: ICacheNWays
          desc: Number of instruction cache ways
          param_type: int unsigned
          unpacked_dimensions: null
          default: 2
          local: false
          expose: true
          name_top: RvCoreIbexICacheNWays
        }
        inst_name: rv_core_ibex
        index: -1
      }
      {
        name: ram_cfg_icache_data
        struct: ram_1p_cfg
        package: prim_ram_1p_pkg
        type: uni
        act: rcv
        width: 1
        inst_name: rv_core_ibex
        default: ""
        top_signame: ast_ram_1p_cfg
        index: -1
      }
      {
        name: ram_cfg_rsp_icache_data
        struct: ram_1p_cfg_rsp
        package: prim_ram_1p_pkg
        type: uni
        act: req
        width:
        {
          name: ICacheNWays
          desc: Number of instruction cache ways
          param_type: int unsigned
          unpacked_dimensions: null
          default: 2
          local: false
          expose: true
          name_top: RvCoreIbexICacheNWays
        }
        inst_name: rv_core_ibex
        index: -1
      }
      {
        name: hart_id
        struct: logic
        type: uni
        act: rcv
        width: 32
        inst_name: rv_core_ibex
        default: ""
        package: ""
        top_signame: rv_core_ibex_hart_id
        index: -1
      }
      {
        name: boot_addr
        struct: logic
        type: uni
        act: rcv
        width: 32
        inst_name: rv_core_ibex
        default: ""
        package: ""
        top_signame: rv_core_ibex_boot_addr
        index: -1
      }
      {
        name: irq_software
        struct: logic
        type: uni
        act: rcv
        width: 1
        inst_name: rv_core_ibex
        default: ""
        package: ""
        top_signame: rv_plic_msip
        index: -1
      }
      {
        name: irq_timer
        struct: logic
        type: uni
        act: rcv
        width: 1
        inst_name: rv_core_ibex
        default: ""
        package: ""
        top_signame: rv_core_ibex_irq_timer
        index: -1
      }
      {
        name: irq_external
        struct: logic
        type: uni
        act: rcv
        width: 1
        inst_name: rv_core_ibex
        default: ""
        package: ""
        top_signame: rv_plic_irq
        index: -1
      }
      {
        name: esc_tx
        struct: esc_tx
        package: prim_esc_pkg
        type: uni
        act: rcv
        width: 1
        inst_name: rv_core_ibex
        default: ""
        top_signame: alert_handler_esc_tx
        index: 0
      }
      {
        name: esc_rx
        struct: esc_rx
        package: prim_esc_pkg
        type: uni
        act: req
        width: 1
        inst_name: rv_core_ibex
        default: ""
        top_signame: alert_handler_esc_rx
        index: 0
      }
      {
        name: debug_req
        struct: logic
        type: uni
        act: rcv
        width: 1
        inst_name: rv_core_ibex
        default: ""
        package: ""
        top_signame: rv_dm_debug_req
        index: -1
      }
      {
        name: crash_dump
        struct: cpu_crash_dump
        package: rv_core_ibex_pkg
        type: uni
        act: req
        width: 1
        inst_name: rv_core_ibex
        default: ""
        end_idx: -1
        top_type: broadcast
        top_signame: rv_core_ibex_crash_dump
        index: -1
      }
      {
        name: lc_cpu_en
        struct: lc_tx
        package: lc_ctrl_pkg
        type: uni
        act: rcv
        width: 1
        inst_name: rv_core_ibex
        default: ""
        top_signame: lc_ctrl_lc_cpu_en
        index: -1
      }
      {
        name: pwrmgr_cpu_en
        struct: lc_tx
        package: lc_ctrl_pkg
        type: uni
        act: rcv
        width: 1
        inst_name: rv_core_ibex
        default: ""
        top_signame: pwrmgr_aon_fetch_en
        index: -1
      }
      {
        name: pwrmgr
        struct: cpu_pwrmgr
        package: rv_core_ibex_pkg
        type: uni
        act: req
        width: 1
        inst_name: rv_core_ibex
        default: ""
        end_idx: -1
        top_type: broadcast
        top_signame: rv_core_ibex_pwrmgr
        index: -1
      }
      {
        name: nmi_wdog
        struct: logic
        type: uni
        act: rcv
        width: 1
        inst_name: rv_core_ibex
        default: ""
        package: ""
        top_signame: aon_timer_aon_nmi_wdog_timer_bark
        index: -1
      }
      {
        name: edn
        struct: edn
        package: edn_pkg
        type: req_rsp
        act: req
        width: 1
        inst_name: rv_core_ibex
        default: ""
        top_signame: edn0_edn
        index: 7
      }
      {
        name: icache_otp_key
        struct: sram_otp_key
        package: otp_ctrl_pkg
        type: req_rsp
        act: req
        width: 1
        inst_name: rv_core_ibex
        default: ""
        top_signame: otp_ctrl_sram_otp_key
        index: 2
      }
      {
        name: fpga_info
        struct: logic
        type: uni
        act: rcv
        width: 32
        inst_name: rv_core_ibex
        default: ""
        package: ""
        external: true
        top_signame: fpga_info
        conn_type: false
        index: -1
      }
      {
        name: corei_tl_h
        struct: tl
        package: tlul_pkg
        type: req_rsp
        act: req
        width: 1
        inst_name: rv_core_ibex
        default: ""
        top_signame: main_tl_rv_core_ibex__corei
        index: -1
      }
      {
        name: cored_tl_h
        struct: tl
        package: tlul_pkg
        type: req_rsp
        act: req
        width: 1
        inst_name: rv_core_ibex
        default: ""
        top_signame: main_tl_rv_core_ibex__cored
        index: -1
      }
      {
        name: cfg_tl_d
        struct: tl
        package: tlul_pkg
        type: req_rsp
        act: rsp
        width: 1
        inst_name: rv_core_ibex
        default: ""
        end_idx: -1
        top_signame: rv_core_ibex_cfg_tl_d
        index: -1
      }
      {
        name: tl_rv_core_ibex__corei
        struct: tl
        package: tlul_pkg
        type: req_rsp
        act: rsp
        inst_name: main
        width: 1
        default: ""
        end_idx: -1
        top_signame: main_tl_rv_core_ibex__corei
        index: -1
      }
      {
        name: tl_rv_core_ibex__cored
        struct: tl
        package: tlul_pkg
        type: req_rsp
        act: rsp
        inst_name: main
        width: 1
        default: ""
        end_idx: -1
        top_signame: main_tl_rv_core_ibex__cored
        index: -1
      }
      {
        name: tl_rv_dm__sba
        struct: tl
        package: tlul_pkg
        type: req_rsp
        act: rsp
        inst_name: main
        width: 1
        default: ""
        end_idx: -1
        top_signame: main_tl_rv_dm__sba
        index: -1
      }
      {
        name: tl_rv_dm__regs
        struct: tl
        package: tlul_pkg
        type: req_rsp
        act: req
        inst_name: main
        width: 1
        default: ""
        top_signame: rv_dm_regs_tl_d
        index: -1
      }
      {
        name: tl_rv_dm__mem
        struct: tl
        package: tlul_pkg
        type: req_rsp
        act: req
        inst_name: main
        width: 1
        default: ""
        top_signame: rv_dm_mem_tl_d
        index: -1
      }
      {
        name: tl_rom_ctrl__rom
        struct: tl
        package: tlul_pkg
        type: req_rsp
        act: req
        inst_name: main
        width: 1
        default: ""
        top_signame: rom_ctrl_rom_tl
        index: -1
      }
      {
        name: tl_rom_ctrl__regs
        struct: tl
        package: tlul_pkg
        type: req_rsp
        act: req
        inst_name: main
        width: 1
        default: ""
        top_signame: rom_ctrl_regs_tl
        index: -1
      }
      {
        name: tl_peri
        struct: tl
        package: tlul_pkg
        type: req_rsp
        act: req
        inst_name: main
        width: 1
        default: ""
        end_idx: -1
        top_signame: main_tl_peri
        index: -1
      }
      {
        name: tl_spi_host0
        struct: tl
        package: tlul_pkg
        type: req_rsp
        act: req
        inst_name: main
        width: 1
        default: ""
        top_signame: spi_host0_tl
        index: -1
      }
      {
        name: tl_spi_host1
        struct: tl
        package: tlul_pkg
        type: req_rsp
        act: req
        inst_name: main
        width: 1
        default: ""
        top_signame: spi_host1_tl
        index: -1
      }
      {
        name: tl_usbdev
        struct: tl
        package: tlul_pkg
        type: req_rsp
        act: req
        inst_name: main
        width: 1
        default: ""
        top_signame: usbdev_tl
        index: -1
      }
      {
        name: tl_flash_ctrl__core
        struct: tl
        package: tlul_pkg
        type: req_rsp
        act: req
        inst_name: main
        width: 1
        default: ""
        top_signame: flash_ctrl_core_tl
        index: -1
      }
      {
        name: tl_flash_ctrl__prim
        struct: tl
        package: tlul_pkg
        type: req_rsp
        act: req
        inst_name: main
        width: 1
        default: ""
        top_signame: flash_ctrl_prim_tl
        index: -1
      }
      {
        name: tl_flash_ctrl__mem
        struct: tl
        package: tlul_pkg
        type: req_rsp
        act: req
        inst_name: main
        width: 1
        default: ""
        top_signame: flash_ctrl_mem_tl
        index: -1
      }
      {
        name: tl_hmac
        struct: tl
        package: tlul_pkg
        type: req_rsp
        act: req
        inst_name: main
        width: 1
        default: ""
        top_signame: hmac_tl
        index: -1
      }
      {
        name: tl_kmac
        struct: tl
        package: tlul_pkg
        type: req_rsp
        act: req
        inst_name: main
        width: 1
        default: ""
        top_signame: kmac_tl
        index: -1
      }
      {
        name: tl_aes
        struct: tl
        package: tlul_pkg
        type: req_rsp
        act: req
        inst_name: main
        width: 1
        default: ""
        top_signame: aes_tl
        index: -1
      }
      {
        name: tl_entropy_src
        struct: tl
        package: tlul_pkg
        type: req_rsp
        act: req
        inst_name: main
        width: 1
        default: ""
        top_signame: entropy_src_tl
        index: -1
      }
      {
        name: tl_csrng
        struct: tl
        package: tlul_pkg
        type: req_rsp
        act: req
        inst_name: main
        width: 1
        default: ""
        top_signame: csrng_tl
        index: -1
      }
      {
        name: tl_edn0
        struct: tl
        package: tlul_pkg
        type: req_rsp
        act: req
        inst_name: main
        width: 1
        default: ""
        top_signame: edn0_tl
        index: -1
      }
      {
        name: tl_edn1
        struct: tl
        package: tlul_pkg
        type: req_rsp
        act: req
        inst_name: main
        width: 1
        default: ""
        top_signame: edn1_tl
        index: -1
      }
      {
        name: tl_rv_plic
        struct: tl
        package: tlul_pkg
        type: req_rsp
        act: req
        inst_name: main
        width: 1
        default: ""
        top_signame: rv_plic_tl
        index: -1
      }
      {
        name: tl_otbn
        struct: tl
        package: tlul_pkg
        type: req_rsp
        act: req
        inst_name: main
        width: 1
        default: ""
        top_signame: otbn_tl
        index: -1
      }
      {
        name: tl_keymgr
        struct: tl
        package: tlul_pkg
        type: req_rsp
        act: req
        inst_name: main
        width: 1
        default: ""
        top_signame: keymgr_tl
        index: -1
      }
      {
        name: tl_rv_core_ibex__cfg
        struct: tl
        package: tlul_pkg
        type: req_rsp
        act: req
        inst_name: main
        width: 1
        default: ""
        top_signame: rv_core_ibex_cfg_tl_d
        index: -1
      }
      {
        name: tl_sram_ctrl_main__regs
        struct: tl
        package: tlul_pkg
        type: req_rsp
        act: req
        inst_name: main
        width: 1
        default: ""
        top_signame: sram_ctrl_main_regs_tl
        index: -1
      }
      {
        name: tl_sram_ctrl_main__ram
        struct: tl
        package: tlul_pkg
        type: req_rsp
        act: req
        inst_name: main
        width: 1
        default: ""
        top_signame: sram_ctrl_main_ram_tl
        index: -1
      }
      {
        name: tl_main
        struct: tl
        package: tlul_pkg
        type: req_rsp
        act: rsp
        inst_name: peri
        width: 1
        default: ""
        top_signame: main_tl_peri
        index: -1
      }
      {
        name: tl_uart0
        struct: tl
        package: tlul_pkg
        type: req_rsp
        act: req
        inst_name: peri
        width: 1
        default: ""
        top_signame: uart0_tl
        index: -1
      }
      {
        name: tl_uart1
        struct: tl
        package: tlul_pkg
        type: req_rsp
        act: req
        inst_name: peri
        width: 1
        default: ""
        top_signame: uart1_tl
        index: -1
      }
      {
        name: tl_uart2
        struct: tl
        package: tlul_pkg
        type: req_rsp
        act: req
        inst_name: peri
        width: 1
        default: ""
        top_signame: uart2_tl
        index: -1
      }
      {
        name: tl_uart3
        struct: tl
        package: tlul_pkg
        type: req_rsp
        act: req
        inst_name: peri
        width: 1
        default: ""
        top_signame: uart3_tl
        index: -1
      }
      {
        name: tl_i2c0
        struct: tl
        package: tlul_pkg
        type: req_rsp
        act: req
        inst_name: peri
        width: 1
        default: ""
        top_signame: i2c0_tl
        index: -1
      }
      {
        name: tl_i2c1
        struct: tl
        package: tlul_pkg
        type: req_rsp
        act: req
        inst_name: peri
        width: 1
        default: ""
        top_signame: i2c1_tl
        index: -1
      }
      {
        name: tl_i2c2
        struct: tl
        package: tlul_pkg
        type: req_rsp
        act: req
        inst_name: peri
        width: 1
        default: ""
        top_signame: i2c2_tl
        index: -1
      }
      {
        name: tl_pattgen
        struct: tl
        package: tlul_pkg
        type: req_rsp
        act: req
        inst_name: peri
        width: 1
        default: ""
        top_signame: pattgen_tl
        index: -1
      }
      {
        name: tl_pwm_aon
        struct: tl
        package: tlul_pkg
        type: req_rsp
        act: req
        inst_name: peri
        width: 1
        default: ""
        top_signame: pwm_aon_tl
        index: -1
      }
      {
        name: tl_gpio
        struct: tl
        package: tlul_pkg
        type: req_rsp
        act: req
        inst_name: peri
        width: 1
        default: ""
        top_signame: gpio_tl
        index: -1
      }
      {
        name: tl_spi_device
        struct: tl
        package: tlul_pkg
        type: req_rsp
        act: req
        inst_name: peri
        width: 1
        default: ""
        top_signame: spi_device_tl
        index: -1
      }
      {
        name: tl_rv_timer
        struct: tl
        package: tlul_pkg
        type: req_rsp
        act: req
        inst_name: peri
        width: 1
        default: ""
        top_signame: rv_timer_tl
        index: -1
      }
      {
        name: tl_pwrmgr_aon
        struct: tl
        package: tlul_pkg
        type: req_rsp
        act: req
        inst_name: peri
        width: 1
        default: ""
        top_signame: pwrmgr_aon_tl
        index: -1
      }
      {
        name: tl_rstmgr_aon
        struct: tl
        package: tlul_pkg
        type: req_rsp
        act: req
        inst_name: peri
        width: 1
        default: ""
        top_signame: rstmgr_aon_tl
        index: -1
      }
      {
        name: tl_clkmgr_aon
        struct: tl
        package: tlul_pkg
        type: req_rsp
        act: req
        inst_name: peri
        width: 1
        default: ""
        top_signame: clkmgr_aon_tl
        index: -1
      }
      {
        name: tl_pinmux_aon
        struct: tl
        package: tlul_pkg
        type: req_rsp
        act: req
        inst_name: peri
        width: 1
        default: ""
        top_signame: pinmux_aon_tl
        index: -1
      }
      {
        name: tl_otp_ctrl__core
        struct: tl
        package: tlul_pkg
        type: req_rsp
        act: req
        inst_name: peri
        width: 1
        default: ""
        top_signame: otp_ctrl_core_tl
        index: -1
      }
      {
        name: tl_otp_macro
        struct: tl
        package: tlul_pkg
        type: req_rsp
        act: req
        inst_name: peri
        width: 1
        default: ""
        top_signame: otp_macro_tl
        index: -1
      }
      {
        name: tl_lc_ctrl__regs
        struct: tl
        package: tlul_pkg
        type: req_rsp
        act: req
        inst_name: peri
        width: 1
        default: ""
        top_signame: lc_ctrl_regs_tl
        index: -1
      }
      {
        name: tl_sensor_ctrl_aon
        struct: tl
        package: tlul_pkg
        type: req_rsp
        act: req
        inst_name: peri
        width: 1
        default: ""
        top_signame: sensor_ctrl_aon_tl
        index: -1
      }
      {
        name: tl_alert_handler
        struct: tl
        package: tlul_pkg
        type: req_rsp
        act: req
        inst_name: peri
        width: 1
        default: ""
        top_signame: alert_handler_tl
        index: -1
      }
      {
        name: tl_sram_ctrl_ret_aon__regs
        struct: tl
        package: tlul_pkg
        type: req_rsp
        act: req
        inst_name: peri
        width: 1
        default: ""
        top_signame: sram_ctrl_ret_aon_regs_tl
        index: -1
      }
      {
        name: tl_sram_ctrl_ret_aon__ram
        struct: tl
        package: tlul_pkg
        type: req_rsp
        act: req
        inst_name: peri
        width: 1
        default: ""
        top_signame: sram_ctrl_ret_aon_ram_tl
        index: -1
      }
      {
        name: tl_aon_timer_aon
        struct: tl
        package: tlul_pkg
        type: req_rsp
        act: req
        inst_name: peri
        width: 1
        default: ""
        top_signame: aon_timer_aon_tl
        index: -1
      }
      {
        name: tl_sysrst_ctrl_aon
        struct: tl
        package: tlul_pkg
        type: req_rsp
        act: req
        inst_name: peri
        width: 1
        default: ""
        top_signame: sysrst_ctrl_aon_tl
        index: -1
      }
      {
        name: tl_adc_ctrl_aon
        struct: tl
        package: tlul_pkg
        type: req_rsp
        act: req
        inst_name: peri
        width: 1
        default: ""
        top_signame: adc_ctrl_aon_tl
        index: -1
      }
      {
        name: tl_ast
        struct: tl
        package: tlul_pkg
        type: req_rsp
        act: req
        inst_name: peri
        width: 1
        default: ""
        external: true
        top_signame: ast_tl
        conn_type: false
        index: -1
      }
      {
        struct: edn
        type: req_rsp
        name: edn
        act: rsp
        package: edn_pkg
        inst_name: ast
        width: 1
        default: ""
        top_signame: edn0_edn
        index: 2
        external: true
        conn_type: true
      }
      {
        struct: lc_tx
        type: uni
        name: lc_dft_en
        act: req
        package: lc_ctrl_pkg
        inst_name: ast
        width: 1
        default: ""
        top_signame: lc_ctrl_lc_dft_en
        index: -1
        external: true
        conn_type: true
      }
      {
        struct: ram_1p_cfg
        package: prim_ram_1p_pkg
        type: uni
        name: ram_1p_cfg
        act: rcv
        inst_name: ast
        width: 1
        default: ""
        end_idx: -1
        top_type: broadcast
        top_signame: ast_ram_1p_cfg
        index: -1
        external: true
        conn_type: true
      }
      {
        struct: ram_2p_cfg
        package: prim_ram_2p_pkg
        type: uni
        name: spi_ram_2p_cfg
        act: rcv
        inst_name: ast
        width: 1
        default: ""
        end_idx: -1
        top_type: broadcast
        top_signame: ast_spi_ram_2p_cfg
        index: -1
        external: true
        conn_type: true
      }
      {
        struct: ram_1p_cfg
        package: prim_ram_1p_pkg
        type: uni
        name: usb_ram_1p_cfg
        act: rcv
        inst_name: ast
        width: 1
        default: ""
        end_idx: -1
        top_type: broadcast
        top_signame: ast_usb_ram_1p_cfg
        index: -1
        external: true
        conn_type: true
      }
      {
        struct: rom_cfg
        package: prim_rom_pkg
        type: uni
        name: rom_cfg
        act: rcv
        inst_name: ast
        width: 1
        default: ""
        end_idx: -1
        top_type: broadcast
        top_signame: ast_rom_cfg
        index: -1
        external: true
        conn_type: true
      }
      {
        struct: ast_obs_ctrl
        type: uni
        name: obs_ctrl
        act: rcv
        package: ast_pkg
        inst_name: ast
        width: 1
        default: ""
        end_idx: -1
        top_type: broadcast
        top_signame: ast_obs_ctrl
        index: -1
        external: true
        conn_type: true
      }
    ]
    external:
    [
      {
        package: ast_pkg
        struct: adc_ast_req
        signame: adc_req_o
        width: 1
        type: req_rsp
        default: ""
        direction: out
        conn_type: false
        index: -1
        netname: adc_req
      }
      {
        package: ast_pkg
        struct: adc_ast_rsp
        signame: adc_rsp_i
        width: 1
        type: req_rsp
        default: ""
        direction: in
        conn_type: false
        index: -1
        netname: adc_rsp
      }
      {
        package: edn_pkg
        struct: edn_req
        signame: ast_edn_req_i
        width: 1
        type: req_rsp
        default: ""
        direction: in
        conn_type: true
        index: 2
        netname: edn0_edn_req
      }
      {
        package: edn_pkg
        struct: edn_rsp
        signame: ast_edn_rsp_o
        width: 1
        type: req_rsp
        default: ""
        direction: out
        conn_type: true
        index: 2
        netname: edn0_edn_rsp
      }
      {
        package: lc_ctrl_pkg
        struct: lc_tx
        signame: ast_lc_dft_en_o
        width: 1
        type: uni
        default: ""
        direction: out
        conn_type: true
        index: -1
        netname: lc_ctrl_lc_dft_en
      }
      {
        package: ast_pkg
        struct: ast_obs_ctrl
        signame: obs_ctrl_i
        width: 1
        type: uni
        default: ""
        direction: in
        conn_type: true
        index: -1
        netname: ast_obs_ctrl
      }
      {
        package: prim_ram_1p_pkg
        struct: ram_1p_cfg
        signame: ram_1p_cfg_i
        width: 1
        type: uni
        default: ""
        direction: in
        conn_type: true
        index: -1
        netname: ast_ram_1p_cfg
      }
      {
        package: prim_ram_1p_pkg
        struct: ram_1p_cfg
        signame: sram_ctrl_main_cfg_i
        width:
        {
          name: NumRamInst
          desc: Number of internal RAM instances. Must be the same as ceil(MemSizeRam / InstSize) .
          param_type: int
          unpacked_dimensions: null
          default: 1
          local: false
          expose: true
          name_top: SramCtrlMainNumRamInst
        }
        type: uni
        default: "'0"
        direction: in
        conn_type: false
        index: -1
        netname: sram_ctrl_main_cfg
      }
      {
        package: prim_ram_1p_pkg
        struct: ram_1p_cfg
        signame: sram_ctrl_ret_aon_cfg_i
        width:
        {
          name: NumRamInst
          desc: Number of internal RAM instances. Must be the same as ceil(MemSizeRam / InstSize) .
          param_type: int
          unpacked_dimensions: null
          default: 1
          local: false
          expose: true
          name_top: SramCtrlRetAonNumRamInst
        }
        type: uni
        default: "'0"
        direction: in
        conn_type: false
        index: -1
        netname: sram_ctrl_ret_aon_cfg
      }
      {
        package: prim_ram_2p_pkg
        struct: ram_2p_cfg
        signame: spi_ram_2p_cfg_i
        width: 1
        type: uni
        default: ""
        direction: in
        conn_type: true
        index: -1
        netname: ast_spi_ram_2p_cfg
      }
      {
        package: prim_ram_1p_pkg
        struct: ram_1p_cfg
        signame: usb_ram_1p_cfg_i
        width: 1
        type: uni
        default: ""
        direction: in
        conn_type: true
        index: -1
        netname: ast_usb_ram_1p_cfg
      }
      {
        package: prim_rom_pkg
        struct: rom_cfg
        signame: rom_cfg_i
        width: 1
        type: uni
        default: ""
        direction: in
        conn_type: true
        index: -1
        netname: ast_rom_cfg
      }
      {
        package: prim_mubi_pkg
        struct: mubi4
        signame: clk_main_jitter_en_o
        width: 1
        type: uni
        default: ""
        direction: out
        conn_type: false
        index: -1
        netname: clk_main_jitter_en
      }
      {
        package: prim_mubi_pkg
        struct: mubi4
        signame: io_clk_byp_req_o
        width: 1
        type: uni
        default: ""
        direction: out
        conn_type: false
        index: -1
        netname: io_clk_byp_req
      }
      {
        package: prim_mubi_pkg
        struct: mubi4
        signame: io_clk_byp_ack_i
        width: 1
        type: uni
        default: ""
        direction: in
        conn_type: false
        index: -1
        netname: io_clk_byp_ack
      }
      {
        package: prim_mubi_pkg
        struct: mubi4
        signame: all_clk_byp_req_o
        width: 1
        type: uni
        default: ""
        direction: out
        conn_type: false
        index: -1
        netname: all_clk_byp_req
      }
      {
        package: prim_mubi_pkg
        struct: mubi4
        signame: all_clk_byp_ack_i
        width: 1
        type: uni
        default: ""
        direction: in
        conn_type: false
        index: -1
        netname: all_clk_byp_ack
      }
      {
        package: prim_mubi_pkg
        struct: mubi4
        signame: hi_speed_sel_o
        width: 1
        type: uni
        default: ""
        direction: out
        conn_type: false
        index: -1
        netname: hi_speed_sel
      }
      {
        package: prim_mubi_pkg
        struct: mubi4
        signame: div_step_down_req_i
        width: 1
        type: uni
        default: ""
        direction: in
        conn_type: false
        index: -1
        netname: div_step_down_req
      }
      {
        package: prim_mubi_pkg
        struct: mubi4
        signame: calib_rdy_i
        width: 1
        type: uni
        default: prim_mubi_pkg::MuBi4True
        direction: in
        conn_type: false
        index: -1
        netname: calib_rdy
      }
      {
        package: prim_mubi_pkg
        struct: mubi4
        signame: flash_bist_enable_i
        width: 1
        type: uni
        default: ""
        direction: in
        conn_type: false
        index: -1
        netname: flash_bist_enable
      }
      {
        package: ""
        struct: logic
        signame: flash_power_down_h_i
        width: 1
        type: uni
        default: ""
        direction: in
        conn_type: false
        index: -1
        netname: flash_power_down_h
      }
      {
        package: ""
        struct: logic
        signame: flash_power_ready_h_i
        width: 1
        type: uni
        default: ""
        direction: in
        conn_type: false
        index: -1
        netname: flash_power_ready_h
      }
      {
        package: ""
        struct: ""
        signame: flash_test_mode_a_io
        width: 2
        type: io
        default: ""
        direction: inout
        conn_type: false
        index: -1
        netname: flash_test_mode_a
      }
      {
        package: ""
        struct: ""
        signame: flash_test_voltage_h_io
        width: 1
        type: io
        default: ""
        direction: inout
        conn_type: false
        index: -1
        netname: flash_test_voltage_h
      }
      {
        package: ""
        struct: logic
        signame: flash_obs_o
        width: 8
        type: uni
        default: ""
        direction: out
        conn_type: false
        index: -1
        netname: flash_obs
      }
      {
        package: entropy_src_pkg
        struct: entropy_src_rng_req
        signame: es_rng_req_o
        width: 1
        type: req_rsp
        default: ""
        direction: out
        conn_type: false
        index: -1
        netname: es_rng_req
      }
      {
        package: entropy_src_pkg
        struct: entropy_src_rng_rsp
        signame: es_rng_rsp_i
        width: 1
        type: req_rsp
        default: ""
        direction: in
        conn_type: false
        index: -1
        netname: es_rng_rsp
      }
      {
        package: ""
        struct: logic
        signame: es_rng_fips_o
        width: 1
        type: uni
        default: ""
        direction: out
        conn_type: false
        index: -1
        netname: es_rng_fips
      }
      {
        package: tlul_pkg
        struct: tl_h2d
        signame: ast_tl_req_o
        width: 1
        type: req_rsp
        default: ""
        direction: out
        conn_type: false
        index: -1
        netname: ast_tl_h2d
      }
      {
        package: tlul_pkg
        struct: tl_d2h
        signame: ast_tl_rsp_i
        width: 1
        type: req_rsp
        default: ""
        direction: in
        conn_type: false
        index: -1
        netname: ast_tl_d2h
      }
      {
        package: pinmux_pkg
        struct: dft_strap_test_req
        signame: dft_strap_test_o
        width: 1
        type: uni
        default: "'0"
        direction: out
        conn_type: false
        index: -1
        netname: dft_strap_test
      }
      {
        package: ""
        struct: logic
        signame: dft_hold_tap_sel_i
        width: 1
        type: uni
        default: "'0"
        direction: in
        conn_type: false
        index: -1
        netname: dft_hold_tap_sel
      }
      {
        package: ""
        struct: logic
        signame: usb_dp_pullup_en_o
        width: 1
        type: uni
        default: 1'b0
        direction: out
        conn_type: false
        index: -1
        netname: usb_dp_pullup_en
      }
      {
        package: ""
        struct: logic
        signame: usb_dn_pullup_en_o
        width: 1
        type: uni
        default: 1'b0
        direction: out
        conn_type: false
        index: -1
        netname: usb_dn_pullup_en
      }
      {
        package: pwrmgr_pkg
        struct: pwr_ast_req
        signame: pwrmgr_ast_req_o
        width: 1
        type: req_rsp
        default: ""
        direction: out
        conn_type: false
        index: -1
        netname: pwrmgr_ast_req
      }
      {
        package: pwrmgr_pkg
        struct: pwr_ast_rsp
        signame: pwrmgr_ast_rsp_i
        width: 1
        type: req_rsp
        default: ""
        direction: in
        conn_type: false
        index: -1
        netname: pwrmgr_ast_rsp
      }
      {
        package: otp_macro_pkg
        struct: pwr_seq
        signame: otp_macro_pwr_seq_o
        width: 1
        type: uni
        default: "'0"
        direction: out
        conn_type: false
        index: -1
        netname: otp_macro_pwr_seq
      }
      {
        package: otp_macro_pkg
        struct: pwr_seq
        signame: otp_macro_pwr_seq_h_i
        width: 1
        type: uni
        default: "'0"
        direction: in
        conn_type: false
        index: -1
        netname: otp_macro_pwr_seq_h
      }
      {
        package: ""
        struct: ""
        signame: otp_ext_voltage_h_io
        width: 1
        type: io
        default: "'0"
        direction: inout
        conn_type: false
        index: -1
        netname: otp_ext_voltage_h
      }
      {
        package: ""
        struct: logic
        signame: otp_obs_o
        width: 8
        type: uni
        default: ""
        direction: out
        conn_type: false
        index: -1
        netname: otp_obs
      }
      {
        package: ""
        struct: logic
        signame: por_n_i
        width: 2
        type: uni
        default: ""
        direction: in
        conn_type: false
        index: -1
        netname: por_n
      }
      {
        package: ""
        struct: logic
        signame: fpga_info_i
        width: 32
        type: uni
        default: ""
        direction: in
        conn_type: false
        index: -1
        netname: fpga_info
      }
      {
        package: ast_pkg
        struct: ast_alert_req
        signame: sensor_ctrl_ast_alert_req_i
        width: 1
        type: req_rsp
        default: ""
        direction: in
        conn_type: false
        index: -1
        netname: sensor_ctrl_ast_alert_req
      }
      {
        package: ast_pkg
        struct: ast_alert_rsp
        signame: sensor_ctrl_ast_alert_rsp_o
        width: 1
        type: req_rsp
        default: ""
        direction: out
        conn_type: false
        index: -1
        netname: sensor_ctrl_ast_alert_rsp
      }
      {
        package: ast_pkg
        struct: ast_status
        signame: sensor_ctrl_ast_status_i
        width: 1
        type: uni
        default: ""
        direction: in
        conn_type: false
        index: -1
        netname: sensor_ctrl_ast_status
      }
      {
        package: ""
        struct: logic
        signame: ast2pinmux_i
        width: 9
        type: uni
        default: ""
        direction: in
        conn_type: false
        index: -1
        netname: ast2pinmux
      }
      {
        package: prim_mubi_pkg
        struct: mubi4
        signame: ast_init_done_i
        width: 1
        type: uni
        default: prim_mubi_pkg::MuBi4True
        direction: in
        conn_type: false
        index: -1
        netname: ast_init_done
      }
      {
        package: prim_pad_wrapper_pkg
        struct: pad_attr
        signame: sensor_ctrl_manual_pad_attr_o
        width: 4
        type: uni
        default: "'0"
        direction: out
        conn_type: false
        index: -1
        netname: sensor_ctrl_manual_pad_attr
      }
      {
        package: ""
        struct: logic
        signame: sck_monitor_o
        width: 1
        type: uni
        default: ""
        direction: out
        conn_type: false
        index: -1
        netname: sck_monitor
      }
      {
        package: ""
        struct: logic
        signame: usbdev_usb_rx_d_i
        width: 1
        type: uni
        default: ""
        direction: in
        conn_type: false
        index: -1
        netname: usbdev_usb_rx_d
      }
      {
        package: ""
        struct: logic
        signame: usbdev_usb_tx_d_o
        width: 1
        type: uni
        default: ""
        direction: out
        conn_type: false
        index: -1
        netname: usbdev_usb_tx_d
      }
      {
        package: ""
        struct: logic
        signame: usbdev_usb_tx_se0_o
        width: 1
        type: uni
        default: ""
        direction: out
        conn_type: false
        index: -1
        netname: usbdev_usb_tx_se0
      }
      {
        package: ""
        struct: logic
        signame: usbdev_usb_tx_use_d_se0_o
        width: 1
        type: uni
        default: ""
        direction: out
        conn_type: false
        index: -1
        netname: usbdev_usb_tx_use_d_se0
      }
      {
        package: ""
        struct: logic
        signame: usbdev_usb_rx_enable_o
        width: 1
        type: uni
        default: ""
        direction: out
        conn_type: false
        index: -1
        netname: usbdev_usb_rx_enable
      }
      {
        package: ""
        struct: logic
        signame: usbdev_usb_ref_val_o
        width: 1
        type: uni
        default: ""
        direction: out
        conn_type: false
        index: -1
        netname: usbdev_usb_ref_val
      }
      {
        package: ""
        struct: logic
        signame: usbdev_usb_ref_pulse_o
        width: 1
        type: uni
        default: ""
        direction: out
        conn_type: false
        index: -1
        netname: usbdev_usb_ref_pulse
      }
    ]
    definitions:
    [
      {
        package: ast_pkg
        struct: ast_obs_ctrl
        signame: ast_obs_ctrl
        width: 1
        type: uni
        end_idx: -1
        act: rcv
        suffix: ""
        default: ast_pkg::AST_OBS_CTRL_DEFAULT
      }
      {
        package: prim_ram_1p_pkg
        struct: ram_1p_cfg
        signame: ast_ram_1p_cfg
        width: 1
        type: uni
        end_idx: -1
        act: rcv
        suffix: ""
        default: prim_ram_1p_pkg::RAM_1P_CFG_DEFAULT
      }
      {
        package: prim_ram_2p_pkg
        struct: ram_2p_cfg
        signame: ast_spi_ram_2p_cfg
        width: 1
        type: uni
        end_idx: -1
        act: rcv
        suffix: ""
        default: prim_ram_2p_pkg::RAM_2P_CFG_DEFAULT
      }
      {
        package: prim_ram_1p_pkg
        struct: ram_1p_cfg
        signame: ast_usb_ram_1p_cfg
        width: 1
        type: uni
        end_idx: -1
        act: rcv
        suffix: ""
        default: prim_ram_1p_pkg::RAM_1P_CFG_DEFAULT
      }
      {
        package: prim_rom_pkg
        struct: rom_cfg
        signame: ast_rom_cfg
        width: 1
        type: uni
        end_idx: -1
        act: rcv
        suffix: ""
        default: prim_rom_pkg::ROM_CFG_DEFAULT
      }
      {
        package: alert_handler_pkg
        struct: alert_crashdump
        signame: alert_handler_crashdump
        width: 1
        type: uni
        end_idx: -1
        act: req
        suffix: ""
        default: alert_handler_pkg::ALERT_CRASHDUMP_DEFAULT
      }
      {
        package: prim_esc_pkg
        struct: esc_rx
        signame: alert_handler_esc_rx
        width: 4
        type: uni
        end_idx: -1
        act: rcv
        suffix: ""
        default: prim_esc_pkg::ESC_RX_DEFAULT
      }
      {
        package: prim_esc_pkg
        struct: esc_tx
        signame: alert_handler_esc_tx
        width: 4
        type: uni
        end_idx: -1
        act: req
        suffix: ""
        default: prim_esc_pkg::ESC_TX_DEFAULT
      }
      {
        package: ""
        struct: logic
        signame: aon_timer_aon_nmi_wdog_timer_bark
        width: 1
        type: uni
        end_idx: -1
        act: req
        suffix: ""
        default: 1'b0
      }
      {
        package: csrng_pkg
        struct: csrng_req
        signame: csrng_csrng_cmd_req
        width: 2
        type: req_rsp
        end_idx: -1
        act: rsp
        suffix: req
        default: csrng_pkg::CSRNG_REQ_DEFAULT
      }
      {
        package: csrng_pkg
        struct: csrng_rsp
        signame: csrng_csrng_cmd_rsp
        width: 2
        type: req_rsp
        end_idx: -1
        act: rsp
        suffix: rsp
        default: ""
      }
      {
        package: entropy_src_pkg
        struct: entropy_src_hw_if_req
        signame: csrng_entropy_src_hw_if_req
        width: 1
        type: req_rsp
        end_idx: -1
        act: req
        suffix: req
        default: ""
      }
      {
        package: entropy_src_pkg
        struct: entropy_src_hw_if_rsp
        signame: csrng_entropy_src_hw_if_rsp
        width: 1
        type: req_rsp
        end_idx: -1
        act: req
        suffix: rsp
        default: entropy_src_pkg::ENTROPY_SRC_HW_IF_RSP_DEFAULT
      }
      {
        package: entropy_src_pkg
        struct: cs_aes_halt_req
        signame: csrng_cs_aes_halt_req
        width: 1
        type: req_rsp
        end_idx: -1
        act: rsp
        suffix: req
        default: entropy_src_pkg::CS_AES_HALT_REQ_DEFAULT
      }
      {
        package: entropy_src_pkg
        struct: cs_aes_halt_rsp
        signame: csrng_cs_aes_halt_rsp
        width: 1
        type: req_rsp
        end_idx: -1
        act: rsp
        suffix: rsp
        default: ""
      }
      {
        package: flash_ctrl_pkg
        struct: keymgr_flash
        signame: flash_ctrl_keymgr
        width: 1
        type: uni
        end_idx: -1
        act: req
        suffix: ""
        default: flash_ctrl_pkg::KEYMGR_FLASH_DEFAULT
      }
      {
        package: otp_ctrl_pkg
        struct: flash_otp_key_req
        signame: flash_ctrl_otp_req
        width: 1
        type: req_rsp
        end_idx: -1
        act: req
        suffix: req
        default: ""
      }
      {
        package: otp_ctrl_pkg
        struct: flash_otp_key_rsp
        signame: flash_ctrl_otp_rsp
        width: 1
        type: req_rsp
        end_idx: -1
        act: req
        suffix: rsp
        default: otp_ctrl_pkg::FLASH_OTP_KEY_RSP_DEFAULT
      }
      {
        package: lc_ctrl_pkg
        struct: lc_flash_rma_seed
        signame: flash_ctrl_rma_seed
        width: 1
        type: uni
        end_idx: -1
        act: rcv
        suffix: ""
        default: lc_ctrl_pkg::LC_FLASH_RMA_SEED_DEFAULT
      }
      {
        package: otp_ctrl_pkg
        struct: sram_otp_key_req
        signame: otp_ctrl_sram_otp_key_req
        width: 4
        type: req_rsp
        end_idx: 3
        act: rsp
        suffix: req
        default: "'0"
      }
      {
        package: otp_ctrl_pkg
        struct: sram_otp_key_rsp
        signame: otp_ctrl_sram_otp_key_rsp
        width: 4
        type: req_rsp
        end_idx: 3
        act: rsp
        suffix: rsp
        default: ""
      }
      {
        package: pwrmgr_pkg
        struct: pwr_flash
        signame: pwrmgr_aon_pwr_flash
        width: 1
        type: uni
        end_idx: -1
        act: rcv
        suffix: ""
        default: pwrmgr_pkg::PWR_FLASH_DEFAULT
      }
      {
        package: pwrmgr_pkg
        struct: pwr_rst_req
        signame: pwrmgr_aon_pwr_rst_req
        width: 1
        type: req_rsp
        end_idx: -1
        act: req
        suffix: req
        default: ""
      }
      {
        package: pwrmgr_pkg
        struct: pwr_rst_rsp
        signame: pwrmgr_aon_pwr_rst_rsp
        width: 1
        type: req_rsp
        end_idx: -1
        act: req
        suffix: rsp
        default: pwrmgr_pkg::PWR_RST_RSP_DEFAULT
      }
      {
        package: pwrmgr_pkg
        struct: pwr_clk_req
        signame: pwrmgr_aon_pwr_clk_req
        width: 1
        type: req_rsp
        end_idx: -1
        act: req
        suffix: req
        default: ""
      }
      {
        package: pwrmgr_pkg
        struct: pwr_clk_rsp
        signame: pwrmgr_aon_pwr_clk_rsp
        width: 1
        type: req_rsp
        end_idx: -1
        act: req
        suffix: rsp
        default: pwrmgr_pkg::PWR_CLK_RSP_DEFAULT
      }
      {
        package: pwrmgr_pkg
        struct: pwr_otp_req
        signame: pwrmgr_aon_pwr_otp_req
        width: 1
        type: req_rsp
        end_idx: -1
        act: req
        suffix: req
        default: ""
      }
      {
        package: pwrmgr_pkg
        struct: pwr_otp_rsp
        signame: pwrmgr_aon_pwr_otp_rsp
        width: 1
        type: req_rsp
        end_idx: -1
        act: req
        suffix: rsp
        default: pwrmgr_pkg::PWR_OTP_RSP_DEFAULT
      }
      {
        package: lc_ctrl_pkg
        struct: pwr_lc_req
        signame: pwrmgr_aon_pwr_lc_req
        width: 1
        type: req_rsp
        end_idx: -1
        act: req
        suffix: req
        default: ""
      }
      {
        package: lc_ctrl_pkg
        struct: pwr_lc_rsp
        signame: pwrmgr_aon_pwr_lc_rsp
        width: 1
        type: req_rsp
        end_idx: -1
        act: req
        suffix: rsp
        default: lc_ctrl_pkg::PWR_LC_RSP_DEFAULT
      }
      {
        package: ""
        struct: logic
        signame: pwrmgr_aon_strap
        width: 1
        type: uni
        end_idx: -1
        act: req
        suffix: ""
        default: "'0"
      }
      {
        package: ""
        struct: logic
        signame: pwrmgr_aon_low_power
        width: 1
        type: uni
        end_idx: -1
        act: req
        suffix: ""
        default: "'0"
      }
      {
        package: lc_ctrl_pkg
        struct: lc_tx
        signame: pwrmgr_aon_fetch_en
        width: 1
        type: uni
        end_idx: -1
        act: req
        suffix: ""
        default: lc_ctrl_pkg::LC_TX_DEFAULT
      }
      {
        package: rom_ctrl_pkg
        struct: pwrmgr_data
        signame: rom_ctrl_pwrmgr_data
        width: 1
        type: uni
        end_idx: -1
        act: req
        suffix: ""
        default: rom_ctrl_pkg::PWRMGR_DATA_DEFAULT
      }
      {
        package: rom_ctrl_pkg
        struct: keymgr_data
        signame: rom_ctrl_keymgr_data
        width: 1
        type: uni
        end_idx: -1
        act: req
        suffix: ""
        default: rom_ctrl_pkg::KEYMGR_DATA_DEFAULT
      }
      {
        package: lc_ctrl_pkg
        struct: lc_tx
        signame: lc_ctrl_lc_flash_rma_req
        width: 1
        type: uni
        end_idx: -1
        act: req
        suffix: ""
        default: lc_ctrl_pkg::Off
      }
      {
        package: lc_ctrl_pkg
        struct: lc_tx
        signame: lc_ctrl_lc_flash_rma_ack
        width: 2
        type: uni
        end_idx: -1
        act: rcv
        suffix: ""
        default: lc_ctrl_pkg::On
      }
      {
        package: ""
        struct: logic
        signame: usbdev_usb_dp_pullup
        width: 1
        type: uni
        end_idx: -1
        act: req
        suffix: ""
        default: "'0"
      }
      {
        package: ""
        struct: logic
        signame: usbdev_usb_dn_pullup
        width: 1
        type: uni
        end_idx: -1
        act: req
        suffix: ""
        default: "'0"
      }
      {
        package: ""
        struct: logic
        signame: usbdev_usb_aon_suspend_req
        width: 1
        type: uni
        end_idx: -1
        act: req
        suffix: ""
        default: "'0"
      }
      {
        package: ""
        struct: logic
        signame: usbdev_usb_aon_wake_ack
        width: 1
        type: uni
        end_idx: -1
        act: req
        suffix: ""
        default: "'0"
      }
      {
        package: ""
        struct: logic
        signame: usbdev_usb_aon_bus_not_idle
        width: 1
        type: uni
        end_idx: -1
        act: rcv
        suffix: ""
        default: "'0"
      }
      {
        package: ""
        struct: logic
        signame: usbdev_usb_aon_bus_reset
        width: 1
        type: uni
        end_idx: -1
        act: rcv
        suffix: ""
        default: "'0"
      }
      {
        package: ""
        struct: logic
        signame: usbdev_usb_aon_sense_lost
        width: 1
        type: uni
        end_idx: -1
        act: rcv
        suffix: ""
        default: "'0"
      }
      {
        package: ""
        struct: logic
        signame: pinmux_aon_usbdev_wake_detect_active
        width: 1
        type: uni
        end_idx: -1
        act: req
        suffix: ""
        default: 1'b0
      }
      {
        package: edn_pkg
        struct: edn_req
        signame: edn0_edn_req
        width: 8
        type: req_rsp
        end_idx: -1
        act: rsp
        suffix: req
        default: "'0"
      }
      {
        package: edn_pkg
        struct: edn_rsp
        signame: edn0_edn_rsp
        width: 8
        type: req_rsp
        end_idx: -1
        act: rsp
        suffix: rsp
        default: ""
      }
      {
        package: edn_pkg
        struct: edn_req
        signame: edn1_edn_req
        width: 8
        type: req_rsp
        end_idx: 1
        act: rsp
        suffix: req
        default: "'0"
      }
      {
        package: edn_pkg
        struct: edn_rsp
        signame: edn1_edn_rsp
        width: 8
        type: req_rsp
        end_idx: 1
        act: rsp
        suffix: rsp
        default: ""
      }
      {
        package: otp_ctrl_pkg
        struct: otbn_otp_key_req
        signame: otp_ctrl_otbn_otp_key_req
        width: 1
        type: req_rsp
        end_idx: -1
        act: rsp
        suffix: req
        default: "'0"
      }
      {
        package: otp_ctrl_pkg
        struct: otbn_otp_key_rsp
        signame: otp_ctrl_otbn_otp_key_rsp
        width: 1
        type: req_rsp
        end_idx: -1
        act: rsp
        suffix: rsp
        default: ""
      }
      {
        package: otp_ctrl_pkg
        struct: otp_keymgr_key
        signame: otp_ctrl_otp_keymgr_key
        width: 1
        type: uni
        end_idx: -1
        act: req
        suffix: ""
        default: "'0"
      }
      {
        package: keymgr_pkg
        struct: hw_key_req
        signame: keymgr_aes_key
        width: 1
        type: uni
        end_idx: -1
        act: req
        suffix: ""
        default: keymgr_pkg::HW_KEY_REQ_DEFAULT
      }
      {
        package: keymgr_pkg
        struct: hw_key_req
        signame: keymgr_kmac_key
        width: 1
        type: uni
        end_idx: -1
        act: req
        suffix: ""
        default: keymgr_pkg::HW_KEY_REQ_DEFAULT
      }
      {
        package: keymgr_pkg
        struct: otbn_key_req
        signame: keymgr_otbn_key
        width: 1
        type: uni
        end_idx: -1
        act: req
        suffix: ""
        default: keymgr_pkg::OTBN_KEY_REQ_DEFAULT
      }
      {
        package: kmac_pkg
        struct: app_req
        signame: kmac_app_req
        width:
        {
          name: NumAppIntf
          desc: Number of application interfaces
          param_type: int
          unpacked_dimensions: null
          default: 3
          local: false
          expose: true
          name_top: KmacNumAppIntf
        }
        type: req_rsp
        end_idx: -1
        act: rsp
        suffix: req
        default: kmac_pkg::APP_REQ_DEFAULT
      }
      {
        package: kmac_pkg
        struct: app_rsp
        signame: kmac_app_rsp
        width:
        {
          name: NumAppIntf
          desc: Number of application interfaces
          param_type: int
          unpacked_dimensions: null
          default: 3
          local: false
          expose: true
          name_top: KmacNumAppIntf
        }
        type: req_rsp
        end_idx: -1
        act: rsp
        suffix: rsp
        default: ""
      }
      {
        package: ""
        struct: logic
        signame: kmac_en_masking
        width: 1
        type: uni
        end_idx: -1
        act: req
        suffix: ""
        default: "'0"
      }
      {
        package: prim_mubi_pkg
        struct: mubi4
        signame: clkmgr_aon_idle
        width: 4
        type: uni
        end_idx: -1
        act: rcv
        suffix: ""
        default: prim_mubi_pkg::MUBI4_DEFAULT
      }
      {
        package: jtag_pkg
        struct: jtag_req
        signame: pinmux_aon_lc_jtag_req
        width: 1
        type: req_rsp
        end_idx: -1
        act: req
        suffix: req
        default: ""
      }
      {
        package: jtag_pkg
        struct: jtag_rsp
        signame: pinmux_aon_lc_jtag_rsp
        width: 1
        type: req_rsp
        end_idx: -1
        act: req
        suffix: rsp
        default: jtag_pkg::JTAG_RSP_DEFAULT
      }
      {
        package: jtag_pkg
        struct: jtag_req
        signame: pinmux_aon_rv_jtag_req
        width: 1
        type: req_rsp
        end_idx: -1
        act: req
        suffix: req
        default: ""
      }
      {
        package: jtag_pkg
        struct: jtag_rsp
        signame: pinmux_aon_rv_jtag_rsp
        width: 1
        type: req_rsp
        end_idx: -1
        act: req
        suffix: rsp
        default: jtag_pkg::JTAG_RSP_DEFAULT
      }
      {
        package: lc_ctrl_pkg
        struct: lc_tx
        signame: pinmux_aon_pinmux_hw_debug_en
        width: 1
        type: uni
        end_idx: -1
        act: req
        suffix: ""
        default: lc_ctrl_pkg::Off
      }
      {
        package: otp_ctrl_pkg
        struct: otp_lc_data
        signame: otp_ctrl_otp_lc_data
        width: 1
        type: uni
        end_idx: -1
        act: req
        suffix: ""
        default: "'0"
      }
      {
        package: otp_ctrl_pkg
        struct: lc_otp_program_req
        signame: lc_ctrl_lc_otp_program_req
        width: 1
        type: req_rsp
        end_idx: -1
        act: req
        suffix: req
        default: ""
      }
      {
        package: otp_ctrl_pkg
        struct: lc_otp_program_rsp
        signame: lc_ctrl_lc_otp_program_rsp
        width: 1
        type: req_rsp
        end_idx: -1
        act: req
        suffix: rsp
        default: "'0"
      }
      {
        package: otp_macro_pkg
        struct: otp_test_req
        signame: lc_ctrl_lc_otp_vendor_test_req
        width: 1
        type: req_rsp
        end_idx: -1
        act: req
        suffix: req
        default: ""
      }
      {
        package: otp_macro_pkg
        struct: otp_test_rsp
        signame: lc_ctrl_lc_otp_vendor_test_rsp
        width: 1
        type: req_rsp
        end_idx: -1
        act: req
        suffix: rsp
        default: "'0"
      }
      {
        package: lc_ctrl_pkg
        struct: lc_keymgr_div
        signame: lc_ctrl_lc_keymgr_div
        width: 1
        type: uni
        end_idx: -1
        act: req
        suffix: ""
        default: "'0"
      }
      {
        package: ""
        struct: logic
        signame: lc_ctrl_strap_en_override
        width: 1
        type: uni
        end_idx: -1
        act: req
        suffix: ""
        default: 1'b0
      }
      {
        package: lc_ctrl_pkg
        struct: lc_tx
        signame: lc_ctrl_lc_dft_en
        width: 1
        type: uni
        end_idx: -1
        act: req
        suffix: ""
        default: lc_ctrl_pkg::Off
      }
      {
        package: lc_ctrl_pkg
        struct: lc_tx
        signame: lc_ctrl_lc_nvm_debug_en
        width: 1
        type: uni
        end_idx: -1
        act: req
        suffix: ""
        default: lc_ctrl_pkg::Off
      }
      {
        package: lc_ctrl_pkg
        struct: lc_tx
        signame: lc_ctrl_lc_hw_debug_en
        width: 1
        type: uni
        end_idx: -1
        act: req
        suffix: ""
        default: lc_ctrl_pkg::Off
      }
      {
        package: lc_ctrl_pkg
        struct: lc_tx
        signame: lc_ctrl_lc_cpu_en
        width: 1
        type: uni
        end_idx: -1
        act: req
        suffix: ""
        default: lc_ctrl_pkg::Off
      }
      {
        package: lc_ctrl_pkg
        struct: lc_tx
        signame: lc_ctrl_lc_keymgr_en
        width: 1
        type: uni
        end_idx: -1
        act: req
        suffix: ""
        default: lc_ctrl_pkg::Off
      }
      {
        package: lc_ctrl_pkg
        struct: lc_tx
        signame: lc_ctrl_lc_escalate_en
        width: 1
        type: uni
        end_idx: -1
        act: req
        suffix: ""
        default: lc_ctrl_pkg::Off
      }
      {
        package: lc_ctrl_pkg
        struct: lc_tx
        signame: lc_ctrl_lc_check_byp_en
        width: 1
        type: uni
        end_idx: -1
        act: req
        suffix: ""
        default: lc_ctrl_pkg::Off
      }
      {
        package: lc_ctrl_pkg
        struct: lc_tx
        signame: lc_ctrl_lc_clk_byp_req
        width: 1
        type: uni
        end_idx: -1
        act: req
        suffix: ""
        default: lc_ctrl_pkg::Off
      }
      {
        package: lc_ctrl_pkg
        struct: lc_tx
        signame: lc_ctrl_lc_clk_byp_ack
        width: 1
        type: uni
        end_idx: -1
        act: rcv
        suffix: ""
        default: lc_ctrl_pkg::Off
      }
      {
        package: lc_ctrl_pkg
        struct: lc_tx
        signame: lc_ctrl_lc_creator_seed_sw_rw_en
        width: 1
        type: uni
        end_idx: -1
        act: req
        suffix: ""
        default: lc_ctrl_pkg::Off
      }
      {
        package: lc_ctrl_pkg
        struct: lc_tx
        signame: lc_ctrl_lc_owner_seed_sw_rw_en
        width: 1
        type: uni
        end_idx: -1
        act: req
        suffix: ""
        default: lc_ctrl_pkg::Off
      }
      {
        package: lc_ctrl_pkg
        struct: lc_tx
        signame: lc_ctrl_lc_iso_part_sw_rd_en
        width: 1
        type: uni
        end_idx: -1
        act: req
        suffix: ""
        default: lc_ctrl_pkg::Off
      }
      {
        package: lc_ctrl_pkg
        struct: lc_tx
        signame: lc_ctrl_lc_iso_part_sw_wr_en
        width: 1
        type: uni
        end_idx: -1
        act: req
        suffix: ""
        default: lc_ctrl_pkg::Off
      }
      {
        package: lc_ctrl_pkg
        struct: lc_tx
        signame: lc_ctrl_lc_seed_hw_rd_en
        width: 1
        type: uni
        end_idx: -1
        act: req
        suffix: ""
        default: lc_ctrl_pkg::Off
      }
      {
        package: otp_ctrl_macro_pkg
        struct: otp_ctrl_macro_req
        signame: otp_ctrl_otp_macro_req
        width: 1
        type: req_rsp
        end_idx: -1
        act: req
        suffix: req
        default: ""
      }
      {
        package: otp_ctrl_macro_pkg
        struct: otp_ctrl_macro_rsp
        signame: otp_ctrl_otp_macro_rsp
        width: 1
        type: req_rsp
        end_idx: -1
        act: req
        suffix: rsp
        default: "'0"
      }
      {
        package: ""
        struct: logic
        signame: rv_plic_msip
        width: 1
        type: uni
        end_idx: -1
        act: req
        suffix: ""
        default: "'0"
      }
      {
        package: ""
        struct: logic
        signame: rv_plic_irq
        width: 1
        type: uni
        end_idx: -1
        act: req
        suffix: ""
        default: "'0"
      }
      {
        package: ""
        struct: logic [rv_dm_reg_pkg::NrHarts-1:0]
        signame: rv_dm_debug_req
        width: 1
        type: uni
        end_idx: -1
        act: req
        suffix: ""
        default: "'0"
      }
      {
        package: rv_core_ibex_pkg
        struct: cpu_crash_dump
        signame: rv_core_ibex_crash_dump
        width: 1
        type: uni
        end_idx: -1
        act: req
        suffix: ""
        default: rv_core_ibex_pkg::CPU_CRASH_DUMP_DEFAULT
      }
      {
        package: rv_core_ibex_pkg
        struct: cpu_pwrmgr
        signame: rv_core_ibex_pwrmgr
        width: 1
        type: uni
        end_idx: -1
        act: req
        suffix: ""
        default: rv_core_ibex_pkg::CPU_PWRMGR_DEFAULT
      }
      {
        package: spi_device_pkg
        struct: passthrough_req
        signame: spi_device_passthrough_req
        width: 1
        type: req_rsp
        end_idx: -1
        act: req
        suffix: req
        default: ""
      }
      {
        package: spi_device_pkg
        struct: passthrough_rsp
        signame: spi_device_passthrough_rsp
        width: 1
        type: req_rsp
        end_idx: -1
        act: req
        suffix: rsp
        default: spi_device_pkg::PASSTHROUGH_RSP_DEFAULT
      }
      {
        package: ""
        struct: logic
        signame: rv_dm_ndmreset_req
        width: 1
        type: uni
        end_idx: -1
        act: req
        suffix: ""
        default: "'0"
      }
      {
        package: prim_mubi_pkg
        struct: mubi4
        signame: rstmgr_aon_sw_rst_req
        width: 1
        type: uni
        end_idx: -1
        act: req
        suffix: ""
        default: prim_mubi_pkg::MUBI4_DEFAULT
      }
      {
        package: ""
        struct: logic
        signame: pwrmgr_aon_wakeups
        width: 6
        type: uni
        end_idx: -1
        act: rcv
        suffix: ""
        default: "'0"
      }
      {
        package: ""
        struct: logic
        signame: pwrmgr_aon_rstreqs
        width: 2
        type: uni
        end_idx: -1
        act: rcv
        suffix: ""
        default: "'0"
      }
      {
        package: tlul_pkg
        struct: tl_h2d
        signame: main_tl_rv_core_ibex__corei_req
        width: 1
        type: req_rsp
        end_idx: -1
        act: rsp
        suffix: req
        default: tlul_pkg::TL_H2D_DEFAULT
      }
      {
        package: tlul_pkg
        struct: tl_d2h
        signame: main_tl_rv_core_ibex__corei_rsp
        width: 1
        type: req_rsp
        end_idx: -1
        act: rsp
        suffix: rsp
        default: ""
      }
      {
        package: tlul_pkg
        struct: tl_h2d
        signame: main_tl_rv_core_ibex__cored_req
        width: 1
        type: req_rsp
        end_idx: -1
        act: rsp
        suffix: req
        default: tlul_pkg::TL_H2D_DEFAULT
      }
      {
        package: tlul_pkg
        struct: tl_d2h
        signame: main_tl_rv_core_ibex__cored_rsp
        width: 1
        type: req_rsp
        end_idx: -1
        act: rsp
        suffix: rsp
        default: ""
      }
      {
        package: tlul_pkg
        struct: tl_h2d
        signame: main_tl_rv_dm__sba_req
        width: 1
        type: req_rsp
        end_idx: -1
        act: rsp
        suffix: req
        default: tlul_pkg::TL_H2D_DEFAULT
      }
      {
        package: tlul_pkg
        struct: tl_d2h
        signame: main_tl_rv_dm__sba_rsp
        width: 1
        type: req_rsp
        end_idx: -1
        act: rsp
        suffix: rsp
        default: ""
      }
      {
        package: tlul_pkg
        struct: tl_h2d
        signame: rv_dm_regs_tl_d_req
        width: 1
        type: req_rsp
        end_idx: -1
        act: rsp
        suffix: req
        default: tlul_pkg::TL_H2D_DEFAULT
      }
      {
        package: tlul_pkg
        struct: tl_d2h
        signame: rv_dm_regs_tl_d_rsp
        width: 1
        type: req_rsp
        end_idx: -1
        act: rsp
        suffix: rsp
        default: ""
      }
      {
        package: tlul_pkg
        struct: tl_h2d
        signame: rv_dm_mem_tl_d_req
        width: 1
        type: req_rsp
        end_idx: -1
        act: rsp
        suffix: req
        default: tlul_pkg::TL_H2D_DEFAULT
      }
      {
        package: tlul_pkg
        struct: tl_d2h
        signame: rv_dm_mem_tl_d_rsp
        width: 1
        type: req_rsp
        end_idx: -1
        act: rsp
        suffix: rsp
        default: ""
      }
      {
        package: tlul_pkg
        struct: tl_h2d
        signame: rom_ctrl_rom_tl_req
        width: 1
        type: req_rsp
        end_idx: -1
        act: rsp
        suffix: req
        default: tlul_pkg::TL_H2D_DEFAULT
      }
      {
        package: tlul_pkg
        struct: tl_d2h
        signame: rom_ctrl_rom_tl_rsp
        width: 1
        type: req_rsp
        end_idx: -1
        act: rsp
        suffix: rsp
        default: ""
      }
      {
        package: tlul_pkg
        struct: tl_h2d
        signame: rom_ctrl_regs_tl_req
        width: 1
        type: req_rsp
        end_idx: -1
        act: rsp
        suffix: req
        default: tlul_pkg::TL_H2D_DEFAULT
      }
      {
        package: tlul_pkg
        struct: tl_d2h
        signame: rom_ctrl_regs_tl_rsp
        width: 1
        type: req_rsp
        end_idx: -1
        act: rsp
        suffix: rsp
        default: ""
      }
      {
        package: tlul_pkg
        struct: tl_h2d
        signame: main_tl_peri_req
        width: 1
        type: req_rsp
        end_idx: -1
        act: req
        suffix: req
        default: ""
      }
      {
        package: tlul_pkg
        struct: tl_d2h
        signame: main_tl_peri_rsp
        width: 1
        type: req_rsp
        end_idx: -1
        act: req
        suffix: rsp
        default: tlul_pkg::TL_D2H_DEFAULT
      }
      {
        package: tlul_pkg
        struct: tl_h2d
        signame: spi_host0_tl_req
        width: 1
        type: req_rsp
        end_idx: -1
        act: rsp
        suffix: req
        default: tlul_pkg::TL_H2D_DEFAULT
      }
      {
        package: tlul_pkg
        struct: tl_d2h
        signame: spi_host0_tl_rsp
        width: 1
        type: req_rsp
        end_idx: -1
        act: rsp
        suffix: rsp
        default: ""
      }
      {
        package: tlul_pkg
        struct: tl_h2d
        signame: spi_host1_tl_req
        width: 1
        type: req_rsp
        end_idx: -1
        act: rsp
        suffix: req
        default: tlul_pkg::TL_H2D_DEFAULT
      }
      {
        package: tlul_pkg
        struct: tl_d2h
        signame: spi_host1_tl_rsp
        width: 1
        type: req_rsp
        end_idx: -1
        act: rsp
        suffix: rsp
        default: ""
      }
      {
        package: tlul_pkg
        struct: tl_h2d
        signame: usbdev_tl_req
        width: 1
        type: req_rsp
        end_idx: -1
        act: rsp
        suffix: req
        default: tlul_pkg::TL_H2D_DEFAULT
      }
      {
        package: tlul_pkg
        struct: tl_d2h
        signame: usbdev_tl_rsp
        width: 1
        type: req_rsp
        end_idx: -1
        act: rsp
        suffix: rsp
        default: ""
      }
      {
        package: tlul_pkg
        struct: tl_h2d
        signame: flash_ctrl_core_tl_req
        width: 1
        type: req_rsp
        end_idx: -1
        act: rsp
        suffix: req
        default: tlul_pkg::TL_H2D_DEFAULT
      }
      {
        package: tlul_pkg
        struct: tl_d2h
        signame: flash_ctrl_core_tl_rsp
        width: 1
        type: req_rsp
        end_idx: -1
        act: rsp
        suffix: rsp
        default: ""
      }
      {
        package: tlul_pkg
        struct: tl_h2d
        signame: flash_ctrl_prim_tl_req
        width: 1
        type: req_rsp
        end_idx: -1
        act: rsp
        suffix: req
        default: tlul_pkg::TL_H2D_DEFAULT
      }
      {
        package: tlul_pkg
        struct: tl_d2h
        signame: flash_ctrl_prim_tl_rsp
        width: 1
        type: req_rsp
        end_idx: -1
        act: rsp
        suffix: rsp
        default: ""
      }
      {
        package: tlul_pkg
        struct: tl_h2d
        signame: flash_ctrl_mem_tl_req
        width: 1
        type: req_rsp
        end_idx: -1
        act: rsp
        suffix: req
        default: tlul_pkg::TL_H2D_DEFAULT
      }
      {
        package: tlul_pkg
        struct: tl_d2h
        signame: flash_ctrl_mem_tl_rsp
        width: 1
        type: req_rsp
        end_idx: -1
        act: rsp
        suffix: rsp
        default: ""
      }
      {
        package: tlul_pkg
        struct: tl_h2d
        signame: hmac_tl_req
        width: 1
        type: req_rsp
        end_idx: -1
        act: rsp
        suffix: req
        default: tlul_pkg::TL_H2D_DEFAULT
      }
      {
        package: tlul_pkg
        struct: tl_d2h
        signame: hmac_tl_rsp
        width: 1
        type: req_rsp
        end_idx: -1
        act: rsp
        suffix: rsp
        default: ""
      }
      {
        package: tlul_pkg
        struct: tl_h2d
        signame: kmac_tl_req
        width: 1
        type: req_rsp
        end_idx: -1
        act: rsp
        suffix: req
        default: tlul_pkg::TL_H2D_DEFAULT
      }
      {
        package: tlul_pkg
        struct: tl_d2h
        signame: kmac_tl_rsp
        width: 1
        type: req_rsp
        end_idx: -1
        act: rsp
        suffix: rsp
        default: ""
      }
      {
        package: tlul_pkg
        struct: tl_h2d
        signame: aes_tl_req
        width: 1
        type: req_rsp
        end_idx: -1
        act: rsp
        suffix: req
        default: tlul_pkg::TL_H2D_DEFAULT
      }
      {
        package: tlul_pkg
        struct: tl_d2h
        signame: aes_tl_rsp
        width: 1
        type: req_rsp
        end_idx: -1
        act: rsp
        suffix: rsp
        default: ""
      }
      {
        package: tlul_pkg
        struct: tl_h2d
        signame: entropy_src_tl_req
        width: 1
        type: req_rsp
        end_idx: -1
        act: rsp
        suffix: req
        default: tlul_pkg::TL_H2D_DEFAULT
      }
      {
        package: tlul_pkg
        struct: tl_d2h
        signame: entropy_src_tl_rsp
        width: 1
        type: req_rsp
        end_idx: -1
        act: rsp
        suffix: rsp
        default: ""
      }
      {
        package: tlul_pkg
        struct: tl_h2d
        signame: csrng_tl_req
        width: 1
        type: req_rsp
        end_idx: -1
        act: rsp
        suffix: req
        default: tlul_pkg::TL_H2D_DEFAULT
      }
      {
        package: tlul_pkg
        struct: tl_d2h
        signame: csrng_tl_rsp
        width: 1
        type: req_rsp
        end_idx: -1
        act: rsp
        suffix: rsp
        default: ""
      }
      {
        package: tlul_pkg
        struct: tl_h2d
        signame: edn0_tl_req
        width: 1
        type: req_rsp
        end_idx: -1
        act: rsp
        suffix: req
        default: tlul_pkg::TL_H2D_DEFAULT
      }
      {
        package: tlul_pkg
        struct: tl_d2h
        signame: edn0_tl_rsp
        width: 1
        type: req_rsp
        end_idx: -1
        act: rsp
        suffix: rsp
        default: ""
      }
      {
        package: tlul_pkg
        struct: tl_h2d
        signame: edn1_tl_req
        width: 1
        type: req_rsp
        end_idx: -1
        act: rsp
        suffix: req
        default: tlul_pkg::TL_H2D_DEFAULT
      }
      {
        package: tlul_pkg
        struct: tl_d2h
        signame: edn1_tl_rsp
        width: 1
        type: req_rsp
        end_idx: -1
        act: rsp
        suffix: rsp
        default: ""
      }
      {
        package: tlul_pkg
        struct: tl_h2d
        signame: rv_plic_tl_req
        width: 1
        type: req_rsp
        end_idx: -1
        act: rsp
        suffix: req
        default: tlul_pkg::TL_H2D_DEFAULT
      }
      {
        package: tlul_pkg
        struct: tl_d2h
        signame: rv_plic_tl_rsp
        width: 1
        type: req_rsp
        end_idx: -1
        act: rsp
        suffix: rsp
        default: ""
      }
      {
        package: tlul_pkg
        struct: tl_h2d
        signame: otbn_tl_req
        width: 1
        type: req_rsp
        end_idx: -1
        act: rsp
        suffix: req
        default: tlul_pkg::TL_H2D_DEFAULT
      }
      {
        package: tlul_pkg
        struct: tl_d2h
        signame: otbn_tl_rsp
        width: 1
        type: req_rsp
        end_idx: -1
        act: rsp
        suffix: rsp
        default: ""
      }
      {
        package: tlul_pkg
        struct: tl_h2d
        signame: keymgr_tl_req
        width: 1
        type: req_rsp
        end_idx: -1
        act: rsp
        suffix: req
        default: tlul_pkg::TL_H2D_DEFAULT
      }
      {
        package: tlul_pkg
        struct: tl_d2h
        signame: keymgr_tl_rsp
        width: 1
        type: req_rsp
        end_idx: -1
        act: rsp
        suffix: rsp
        default: ""
      }
      {
        package: tlul_pkg
        struct: tl_h2d
        signame: rv_core_ibex_cfg_tl_d_req
        width: 1
        type: req_rsp
        end_idx: -1
        act: rsp
        suffix: req
        default: tlul_pkg::TL_H2D_DEFAULT
      }
      {
        package: tlul_pkg
        struct: tl_d2h
        signame: rv_core_ibex_cfg_tl_d_rsp
        width: 1
        type: req_rsp
        end_idx: -1
        act: rsp
        suffix: rsp
        default: ""
      }
      {
        package: tlul_pkg
        struct: tl_h2d
        signame: sram_ctrl_main_regs_tl_req
        width: 1
        type: req_rsp
        end_idx: -1
        act: rsp
        suffix: req
        default: tlul_pkg::TL_H2D_DEFAULT
      }
      {
        package: tlul_pkg
        struct: tl_d2h
        signame: sram_ctrl_main_regs_tl_rsp
        width: 1
        type: req_rsp
        end_idx: -1
        act: rsp
        suffix: rsp
        default: ""
      }
      {
        package: tlul_pkg
        struct: tl_h2d
        signame: sram_ctrl_main_ram_tl_req
        width: 1
        type: req_rsp
        end_idx: -1
        act: rsp
        suffix: req
        default: tlul_pkg::TL_H2D_DEFAULT
      }
      {
        package: tlul_pkg
        struct: tl_d2h
        signame: sram_ctrl_main_ram_tl_rsp
        width: 1
        type: req_rsp
        end_idx: -1
        act: rsp
        suffix: rsp
        default: ""
      }
      {
        package: tlul_pkg
        struct: tl_h2d
        signame: uart0_tl_req
        width: 1
        type: req_rsp
        end_idx: -1
        act: rsp
        suffix: req
        default: tlul_pkg::TL_H2D_DEFAULT
      }
      {
        package: tlul_pkg
        struct: tl_d2h
        signame: uart0_tl_rsp
        width: 1
        type: req_rsp
        end_idx: -1
        act: rsp
        suffix: rsp
        default: ""
      }
      {
        package: tlul_pkg
        struct: tl_h2d
        signame: uart1_tl_req
        width: 1
        type: req_rsp
        end_idx: -1
        act: rsp
        suffix: req
        default: tlul_pkg::TL_H2D_DEFAULT
      }
      {
        package: tlul_pkg
        struct: tl_d2h
        signame: uart1_tl_rsp
        width: 1
        type: req_rsp
        end_idx: -1
        act: rsp
        suffix: rsp
        default: ""
      }
      {
        package: tlul_pkg
        struct: tl_h2d
        signame: uart2_tl_req
        width: 1
        type: req_rsp
        end_idx: -1
        act: rsp
        suffix: req
        default: tlul_pkg::TL_H2D_DEFAULT
      }
      {
        package: tlul_pkg
        struct: tl_d2h
        signame: uart2_tl_rsp
        width: 1
        type: req_rsp
        end_idx: -1
        act: rsp
        suffix: rsp
        default: ""
      }
      {
        package: tlul_pkg
        struct: tl_h2d
        signame: uart3_tl_req
        width: 1
        type: req_rsp
        end_idx: -1
        act: rsp
        suffix: req
        default: tlul_pkg::TL_H2D_DEFAULT
      }
      {
        package: tlul_pkg
        struct: tl_d2h
        signame: uart3_tl_rsp
        width: 1
        type: req_rsp
        end_idx: -1
        act: rsp
        suffix: rsp
        default: ""
      }
      {
        package: tlul_pkg
        struct: tl_h2d
        signame: i2c0_tl_req
        width: 1
        type: req_rsp
        end_idx: -1
        act: rsp
        suffix: req
        default: tlul_pkg::TL_H2D_DEFAULT
      }
      {
        package: tlul_pkg
        struct: tl_d2h
        signame: i2c0_tl_rsp
        width: 1
        type: req_rsp
        end_idx: -1
        act: rsp
        suffix: rsp
        default: ""
      }
      {
        package: tlul_pkg
        struct: tl_h2d
        signame: i2c1_tl_req
        width: 1
        type: req_rsp
        end_idx: -1
        act: rsp
        suffix: req
        default: tlul_pkg::TL_H2D_DEFAULT
      }
      {
        package: tlul_pkg
        struct: tl_d2h
        signame: i2c1_tl_rsp
        width: 1
        type: req_rsp
        end_idx: -1
        act: rsp
        suffix: rsp
        default: ""
      }
      {
        package: tlul_pkg
        struct: tl_h2d
        signame: i2c2_tl_req
        width: 1
        type: req_rsp
        end_idx: -1
        act: rsp
        suffix: req
        default: tlul_pkg::TL_H2D_DEFAULT
      }
      {
        package: tlul_pkg
        struct: tl_d2h
        signame: i2c2_tl_rsp
        width: 1
        type: req_rsp
        end_idx: -1
        act: rsp
        suffix: rsp
        default: ""
      }
      {
        package: tlul_pkg
        struct: tl_h2d
        signame: pattgen_tl_req
        width: 1
        type: req_rsp
        end_idx: -1
        act: rsp
        suffix: req
        default: tlul_pkg::TL_H2D_DEFAULT
      }
      {
        package: tlul_pkg
        struct: tl_d2h
        signame: pattgen_tl_rsp
        width: 1
        type: req_rsp
        end_idx: -1
        act: rsp
        suffix: rsp
        default: ""
      }
      {
        package: tlul_pkg
        struct: tl_h2d
        signame: pwm_aon_tl_req
        width: 1
        type: req_rsp
        end_idx: -1
        act: rsp
        suffix: req
        default: tlul_pkg::TL_H2D_DEFAULT
      }
      {
        package: tlul_pkg
        struct: tl_d2h
        signame: pwm_aon_tl_rsp
        width: 1
        type: req_rsp
        end_idx: -1
        act: rsp
        suffix: rsp
        default: ""
      }
      {
        package: tlul_pkg
        struct: tl_h2d
        signame: gpio_tl_req
        width: 1
        type: req_rsp
        end_idx: -1
        act: rsp
        suffix: req
        default: tlul_pkg::TL_H2D_DEFAULT
      }
      {
        package: tlul_pkg
        struct: tl_d2h
        signame: gpio_tl_rsp
        width: 1
        type: req_rsp
        end_idx: -1
        act: rsp
        suffix: rsp
        default: ""
      }
      {
        package: tlul_pkg
        struct: tl_h2d
        signame: spi_device_tl_req
        width: 1
        type: req_rsp
        end_idx: -1
        act: rsp
        suffix: req
        default: tlul_pkg::TL_H2D_DEFAULT
      }
      {
        package: tlul_pkg
        struct: tl_d2h
        signame: spi_device_tl_rsp
        width: 1
        type: req_rsp
        end_idx: -1
        act: rsp
        suffix: rsp
        default: ""
      }
      {
        package: tlul_pkg
        struct: tl_h2d
        signame: rv_timer_tl_req
        width: 1
        type: req_rsp
        end_idx: -1
        act: rsp
        suffix: req
        default: tlul_pkg::TL_H2D_DEFAULT
      }
      {
        package: tlul_pkg
        struct: tl_d2h
        signame: rv_timer_tl_rsp
        width: 1
        type: req_rsp
        end_idx: -1
        act: rsp
        suffix: rsp
        default: ""
      }
      {
        package: tlul_pkg
        struct: tl_h2d
        signame: pwrmgr_aon_tl_req
        width: 1
        type: req_rsp
        end_idx: -1
        act: rsp
        suffix: req
        default: tlul_pkg::TL_H2D_DEFAULT
      }
      {
        package: tlul_pkg
        struct: tl_d2h
        signame: pwrmgr_aon_tl_rsp
        width: 1
        type: req_rsp
        end_idx: -1
        act: rsp
        suffix: rsp
        default: ""
      }
      {
        package: tlul_pkg
        struct: tl_h2d
        signame: rstmgr_aon_tl_req
        width: 1
        type: req_rsp
        end_idx: -1
        act: rsp
        suffix: req
        default: tlul_pkg::TL_H2D_DEFAULT
      }
      {
        package: tlul_pkg
        struct: tl_d2h
        signame: rstmgr_aon_tl_rsp
        width: 1
        type: req_rsp
        end_idx: -1
        act: rsp
        suffix: rsp
        default: ""
      }
      {
        package: tlul_pkg
        struct: tl_h2d
        signame: clkmgr_aon_tl_req
        width: 1
        type: req_rsp
        end_idx: -1
        act: rsp
        suffix: req
        default: tlul_pkg::TL_H2D_DEFAULT
      }
      {
        package: tlul_pkg
        struct: tl_d2h
        signame: clkmgr_aon_tl_rsp
        width: 1
        type: req_rsp
        end_idx: -1
        act: rsp
        suffix: rsp
        default: ""
      }
      {
        package: tlul_pkg
        struct: tl_h2d
        signame: pinmux_aon_tl_req
        width: 1
        type: req_rsp
        end_idx: -1
        act: rsp
        suffix: req
        default: tlul_pkg::TL_H2D_DEFAULT
      }
      {
        package: tlul_pkg
        struct: tl_d2h
        signame: pinmux_aon_tl_rsp
        width: 1
        type: req_rsp
        end_idx: -1
        act: rsp
        suffix: rsp
        default: ""
      }
      {
        package: tlul_pkg
        struct: tl_h2d
        signame: otp_ctrl_core_tl_req
        width: 1
        type: req_rsp
        end_idx: -1
        act: rsp
        suffix: req
        default: tlul_pkg::TL_H2D_DEFAULT
      }
      {
        package: tlul_pkg
        struct: tl_d2h
        signame: otp_ctrl_core_tl_rsp
        width: 1
        type: req_rsp
        end_idx: -1
        act: rsp
        suffix: rsp
        default: ""
      }
      {
        package: tlul_pkg
        struct: tl_h2d
        signame: otp_macro_tl_req
        width: 1
        type: req_rsp
        end_idx: -1
        act: rsp
        suffix: req
        default: tlul_pkg::TL_H2D_DEFAULT
      }
      {
        package: tlul_pkg
        struct: tl_d2h
        signame: otp_macro_tl_rsp
        width: 1
        type: req_rsp
        end_idx: -1
        act: rsp
        suffix: rsp
        default: ""
      }
      {
        package: tlul_pkg
        struct: tl_h2d
        signame: lc_ctrl_regs_tl_req
        width: 1
        type: req_rsp
        end_idx: -1
        act: rsp
        suffix: req
        default: tlul_pkg::TL_H2D_DEFAULT
      }
      {
        package: tlul_pkg
        struct: tl_d2h
        signame: lc_ctrl_regs_tl_rsp
        width: 1
        type: req_rsp
        end_idx: -1
        act: rsp
        suffix: rsp
        default: ""
      }
      {
        package: tlul_pkg
        struct: tl_h2d
        signame: sensor_ctrl_aon_tl_req
        width: 1
        type: req_rsp
        end_idx: -1
        act: rsp
        suffix: req
        default: tlul_pkg::TL_H2D_DEFAULT
      }
      {
        package: tlul_pkg
        struct: tl_d2h
        signame: sensor_ctrl_aon_tl_rsp
        width: 1
        type: req_rsp
        end_idx: -1
        act: rsp
        suffix: rsp
        default: ""
      }
      {
        package: tlul_pkg
        struct: tl_h2d
        signame: alert_handler_tl_req
        width: 1
        type: req_rsp
        end_idx: -1
        act: rsp
        suffix: req
        default: tlul_pkg::TL_H2D_DEFAULT
      }
      {
        package: tlul_pkg
        struct: tl_d2h
        signame: alert_handler_tl_rsp
        width: 1
        type: req_rsp
        end_idx: -1
        act: rsp
        suffix: rsp
        default: ""
      }
      {
        package: tlul_pkg
        struct: tl_h2d
        signame: sram_ctrl_ret_aon_regs_tl_req
        width: 1
        type: req_rsp
        end_idx: -1
        act: rsp
        suffix: req
        default: tlul_pkg::TL_H2D_DEFAULT
      }
      {
        package: tlul_pkg
        struct: tl_d2h
        signame: sram_ctrl_ret_aon_regs_tl_rsp
        width: 1
        type: req_rsp
        end_idx: -1
        act: rsp
        suffix: rsp
        default: ""
      }
      {
        package: tlul_pkg
        struct: tl_h2d
        signame: sram_ctrl_ret_aon_ram_tl_req
        width: 1
        type: req_rsp
        end_idx: -1
        act: rsp
        suffix: req
        default: tlul_pkg::TL_H2D_DEFAULT
      }
      {
        package: tlul_pkg
        struct: tl_d2h
        signame: sram_ctrl_ret_aon_ram_tl_rsp
        width: 1
        type: req_rsp
        end_idx: -1
        act: rsp
        suffix: rsp
        default: ""
      }
      {
        package: tlul_pkg
        struct: tl_h2d
        signame: aon_timer_aon_tl_req
        width: 1
        type: req_rsp
        end_idx: -1
        act: rsp
        suffix: req
        default: tlul_pkg::TL_H2D_DEFAULT
      }
      {
        package: tlul_pkg
        struct: tl_d2h
        signame: aon_timer_aon_tl_rsp
        width: 1
        type: req_rsp
        end_idx: -1
        act: rsp
        suffix: rsp
        default: ""
      }
      {
        package: tlul_pkg
        struct: tl_h2d
        signame: sysrst_ctrl_aon_tl_req
        width: 1
        type: req_rsp
        end_idx: -1
        act: rsp
        suffix: req
        default: tlul_pkg::TL_H2D_DEFAULT
      }
      {
        package: tlul_pkg
        struct: tl_d2h
        signame: sysrst_ctrl_aon_tl_rsp
        width: 1
        type: req_rsp
        end_idx: -1
        act: rsp
        suffix: rsp
        default: ""
      }
      {
        package: tlul_pkg
        struct: tl_h2d
        signame: adc_ctrl_aon_tl_req
        width: 1
        type: req_rsp
        end_idx: -1
        act: rsp
        suffix: req
        default: tlul_pkg::TL_H2D_DEFAULT
      }
      {
        package: tlul_pkg
        struct: tl_d2h
        signame: adc_ctrl_aon_tl_rsp
        width: 1
        type: req_rsp
        end_idx: -1
        act: rsp
        suffix: rsp
        default: ""
      }
      {
        package: clkmgr_pkg
        struct: clkmgr_out
        signame: clkmgr_aon_clocks
        width: 1
        type: uni
        end_idx: -1
        default: ""
      }
      {
        package: clkmgr_pkg
        struct: clkmgr_cg_en
        signame: clkmgr_aon_cg_en
        width: 1
        type: uni
        end_idx: -1
        default: ""
      }
      {
        package: rstmgr_pkg
        struct: rstmgr_out
        signame: rstmgr_aon_resets
        width: 1
        type: uni
        end_idx: -1
        default: ""
      }
      {
        package: rstmgr_pkg
        struct: rstmgr_rst_en
        signame: rstmgr_aon_rst_en
        width: 1
        type: uni
        end_idx: -1
        default: ""
      }
      {
        package: ""
        struct: logic
        signame: rv_core_ibex_irq_timer
        width: 1
        type: uni
        end_idx: -1
        default: ""
      }
      {
        package: ""
        struct: logic
        signame: rv_core_ibex_hart_id
        width: 32
        type: uni
        end_idx: -1
        default: ""
      }
      {
        package: ""
        struct: logic
        signame: rv_core_ibex_boot_addr
        width: 32
        type: uni
        end_idx: -1
        default: ""
      }
      {
        package: jtag_pkg
        struct: jtag_req
        signame: pinmux_aon_dft_jtag_req
        width: 1
        type: req_rsp
        end_idx: -1
        default: ""
      }
      {
        package: jtag_pkg
        struct: jtag_rsp
        signame: pinmux_aon_dft_jtag_rsp
        width: 1
        type: req_rsp
        end_idx: -1
        default: ""
      }
      {
        package: otp_ctrl_part_pkg
        struct: otp_broadcast
        signame: otp_ctrl_otp_broadcast
        width: 1
        type: uni
        end_idx: -1
        default: "'0"
      }
      {
        package: prim_mubi_pkg
        struct: mubi8
        signame: csrng_otp_en_csrng_sw_app_read
        width: 1
        type: uni
        end_idx: -1
        default: prim_mubi_pkg::MuBi8True
      }
      {
        package: otp_ctrl_pkg
        struct: otp_device_id
        signame: lc_ctrl_otp_device_id
        width: 1
        type: uni
        end_idx: -1
        default: "'0"
      }
      {
        package: otp_ctrl_pkg
        struct: otp_manuf_state
        signame: lc_ctrl_otp_manuf_state
        width: 1
        type: uni
        end_idx: -1
        default: "'0"
      }
      {
        package: otp_ctrl_pkg
        struct: otp_device_id
        signame: keymgr_otp_device_id
        width: 1
        type: uni
        end_idx: -1
        default: ""
      }
      {
        package: prim_mubi_pkg
        struct: mubi8
        signame: sram_ctrl_main_otp_en_sram_ifetch
        width: 1
        type: uni
        end_idx: -1
        default: prim_mubi_pkg::MuBi8False
      }
      {
        package: prim_mubi_pkg
        struct: mubi8
        signame: rv_dm_otp_dis_rv_dm_late_debug
        width: 1
        type: uni
        end_idx: -1
        default: prim_mubi_pkg::MuBi8False
      }
    ]
  }
}
