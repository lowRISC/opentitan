// Copyright lowRISC contributors.
// Licensed under the Apache License, Version 2.0, see LICENSE for details.
// SPDX-License-Identifier: Apache-2.0
//
// ------------------- W A R N I N G: A U T O - G E N E R A T E D   C O D E !! -------------------//
// PLEASE DO NOT HAND-EDIT THIS FILE. IT HAS BEEN AUTO-GENERATED WITH THE FOLLOWING COMMAND:
// util/topgen.py -t hw/top_earlgrey/data/top_earlgrey.hjson --hjson-only -o hw/top_earlgrey/
{
  name: earlgrey
  type: top
  datawidth: "32"
  clocks:
  {
    hier_paths:
    {
      top: clkmgr_aon_clocks.
      ext: ""
    }
    srcs:
    [
      {
        name: main
        aon: no
        freq: "100000000"
      }
      {
        name: io
        aon: no
        freq: "100000000"
      }
      {
        name: usb
        aon: no
        freq: "48000000"
      }
      {
        name: aon
        aon: yes
        freq: "200000"
      }
    ]
    groups:
    [
      {
        name: powerup
        src: ext
        sw_cg: no
        unique: no
        clocks:
        {
          clk_io_i: io
          clk_aon_i: aon
          clk_i: main
          clk_usb_i: usb
        }
      }
      {
        name: trans
        src: top
        sw_cg: hint
        unique: yes
        clocks:
        {
          clk_main_aes: main
          clk_main_hmac: main
          clk_main_kmac: main
          clk_main_keymgr: main
          clk_main_csrng: main
          clk_main_entropy_src: main
          clk_main_otbn: main
        }
      }
      {
        name: infra
        src: top
        sw_cg: no
        unique: no
        clocks:
        {
          clk_main_infra: main
          clk_io_infra: io
        }
      }
      {
        name: secure
        src: top
        sw_cg: no
        unique: no
        clocks:
        {
          clk_io_secure: io
          clk_aon_secure: aon
          clk_main_secure: main
          clk_usb_secure: usb
        }
      }
      {
        name: peri
        src: top
        sw_cg: yes
        unique: no
        clocks:
        {
          clk_io_peri: io
          clk_usb_peri: usb
        }
      }
      {
        name: timers
        src: top
        sw_cg: no
        unique: no
        clocks:
        {
          clk_io_timers: io
        }
      }
      {
        name: proc
        src: top
        sw_cg: no
        unique: no
        clocks:
        {
          clk_proc_main: main
        }
      }
    ]
  }
  resets:
  [
    {
      name: rst_ni
      type: ext
    }
    {
      name: por_aon
      type: top
      root: rst_ni
      clk: aon
    }
    {
      name: por
      type: top
      root: por_aon
      clk: main
    }
    {
      name: por_io
      type: top
      root: por_aon
      clk: io
    }
    {
      name: por_usb
      type: top
      root: por_aon
      clk: usb
    }
    {
      name: lc
      type: top
      root: lc
      clk: io
    }
    {
      name: sys
      type: top
      root: sys
      clk: main
    }
    {
      name: sys_io
      type: top
      root: sys
      clk: io
    }
    {
      name: sys_aon
      type: top
      root: sys
      clk: io
    }
    {
      name: spi_device
      type: top
      root: sys
      clk: io
      sw: 1
    }
    {
      name: usb
      type: top
      root: sys
      clk: usb
      sw: 1
    }
  ]
  num_cores: "1"
  module:
  [
    {
      name: uart
      type: uart
      clock_srcs:
      {
        clk_i: io
      }
      reset_connections:
      {
        rst_ni: sys_io
      }
      base_addr: 0x40000000
      clock_group: secure
      clock_connections:
      {
        clk_i: clkmgr_aon_clocks.clk_io_secure
      }
      size: 0x1000
      bus_device: tlul
      bus_host: none
      available_input_list:
      [
        {
          name: rx
          width: 1
          type: input
        }
      ]
      available_output_list:
      [
        {
          name: tx
          width: 1
          type: output
        }
      ]
      available_inout_list: []
      interrupt_list:
      [
        {
          name: tx_watermark
          width: 1
          bits: "0"
          bitinfo:
          [
            1
            1
            0
          ]
          type: interrupt
        }
        {
          name: rx_watermark
          width: 1
          bits: "1"
          bitinfo:
          [
            2
            1
            1
          ]
          type: interrupt
        }
        {
          name: tx_empty
          width: 1
          bits: "2"
          bitinfo:
          [
            4
            1
            2
          ]
          type: interrupt
        }
        {
          name: rx_overflow
          width: 1
          bits: "3"
          bitinfo:
          [
            8
            1
            3
          ]
          type: interrupt
        }
        {
          name: rx_frame_err
          width: 1
          bits: "4"
          bitinfo:
          [
            16
            1
            4
          ]
          type: interrupt
        }
        {
          name: rx_break_err
          width: 1
          bits: "5"
          bitinfo:
          [
            32
            1
            5
          ]
          type: interrupt
        }
        {
          name: rx_timeout
          width: 1
          bits: "6"
          bitinfo:
          [
            64
            1
            6
          ]
          type: interrupt
        }
        {
          name: rx_parity_err
          width: 1
          bits: "7"
          bitinfo:
          [
            128
            1
            7
          ]
          type: interrupt
        }
      ]
      alert_list: []
      wakeup_list: []
      scan: "false"
    }
    {
      name: uart1
      type: uart
      clock_srcs:
      {
        clk_i: io
      }
      clock_group: peri
      reset_connections:
      {
        rst_ni: sys_io
      }
      base_addr: 0x40010000
      clock_connections:
      {
        clk_i: clkmgr_aon_clocks.clk_io_peri
      }
      size: 0x1000
      bus_device: tlul
      bus_host: none
      available_input_list:
      [
        {
          name: rx
          width: 1
          type: input
        }
      ]
      available_output_list:
      [
        {
          name: tx
          width: 1
          type: output
        }
      ]
      available_inout_list: []
      interrupt_list:
      [
        {
          name: tx_watermark
          width: 1
          bits: "0"
          bitinfo:
          [
            1
            1
            0
          ]
          type: interrupt
        }
        {
          name: rx_watermark
          width: 1
          bits: "1"
          bitinfo:
          [
            2
            1
            1
          ]
          type: interrupt
        }
        {
          name: tx_empty
          width: 1
          bits: "2"
          bitinfo:
          [
            4
            1
            2
          ]
          type: interrupt
        }
        {
          name: rx_overflow
          width: 1
          bits: "3"
          bitinfo:
          [
            8
            1
            3
          ]
          type: interrupt
        }
        {
          name: rx_frame_err
          width: 1
          bits: "4"
          bitinfo:
          [
            16
            1
            4
          ]
          type: interrupt
        }
        {
          name: rx_break_err
          width: 1
          bits: "5"
          bitinfo:
          [
            32
            1
            5
          ]
          type: interrupt
        }
        {
          name: rx_timeout
          width: 1
          bits: "6"
          bitinfo:
          [
            64
            1
            6
          ]
          type: interrupt
        }
        {
          name: rx_parity_err
          width: 1
          bits: "7"
          bitinfo:
          [
            128
            1
            7
          ]
          type: interrupt
        }
      ]
      alert_list: []
      wakeup_list: []
      scan: "false"
    }
    {
      name: uart2
      type: uart
      clock_srcs:
      {
        clk_i: io
      }
      clock_group: peri
      reset_connections:
      {
        rst_ni: sys_io
      }
      base_addr: 0x40020000
      clock_connections:
      {
        clk_i: clkmgr_aon_clocks.clk_io_peri
      }
      size: 0x1000
      bus_device: tlul
      bus_host: none
      available_input_list:
      [
        {
          name: rx
          width: 1
          type: input
        }
      ]
      available_output_list:
      [
        {
          name: tx
          width: 1
          type: output
        }
      ]
      available_inout_list: []
      interrupt_list:
      [
        {
          name: tx_watermark
          width: 1
          bits: "0"
          bitinfo:
          [
            1
            1
            0
          ]
          type: interrupt
        }
        {
          name: rx_watermark
          width: 1
          bits: "1"
          bitinfo:
          [
            2
            1
            1
          ]
          type: interrupt
        }
        {
          name: tx_empty
          width: 1
          bits: "2"
          bitinfo:
          [
            4
            1
            2
          ]
          type: interrupt
        }
        {
          name: rx_overflow
          width: 1
          bits: "3"
          bitinfo:
          [
            8
            1
            3
          ]
          type: interrupt
        }
        {
          name: rx_frame_err
          width: 1
          bits: "4"
          bitinfo:
          [
            16
            1
            4
          ]
          type: interrupt
        }
        {
          name: rx_break_err
          width: 1
          bits: "5"
          bitinfo:
          [
            32
            1
            5
          ]
          type: interrupt
        }
        {
          name: rx_timeout
          width: 1
          bits: "6"
          bitinfo:
          [
            64
            1
            6
          ]
          type: interrupt
        }
        {
          name: rx_parity_err
          width: 1
          bits: "7"
          bitinfo:
          [
            128
            1
            7
          ]
          type: interrupt
        }
      ]
      alert_list: []
      wakeup_list: []
      scan: "false"
    }
    {
      name: uart3
      type: uart
      clock_srcs:
      {
        clk_i: io
      }
      clock_group: peri
      reset_connections:
      {
        rst_ni: sys_io
      }
      base_addr: 0x40030000
      clock_connections:
      {
        clk_i: clkmgr_aon_clocks.clk_io_peri
      }
      size: 0x1000
      bus_device: tlul
      bus_host: none
      available_input_list:
      [
        {
          name: rx
          width: 1
          type: input
        }
      ]
      available_output_list:
      [
        {
          name: tx
          width: 1
          type: output
        }
      ]
      available_inout_list: []
      interrupt_list:
      [
        {
          name: tx_watermark
          width: 1
          bits: "0"
          bitinfo:
          [
            1
            1
            0
          ]
          type: interrupt
        }
        {
          name: rx_watermark
          width: 1
          bits: "1"
          bitinfo:
          [
            2
            1
            1
          ]
          type: interrupt
        }
        {
          name: tx_empty
          width: 1
          bits: "2"
          bitinfo:
          [
            4
            1
            2
          ]
          type: interrupt
        }
        {
          name: rx_overflow
          width: 1
          bits: "3"
          bitinfo:
          [
            8
            1
            3
          ]
          type: interrupt
        }
        {
          name: rx_frame_err
          width: 1
          bits: "4"
          bitinfo:
          [
            16
            1
            4
          ]
          type: interrupt
        }
        {
          name: rx_break_err
          width: 1
          bits: "5"
          bitinfo:
          [
            32
            1
            5
          ]
          type: interrupt
        }
        {
          name: rx_timeout
          width: 1
          bits: "6"
          bitinfo:
          [
            64
            1
            6
          ]
          type: interrupt
        }
        {
          name: rx_parity_err
          width: 1
          bits: "7"
          bitinfo:
          [
            128
            1
            7
          ]
          type: interrupt
        }
      ]
      alert_list: []
      wakeup_list: []
      scan: "false"
    }
    {
      name: gpio
      type: gpio
      clock_srcs:
      {
        clk_i: io
      }
      clock_group: peri
      reset_connections:
      {
        rst_ni: sys_io
      }
      base_addr: 0x40040000
      clock_connections:
      {
        clk_i: clkmgr_aon_clocks.clk_io_peri
      }
      size: 0x1000
      bus_device: tlul
      bus_host: none
      available_input_list: []
      available_output_list: []
      available_inout_list:
      [
        {
          name: gpio
          width: 32
          type: inout
        }
      ]
      interrupt_list:
      [
        {
          name: gpio
          width: 32
          bits: 31:0
          bitinfo:
          [
            4294967295
            32
            0
          ]
          type: interrupt
        }
      ]
      alert_list: []
      wakeup_list: []
      scan: "false"
    }
    {
      name: spi_device
      type: spi_device
      clock_srcs:
      {
        clk_i: io
      }
      clock_group: peri
      reset_connections:
      {
        rst_ni: spi_device
      }
      base_addr: 0x40050000
      clock_connections:
      {
        clk_i: clkmgr_aon_clocks.clk_io_peri
      }
      size: 0x1000
      bus_device: tlul
      bus_host: none
      available_input_list:
      [
        {
          name: sck
          width: 1
          type: input
        }
        {
          name: csb
          width: 1
          type: input
        }
        {
          name: mosi
          width: 1
          type: input
        }
      ]
      available_output_list:
      [
        {
          name: miso
          width: 1
          type: output
        }
      ]
      available_inout_list: []
      interrupt_list:
      [
        {
          name: rxf
          width: 1
          bits: "0"
          bitinfo:
          [
            1
            1
            0
          ]
          type: interrupt
        }
        {
          name: rxlvl
          width: 1
          bits: "1"
          bitinfo:
          [
            2
            1
            1
          ]
          type: interrupt
        }
        {
          name: txlvl
          width: 1
          bits: "2"
          bitinfo:
          [
            4
            1
            2
          ]
          type: interrupt
        }
        {
          name: rxerr
          width: 1
          bits: "3"
          bitinfo:
          [
            8
            1
            3
          ]
          type: interrupt
        }
        {
          name: rxoverflow
          width: 1
          bits: "4"
          bitinfo:
          [
            16
            1
            4
          ]
          type: interrupt
        }
        {
          name: txunderflow
          width: 1
          bits: "5"
          bitinfo:
          [
            32
            1
            5
          ]
          type: interrupt
        }
      ]
      alert_list: []
      wakeup_list: []
      scan: "true"
    }
    {
      name: flash_ctrl
      type: flash_ctrl
      clock_srcs:
      {
        clk_i: main
      }
      clock_group: infra
      reset_connections:
      {
        rst_ni: lc
      }
      base_addr: 0x41000000
      clock_connections:
      {
        clk_i: clkmgr_aon_clocks.clk_main_infra
      }
      size: 0x1000
      bus_device: tlul
      bus_host: none
      available_input_list: []
      available_output_list: []
      available_inout_list: []
      interrupt_list:
      [
        {
          name: prog_empty
          width: 1
          bits: "0"
          bitinfo:
          [
            1
            1
            0
          ]
          type: interrupt
        }
        {
          name: prog_lvl
          width: 1
          bits: "1"
          bitinfo:
          [
            2
            1
            1
          ]
          type: interrupt
        }
        {
          name: rd_full
          width: 1
          bits: "2"
          bitinfo:
          [
            4
            1
            2
          ]
          type: interrupt
        }
        {
          name: rd_lvl
          width: 1
          bits: "3"
          bitinfo:
          [
            8
            1
            3
          ]
          type: interrupt
        }
        {
          name: op_done
          width: 1
          bits: "4"
          bitinfo:
          [
            16
            1
            4
          ]
          type: interrupt
        }
        {
          name: op_error
          width: 1
          bits: "5"
          bitinfo:
          [
            32
            1
            5
          ]
          type: interrupt
        }
      ]
      alert_list: []
      wakeup_list: []
      scan: "false"
      inter_signal_list:
      [
        {
          struct: flash
          type: req_rsp
          name: flash
          act: req
          package: flash_ctrl_pkg
          inst_name: flash_ctrl
          width: 1
          top_signame: flash_ctrl_flash
          index: -1
        }
        {
          struct: flash_key
          type: uni
          name: otp
          act: rcv
          package: otp_ctrl_pkg
          inst_name: flash_ctrl
          width: 1
          top_signame: otp_ctrl_otp_flash_key
          index: -1
        }
      ]
    }
    {
      name: rv_timer
      type: rv_timer
      clock_srcs:
      {
        clk_i: io
      }
      clock_group: timers
      reset_connections:
      {
        rst_ni: sys_io
      }
      base_addr: 0x40100000
      clock_connections:
      {
        clk_i: clkmgr_aon_clocks.clk_io_timers
      }
      size: 0x1000
      bus_device: tlul
      bus_host: none
      available_input_list: []
      available_output_list: []
      available_inout_list: []
      interrupt_list:
      [
        {
          name: timer_expired_0_0
          width: 1
          type: interrupt
        }
      ]
      alert_list: []
      wakeup_list: []
      scan: "false"
    }
    {
      name: i2c0
      type: i2c
      clock_srcs:
      {
        clk_i: io
      }
      clock_group: peri
      reset_connections:
      {
        rst_ni: sys_io
      }
      base_addr: 0x40080000
      clock_connections:
      {
        clk_i: clkmgr_aon_clocks.clk_io_peri
      }
      size: 0x1000
      bus_device: tlul
      bus_host: none
      available_input_list: []
      available_output_list: []
      available_inout_list:
      [
        {
          name: sda
          width: 1
          type: inout
        }
        {
          name: scl
          width: 1
          type: inout
        }
      ]
      interrupt_list:
      [
        {
          name: fmt_watermark
          width: 1
          bits: "0"
          bitinfo:
          [
            1
            1
            0
          ]
          type: interrupt
        }
        {
          name: rx_watermark
          width: 1
          bits: "1"
          bitinfo:
          [
            2
            1
            1
          ]
          type: interrupt
        }
        {
          name: fmt_overflow
          width: 1
          bits: "2"
          bitinfo:
          [
            4
            1
            2
          ]
          type: interrupt
        }
        {
          name: rx_overflow
          width: 1
          bits: "3"
          bitinfo:
          [
            8
            1
            3
          ]
          type: interrupt
        }
        {
          name: nak
          width: 1
          bits: "4"
          bitinfo:
          [
            16
            1
            4
          ]
          type: interrupt
        }
        {
          name: scl_interference
          width: 1
          bits: "5"
          bitinfo:
          [
            32
            1
            5
          ]
          type: interrupt
        }
        {
          name: sda_interference
          width: 1
          bits: "6"
          bitinfo:
          [
            64
            1
            6
          ]
          type: interrupt
        }
        {
          name: stretch_timeout
          width: 1
          bits: "7"
          bitinfo:
          [
            128
            1
            7
          ]
          type: interrupt
        }
        {
          name: sda_unstable
          width: 1
          bits: "8"
          bitinfo:
          [
            256
            1
            8
          ]
          type: interrupt
        }
      ]
      alert_list: []
      wakeup_list: []
      scan: "false"
    }
    {
      name: i2c1
      type: i2c
      clock_srcs:
      {
        clk_i: io
      }
      clock_group: peri
      reset_connections:
      {
        rst_ni: sys_io
      }
      base_addr: 0x40090000
      clock_connections:
      {
        clk_i: clkmgr_aon_clocks.clk_io_peri
      }
      size: 0x1000
      bus_device: tlul
      bus_host: none
      available_input_list: []
      available_output_list: []
      available_inout_list:
      [
        {
          name: sda
          width: 1
          type: inout
        }
        {
          name: scl
          width: 1
          type: inout
        }
      ]
      interrupt_list:
      [
        {
          name: fmt_watermark
          width: 1
          bits: "0"
          bitinfo:
          [
            1
            1
            0
          ]
          type: interrupt
        }
        {
          name: rx_watermark
          width: 1
          bits: "1"
          bitinfo:
          [
            2
            1
            1
          ]
          type: interrupt
        }
        {
          name: fmt_overflow
          width: 1
          bits: "2"
          bitinfo:
          [
            4
            1
            2
          ]
          type: interrupt
        }
        {
          name: rx_overflow
          width: 1
          bits: "3"
          bitinfo:
          [
            8
            1
            3
          ]
          type: interrupt
        }
        {
          name: nak
          width: 1
          bits: "4"
          bitinfo:
          [
            16
            1
            4
          ]
          type: interrupt
        }
        {
          name: scl_interference
          width: 1
          bits: "5"
          bitinfo:
          [
            32
            1
            5
          ]
          type: interrupt
        }
        {
          name: sda_interference
          width: 1
          bits: "6"
          bitinfo:
          [
            64
            1
            6
          ]
          type: interrupt
        }
        {
          name: stretch_timeout
          width: 1
          bits: "7"
          bitinfo:
          [
            128
            1
            7
          ]
          type: interrupt
        }
        {
          name: sda_unstable
          width: 1
          bits: "8"
          bitinfo:
          [
            256
            1
            8
          ]
          type: interrupt
        }
      ]
      alert_list: []
      wakeup_list: []
      scan: "false"
    }
    {
      name: i2c2
      type: i2c
      clock_srcs:
      {
        clk_i: io
      }
      clock_group: peri
      reset_connections:
      {
        rst_ni: sys_io
      }
      base_addr: 0x400A0000
      clock_connections:
      {
        clk_i: clkmgr_aon_clocks.clk_io_peri
      }
      size: 0x1000
      bus_device: tlul
      bus_host: none
      available_input_list: []
      available_output_list: []
      available_inout_list:
      [
        {
          name: sda
          width: 1
          type: inout
        }
        {
          name: scl
          width: 1
          type: inout
        }
      ]
      interrupt_list:
      [
        {
          name: fmt_watermark
          width: 1
          bits: "0"
          bitinfo:
          [
            1
            1
            0
          ]
          type: interrupt
        }
        {
          name: rx_watermark
          width: 1
          bits: "1"
          bitinfo:
          [
            2
            1
            1
          ]
          type: interrupt
        }
        {
          name: fmt_overflow
          width: 1
          bits: "2"
          bitinfo:
          [
            4
            1
            2
          ]
          type: interrupt
        }
        {
          name: rx_overflow
          width: 1
          bits: "3"
          bitinfo:
          [
            8
            1
            3
          ]
          type: interrupt
        }
        {
          name: nak
          width: 1
          bits: "4"
          bitinfo:
          [
            16
            1
            4
          ]
          type: interrupt
        }
        {
          name: scl_interference
          width: 1
          bits: "5"
          bitinfo:
          [
            32
            1
            5
          ]
          type: interrupt
        }
        {
          name: sda_interference
          width: 1
          bits: "6"
          bitinfo:
          [
            64
            1
            6
          ]
          type: interrupt
        }
        {
          name: stretch_timeout
          width: 1
          bits: "7"
          bitinfo:
          [
            128
            1
            7
          ]
          type: interrupt
        }
        {
          name: sda_unstable
          width: 1
          bits: "8"
          bitinfo:
          [
            256
            1
            8
          ]
          type: interrupt
        }
      ]
      alert_list: []
      wakeup_list: []
      scan: "false"
    }
    {
      name: sensor_ctrl
      type: sensor_ctrl
      clock_srcs:
      {
        clk_i: io
        clk_aon_i: aon
        clk_sys_i: main
        clk_usb_i: usb
      }
      clock_group: secure
      reset_connections:
      {
        rst_ni: sys_io
        rst_aon_ni: por_aon
        rst_sys_ni: sys
        rst_usb_ni: usb
      }
      base_addr: 0x40110000
      clock_connections:
      {
        clk_i: clkmgr_aon_clocks.clk_io_secure
        clk_aon_i: clkmgr_aon_clocks.clk_aon_secure
        clk_sys_i: clkmgr_aon_clocks.clk_main_secure
        clk_usb_i: clkmgr_aon_clocks.clk_usb_secure
      }
      size: 0x20000
      bus_device: tlul
      bus_host: none
      available_input_list: []
      available_output_list: []
      available_inout_list: []
      interrupt_list: []
      alert_list:
      [
        {
          name: ast_alerts
          width: 7
          type: alert
          async: 1
        }
      ]
      wakeup_list: []
      scan: "false"
      inter_signal_list:
      [
        {
          struct: tl_h2d
          type: uni
          name: ast_host
          act: req
          package: tlul_pkg
          inst_name: sensor_ctrl
          width: 1
          top_signame: sensor_ctrl_ast_host
          index: -1
        }
        {
          struct: tl_d2h
          type: uni
          name: ast_dev
          act: rcv
          package: tlul_pkg
          inst_name: sensor_ctrl
          width: 1
          top_signame: sensor_ctrl_ast_dev
          index: -1
        }
        {
          struct: ast_aux
          type: uni
          name: ast_aux
          act: req
          package: sensor_ctrl_pkg
          inst_name: sensor_ctrl
          width: 1
          top_signame: sensor_ctrl_ast_aux
          index: -1
        }
        {
          struct: ast_alert
          type: req_rsp
          name: ast_alert
          act: rsp
          package: ast_wrapper_pkg
          inst_name: sensor_ctrl
          width: 1
          top_signame: sensor_ctrl_ast_alert
          index: -1
        }
        {
          struct: ast_status
          type: uni
          name: ast_status
          act: rcv
          package: ast_wrapper_pkg
          inst_name: sensor_ctrl
          width: 1
          top_signame: sensor_ctrl_ast_status
          index: -1
        }
      ]
    }
    {
      name: otp_ctrl
      type: otp_ctrl
      clock_srcs:
      {
        clk_i: io
      }
      clock_group: secure
      reset_connections:
      {
        rst_ni: lc
      }
      base_addr: 0x40130000
      clock_connections:
      {
        clk_i: clkmgr_aon_clocks.clk_io_secure
      }
      size: 0x1000
      bus_device: tlul
      bus_host: none
      available_input_list: []
      available_output_list: []
      available_inout_list: []
      interrupt_list:
      [
        {
          name: otp_access_done
          width: 1
          bits: "0"
          bitinfo:
          [
            1
            1
            0
          ]
          type: interrupt
        }
        {
          name: otp_ctrl_err
          width: 1
          bits: "1"
          bitinfo:
          [
            2
            1
            1
          ]
          type: interrupt
        }
      ]
      alert_list:
      [
        {
          name: otp_reg_parity_mismatch
          width: 1
          type: alert
          async: 1
        }
        {
          name: otp_reg_digest_mismatch
          width: 1
          type: alert
          async: 1
        }
      ]
      wakeup_list: []
      scan: "false"
      inter_signal_list:
      [
        {
          struct: pwr_otp
          type: req_rsp
          name: pwr_otp_init
          act: rsp
          package: pwrmgr_pkg
          inst_name: otp_ctrl
          width: 1
          top_signame: pwrmgr_aon_pwr_otp
          index: -1
        }
        {
          struct: otp_pwr_state
          type: uni
          name: otp_pwr_state
          act: req
          package: otp_ctrl_pkg
          inst_name: otp_ctrl
          index: -1
        }
        {
          struct: lc_otp_program
          type: req_rsp
          name: lc_otp_program
          act: rsp
          package: otp_ctrl_pkg
          inst_name: otp_ctrl
          index: -1
        }
        {
          struct: otp_lc_data
          type: uni
          name: otp_lc_data
          act: req
          package: otp_ctrl_pkg
          inst_name: otp_ctrl
          index: -1
        }
        {
          struct: lc_tx
          type: uni
          name: lc_provision_en
          act: rsp
          package: otp_ctrl_pkg
          inst_name: otp_ctrl
          index: -1
        }
        {
          struct: lc_tx
          type: uni
          name: lc_test_en
          act: rsp
          package: otp_ctrl_pkg
          inst_name: otp_ctrl
          index: -1
        }
        {
          struct: keymgr_key
          type: uni
          name: otp_keymgr_key
          act: req
          package: otp_ctrl_pkg
          inst_name: otp_ctrl
          index: -1
        }
        {
          struct: flash_key
          type: uni
          name: otp_flash_key
          act: req
          package: otp_ctrl_pkg
          inst_name: otp_ctrl
          width: 1
          top_type: broadcast
          top_signame: otp_ctrl_otp_flash_key
          index: -1
        }
        {
          struct: sram_key
          type: uni
          name: otp_sram_key
          act: req
          package: otp_ctrl_pkg
          inst_name: otp_ctrl
          width: 1
          top_type: broadcast
          top_signame: otp_ctrl_otp_sram_key
          index: -1
        }
      ]
    }
    {
      name: aes
      type: aes
      clock_srcs:
      {
        clk_i: main
      }
      clock_group: trans
      reset_connections:
      {
        rst_ni: sys
      }
      base_addr: 0x41100000
      clock_connections:
      {
        clk_i: clkmgr_aon_clocks.clk_main_aes
      }
      size: 0x1000
      bus_device: tlul
      bus_host: none
      available_input_list: []
      available_output_list: []
      available_inout_list: []
      interrupt_list: []
      alert_list: []
      wakeup_list: []
      scan: "false"
    }
    {
      name: hmac
      type: hmac
      clock_srcs:
      {
        clk_i: main
      }
      clock_group: trans
      reset_connections:
      {
        rst_ni: sys
      }
      base_addr: 0x41110000
      clock_connections:
      {
        clk_i: clkmgr_aon_clocks.clk_main_hmac
      }
      size: 0x1000
      bus_device: tlul
      bus_host: none
      available_input_list: []
      available_output_list: []
      available_inout_list: []
      interrupt_list:
      [
        {
          name: hmac_done
          width: 1
          bits: "0"
          bitinfo:
          [
            1
            1
            0
          ]
          type: interrupt
        }
        {
          name: fifo_empty
          width: 1
          bits: "1"
          bitinfo:
          [
            2
            1
            1
          ]
          type: interrupt
        }
        {
          name: hmac_err
          width: 1
          bits: "2"
          bitinfo:
          [
            4
            1
            2
          ]
          type: interrupt
        }
      ]
      alert_list:
      [
        {
          name: msg_push_sha_disabled
          width: 1
          type: alert
          async: 0
        }
      ]
      wakeup_list: []
      scan: "false"
    }
    {
      name: kmac
      type: kmac
      clock_srcs:
      {
        clk_i: main
      }
      clock_group: trans
      reset_connections:
      {
        rst_ni: sys
      }
      base_addr: 0x41120000
      clock_connections:
      {
        clk_i: clkmgr_aon_clocks.clk_main_kmac
      }
      size: 0x1000
      bus_device: tlul
      bus_host: none
      available_input_list: []
      available_output_list: []
      available_inout_list: []
      interrupt_list:
      [
        {
          name: kmac_done
          width: 1
          bits: "0"
          bitinfo:
          [
            1
            1
            0
          ]
          type: interrupt
        }
        {
          name: fifo_empty
          width: 1
          bits: "1"
          bitinfo:
          [
            2
            1
            1
          ]
          type: interrupt
        }
        {
          name: kmac_err
          width: 1
          bits: "2"
          bitinfo:
          [
            4
            1
            2
          ]
          type: interrupt
        }
      ]
      alert_list:
      [
        {
          name: sram_uncorrectable
          width: 1
          type: alert
          async: 0
        }
        {
          name: data_parity
          width: 1
          type: alert
          async: 0
        }
      ]
      wakeup_list: []
      scan: "false"
      inter_signal_list:
      [
        {
          struct: hw_key_req
          type: uni
          name: keymgr_key
          act: rcv
          package: keymgr_pkg
          inst_name: kmac
          width: 1
          top_signame: keymgr_kmac_key
          index: -1
        }
        {
          struct: kmac_data
          type: req_rsp
          name: keymgr_data
          act: rsp
          package: keymgr_pkg
          inst_name: kmac
          width: 1
          top_signame: keymgr_kmac_data
          index: -1
        }
      ]
    }
    {
      name: rv_plic
      type: rv_plic
      clock_srcs:
      {
        clk_i: main
      }
      clock_group: secure
      reset_connections:
      {
        rst_ni: sys
      }
      base_addr: 0x41010000
      generated: "true"
      clock_connections:
      {
        clk_i: clkmgr_aon_clocks.clk_main_secure
      }
      size: 0x1000
      bus_device: tlul
      bus_host: none
      available_input_list: []
      available_output_list: []
      available_inout_list: []
      interrupt_list: []
      alert_list: []
      wakeup_list: []
      scan: "false"
    }
    {
      name: pinmux_aon
      type: pinmux
      clock: main
      clock_srcs:
      {
        clk_i: main
        clk_aon_i: io
      }
      clock_group: secure
      reset_connections:
      {
        rst_ni: sys
        rst_aon_ni: sys_io
      }
      base_addr: 0x40460000
      generated: "true"
      clock_connections:
      {
        clk_i: clkmgr_aon_clocks.clk_main_secure
        clk_aon_i: clkmgr_aon_clocks.clk_io_secure
      }
      size: 0x1000
      bus_device: tlul
      bus_host: none
      available_input_list: []
      available_output_list: []
      available_inout_list: []
      interrupt_list: []
      alert_list: []
      wakeup_list:
      [
        {
          name: aon_wkup_req
        }
      ]
      scan: "false"
      inter_signal_list:
      [
        {
          struct: lc_pinmux_strap
          type: req_rsp
          name: lc_pinmux_strap
          act: rsp
          package: pinmux_pkg
          inst_name: pinmux_aon
          index: -1
        }
        {
          struct: logic
          type: uni
          name: sleep_en
          act: rcv
          package: ""
          inst_name: pinmux_aon
          index: -1
        }
        {
          struct: logic
          type: uni
          name: aon_wkup_req
          act: req
          package: ""
          inst_name: pinmux_aon
          width: 1
          top_signame: pwrmgr_aon_wakeups
          index: -1
        }
      ]
    }
    {
      name: padctrl_aon
      type: padctrl
      clock: main
      clock_srcs:
      {
        clk_i: main
      }
      clock_group: secure
      reset_connections:
      {
        rst_ni: sys
      }
      base_addr: 0x40470000
      generated: "true"
      clock_connections:
      {
        clk_i: clkmgr_aon_clocks.clk_main_secure
      }
      size: 0x1000
      bus_device: tlul
      bus_host: none
      available_input_list: []
      available_output_list: []
      available_inout_list: []
      interrupt_list: []
      alert_list: []
      wakeup_list: []
      scan: "false"
    }
    {
      name: alert_handler
      type: alert_handler
      clock_srcs:
      {
        clk_i: main
      }
      clock_group: secure
      reset_connections:
      {
        rst_ni: sys
      }
      base_addr: 0x41170000
      generated: "true"
      localparam:
      {
        EscCntDw: 32
        AccuCntDw: 16
        LfsrSeed: 0x7FFFFFFF
      }
      clock_connections:
      {
        clk_i: clkmgr_aon_clocks.clk_main_secure
      }
      size: 0x1000
      bus_device: tlul
      bus_host: none
      available_input_list: []
      available_output_list: []
      available_inout_list: []
      interrupt_list:
      [
        {
          name: classa
          width: 1
          bits: "0"
          bitinfo:
          [
            1
            1
            0
          ]
          type: interrupt
        }
        {
          name: classb
          width: 1
          bits: "1"
          bitinfo:
          [
            2
            1
            1
          ]
          type: interrupt
        }
        {
          name: classc
          width: 1
          bits: "2"
          bitinfo:
          [
            4
            1
            2
          ]
          type: interrupt
        }
        {
          name: classd
          width: 1
          bits: "3"
          bitinfo:
          [
            8
            1
            3
          ]
          type: interrupt
        }
      ]
      alert_list: []
      wakeup_list: []
      scan: "false"
    }
    {
      name: pwrmgr_aon
      type: pwrmgr
      clock_srcs:
      {
        clk_i: io
        clk_slow_i: aon
      }
      clock_group: powerup
      reset_connections:
      {
        rst_ni: por
        rst_slow_ni: por_aon
      }
      base_addr: 0x40400000
      generated: "true"
      clock_connections:
      {
        clk_i: clk_io_i
        clk_slow_i: clk_aon_i
      }
      size: 0x1000
      bus_device: tlul
      bus_host: none
      available_input_list: []
      available_output_list: []
      available_inout_list: []
      interrupt_list:
      [
        {
          name: wakeup
          width: 1
          bits: "0"
          bitinfo:
          [
            1
            1
            0
          ]
          type: interrupt
        }
      ]
      alert_list: []
      wakeup_list: []
      scan: "false"
      inter_signal_list:
      [
        {
          struct: pwr_ast
          type: req_rsp
          name: pwr_ast
          act: req
          package: pwrmgr_pkg
          inst_name: pwrmgr_aon
          width: 1
          top_signame: pwrmgr_aon_pwr_ast
          index: -1
        }
        {
          struct: pwr_rst
          type: req_rsp
          name: pwr_rst
          act: req
          package: pwrmgr_pkg
          inst_name: pwrmgr_aon
          width: 1
          top_signame: pwrmgr_aon_pwr_rst
          index: -1
        }
        {
          struct: pwr_clk
          type: req_rsp
          name: pwr_clk
          act: req
          package: pwrmgr_pkg
          inst_name: pwrmgr_aon
          width: 1
          top_signame: pwrmgr_aon_pwr_clk
          index: -1
        }
        {
          struct: pwr_otp
          type: req_rsp
          name: pwr_otp
          act: req
          package: pwrmgr_pkg
          inst_name: pwrmgr_aon
          width: 1
          top_signame: pwrmgr_aon_pwr_otp
          index: -1
        }
        {
          struct: pwr_lc
          type: req_rsp
          name: pwr_lc
          act: req
          package: pwrmgr_pkg
          inst_name: pwrmgr_aon
          index: -1
        }
        {
          struct: pwr_flash
          type: uni
          name: pwr_flash
          act: rcv
          package: pwrmgr_pkg
          inst_name: pwrmgr_aon
          index: -1
        }
        {
          struct: pwr_cpu
          type: uni
          name: pwr_cpu
          act: rcv
          package: pwrmgr_pkg
          inst_name: pwrmgr_aon
          width: 1
          top_signame: pwrmgr_aon_pwr_cpu
          index: -1
        }
        {
          struct: logic
          width: 1
          type: uni
          name: wakeups
          act: rcv
          package: ""
          inst_name: pwrmgr_aon
          top_type: broadcast
          top_signame: pwrmgr_aon_wakeups
          index: -1
        }
        {
          struct: logic
          width: 2
          type: uni
          name: rstreqs
          act: rcv
          package: ""
          inst_name: pwrmgr_aon
          index: -1
        }
      ]
    }
    {
      name: rstmgr_aon
      type: rstmgr
      clock_srcs:
      {
        clk_i: io
        clk_aon_i: aon
        clk_main_i: main
        clk_io_i: io
        clk_usb_i: usb
      }
      clock_group: powerup
      reset_connections:
      {
        rst_ni: rst_ni
      }
      base_addr: 0x40410000
      clock_connections:
      {
        clk_i: clk_io_i
        clk_aon_i: clk_aon_i
        clk_main_i: clk_i
        clk_io_i: clk_io_i
        clk_usb_i: clk_usb_i
      }
      size: 0x1000
      bus_device: tlul
      bus_host: none
      available_input_list: []
      available_output_list: []
      available_inout_list: []
      interrupt_list: []
      alert_list: []
      wakeup_list: []
      scan: "false"
      inter_signal_list:
      [
        {
          struct: pwr_rst
          type: req_rsp
          name: pwr
          act: rsp
          inst_name: rstmgr_aon
          width: 1
          package: pwrmgr_pkg
          top_signame: pwrmgr_aon_pwr_rst
          index: -1
        }
        {
          struct: rstmgr_out
          type: uni
          name: resets
          act: req
          package: rstmgr_pkg
          inst_name: rstmgr_aon
          width: 1
          top_signame: rstmgr_aon_resets
          index: -1
        }
        {
          struct: ast_rst
          type: uni
          name: ast
          act: rcv
          package: ast_wrapper_pkg
          inst_name: rstmgr_aon
          width: 1
          top_signame: rstmgr_aon_ast
          index: -1
        }
        {
          struct: rstmgr_cpu
          type: uni
          name: cpu
          act: rcv
          package: rstmgr_pkg
          inst_name: rstmgr_aon
          width: 1
          top_signame: rstmgr_aon_cpu
          index: -1
        }
        {
          struct: rstmgr_peri
          type: uni
          name: peri
          act: rcv
          package: rstmgr_pkg
          inst_name: rstmgr_aon
          index: -1
        }
      ]
    }
    {
      name: clkmgr_aon
      type: clkmgr
      clock_srcs:
      {
        clk_i: io
        clk_main_i: main
        clk_io_i: io
        clk_usb_i: usb
        clk_aon_i: aon
      }
      clock_group: powerup
      reset_connections:
      {
        rst_ni: por_io
        rst_main_ni: por
        rst_io_ni: por_io
        rst_usb_ni: por_usb
      }
      base_addr: 0x40420000
      generated: "true"
      clock_connections:
      {
        clk_i: clk_io_i
        clk_main_i: clk_i
        clk_io_i: clk_io_i
        clk_usb_i: clk_usb_i
        clk_aon_i: clk_aon_i
      }
      size: 0x1000
      bus_device: tlul
      bus_host: none
      available_input_list: []
      available_output_list: []
      available_inout_list: []
      interrupt_list: []
      alert_list: []
      wakeup_list: []
      scan: "false"
      inter_signal_list:
      [
        {
          struct: clkmgr_out
          type: uni
          name: clocks
          act: req
          package: clkmgr_pkg
          inst_name: clkmgr_aon
          width: 1
          top_signame: clkmgr_aon_clocks
          index: -1
        }
        {
          struct: pwr_clk
          type: req_rsp
          name: pwr
          act: rsp
          inst_name: clkmgr_aon
          width: 1
          package: pwrmgr_pkg
          top_signame: pwrmgr_aon_pwr_clk
          index: -1
        }
        {
          struct: clk_dft
          type: uni
          name: dft
          act: rcv
          package: clkmgr_pkg
          inst_name: clkmgr_aon
          index: -1
        }
        {
          struct: clk_hint_status
          type: uni
          name: status
          act: rcv
          package: clkmgr_pkg
          inst_name: clkmgr_aon
          index: -1
        }
      ]
    }
    {
      name: rbox_aon
      type: rbox
      clock_srcs:
      {
        clk_i: io
      }
      clock_group: powerup
      reset_connections:
      {
        rst_ni: por_io
        sw_rst_ni: por_io
      }
      base_addr: 0x40430000
      clock_connections:
      {
        clk_i: clk_io_i
      }
      size: 0x1000
      bus_device: tlul
      bus_host: none
      available_input_list:
      [
        {
          name: ac_present
          width: 1
          type: input
        }
        {
          name: ec_entering_rw
          width: 1
          type: input
        }
        {
          name: key0_in
          width: 1
          type: input
        }
        {
          name: key1_in
          width: 1
          type: input
        }
        {
          name: key2_in
          width: 1
          type: input
        }
        {
          name: pwrb_in
          width: 1
          type: input
        }
      ]
      available_output_list:
      [
        {
          name: bat_en
          width: 1
          type: output
        }
        {
          name: ec_in_rw
          width: 1
          type: output
        }
        {
          name: ec_rst_l
          width: 1
          type: output
        }
        {
          name: flash_wp_l
          width: 1
          type: output
        }
        {
          name: key0_out
          width: 1
          type: output
        }
        {
          name: key1_out
          width: 1
          type: output
        }
        {
          name: key2_out
          width: 1
          type: output
        }
        {
          name: pwrb_out
          width: 1
          type: output
        }
      ]
      available_inout_list: []
      interrupt_list: []
      alert_list: []
      wakeup_list: []
      scan: "false"
    }
    {
      name: nmi_gen
      type: nmi_gen
      clock_srcs:
      {
        clk_i: main
      }
      clock_group: secure
      reset_connections:
      {
        rst_ni: sys
      }
      base_addr: 0x41180000
      clock_connections:
      {
        clk_i: clkmgr_aon_clocks.clk_main_secure
      }
      size: 0x1000
      bus_device: tlul
      bus_host: none
      available_input_list: []
      available_output_list: []
      available_inout_list: []
      interrupt_list:
      [
        {
          name: esc0
          width: 1
          bits: "0"
          bitinfo:
          [
            1
            1
            0
          ]
          type: interrupt
        }
        {
          name: esc1
          width: 1
          bits: "1"
          bitinfo:
          [
            2
            1
            1
          ]
          type: interrupt
        }
        {
          name: esc2
          width: 1
          bits: "2"
          bitinfo:
          [
            4
            1
            2
          ]
          type: interrupt
        }
        {
          name: esc3
          width: 1
          bits: "3"
          bitinfo:
          [
            8
            1
            3
          ]
          type: interrupt
        }
      ]
      alert_list: []
      wakeup_list: []
      scan: "false"
    }
    {
      name: usbdev_aon
      type: usbdev
      clock_srcs:
      {
        clk_i: io
        clk_usb_48mhz_i: usb
      }
      clock_group: peri
      reset_connections:
      {
        rst_ni: sys_io
        rst_usb_48mhz_ni: usb
      }
      base_addr: 0x40500000
      clock_connections:
      {
        clk_i: clkmgr_aon_clocks.clk_io_peri
        clk_usb_48mhz_i: clkmgr_aon_clocks.clk_usb_peri
      }
      size: 0x1000
      bus_device: tlul
      bus_host: none
      available_input_list:
      [
        {
          name: sense
          width: 1
          type: input
        }
      ]
      available_output_list:
      [
        {
          name: se0
          width: 1
          type: output
        }
        {
          name: dp_pullup
          width: 1
          type: output
        }
        {
          name: dn_pullup
          width: 1
          type: output
        }
        {
          name: tx_mode_se
          width: 1
          type: output
        }
        {
          name: suspend
          width: 1
          type: output
        }
      ]
      available_inout_list:
      [
        {
          name: d
          width: 1
          type: inout
        }
        {
          name: dp
          width: 1
          type: inout
        }
        {
          name: dn
          width: 1
          type: inout
        }
      ]
      interrupt_list:
      [
        {
          name: pkt_received
          width: 1
          bits: "0"
          bitinfo:
          [
            1
            1
            0
          ]
          type: interrupt
        }
        {
          name: pkt_sent
          width: 1
          bits: "1"
          bitinfo:
          [
            2
            1
            1
          ]
          type: interrupt
        }
        {
          name: disconnected
          width: 1
          bits: "2"
          bitinfo:
          [
            4
            1
            2
          ]
          type: interrupt
        }
        {
          name: host_lost
          width: 1
          bits: "3"
          bitinfo:
          [
            8
            1
            3
          ]
          type: interrupt
        }
        {
          name: link_reset
          width: 1
          bits: "4"
          bitinfo:
          [
            16
            1
            4
          ]
          type: interrupt
        }
        {
          name: link_suspend
          width: 1
          bits: "5"
          bitinfo:
          [
            32
            1
            5
          ]
          type: interrupt
        }
        {
          name: link_resume
          width: 1
          bits: "6"
          bitinfo:
          [
            64
            1
            6
          ]
          type: interrupt
        }
        {
          name: av_empty
          width: 1
          bits: "7"
          bitinfo:
          [
            128
            1
            7
          ]
          type: interrupt
        }
        {
          name: rx_full
          width: 1
          bits: "8"
          bitinfo:
          [
            256
            1
            8
          ]
          type: interrupt
        }
        {
          name: av_overflow
          width: 1
          bits: "9"
          bitinfo:
          [
            512
            1
            9
          ]
          type: interrupt
        }
        {
          name: link_in_err
          width: 1
          bits: "10"
          bitinfo:
          [
            1024
            1
            10
          ]
          type: interrupt
        }
        {
          name: rx_crc_err
          width: 1
          bits: "11"
          bitinfo:
          [
            2048
            1
            11
          ]
          type: interrupt
        }
        {
          name: rx_pid_err
          width: 1
          bits: "12"
          bitinfo:
          [
            4096
            1
            12
          ]
          type: interrupt
        }
        {
          name: rx_bitstuff_err
          width: 1
          bits: "13"
          bitinfo:
          [
            8192
            1
            13
          ]
          type: interrupt
        }
        {
          name: frame
          width: 1
          bits: "14"
          bitinfo:
          [
            16384
            1
            14
          ]
          type: interrupt
        }
        {
          name: connected
          width: 1
          bits: "15"
          bitinfo:
          [
            32768
            1
            15
          ]
          type: interrupt
        }
      ]
      alert_list: []
      wakeup_list: []
      scan: "false"
      inter_signal_list:
      [
        {
          name: usb_ref_val
          type: uni
          act: req
          package: ""
          struct: logic
          width: 1
          inst_name: usbdev_aon
          top_signame: usbdev_aon_usb_ref_val
          index: -1
        }
        {
          name: usb_ref_pulse
          type: uni
          act: req
          package: ""
          struct: logic
          width: 1
          inst_name: usbdev_aon
          top_signame: usbdev_aon_usb_ref_pulse
          index: -1
        }
      ]
    }
    {
      name: pattgen
      type: pattgen
      clock_srcs:
      {
        clk_i: io
      }
      clock_group: peri
      reset_connections:
      {
        rst_ni: sys_io
      }
      base_addr: 0x400E0000
      clock_connections:
      {
        clk_i: clkmgr_aon_clocks.clk_io_peri
      }
      size: 0x1000
      bus_device: tlul
      bus_host: none
      available_input_list: []
      available_output_list:
      [
        {
          name: pda0_tx
          width: 1
          type: output
        }
        {
          name: pcl0_tx
          width: 1
          type: output
        }
        {
          name: pda1_tx
          width: 1
          type: output
        }
        {
          name: pcl1_tx
          width: 1
          type: output
        }
      ]
      available_inout_list: []
      interrupt_list:
      [
        {
          name: patt_done0
          width: 1
          bits: "0"
          bitinfo:
          [
            1
            1
            0
          ]
          type: interrupt
        }
        {
          name: patt_done1
          width: 1
          bits: "1"
          bitinfo:
          [
            2
            1
            1
          ]
          type: interrupt
        }
      ]
      alert_list: []
      wakeup_list: []
      scan: "false"
    }
    {
      name: keymgr
      type: keymgr
      clock_srcs:
      {
        clk_i: main
      }
      clock_group: trans
      reset_connections:
      {
        rst_ni: sys
      }
      base_addr: 0x41130000
      clock_connections:
      {
        clk_i: clkmgr_aon_clocks.clk_main_keymgr
      }
      size: 0x1000
      bus_device: tlul
      bus_host: none
      available_input_list: []
      available_output_list: []
      available_inout_list: []
      interrupt_list:
      [
        {
          name: op_done
          width: 1
          bits: "0"
          bitinfo:
          [
            1
            1
            0
          ]
          type: interrupt
        }
      ]
      alert_list: []
      wakeup_list: []
      scan: "false"
      inter_signal_list:
      [
        {
          struct: hw_key_req
          type: uni
          name: aes_key
          act: req
          package: keymgr_pkg
          inst_name: keymgr
          index: -1
        }
        {
          struct: hw_key_req
          type: uni
          name: hmac_key
          act: req
          package: keymgr_pkg
          inst_name: keymgr
          index: -1
        }
        {
          struct: hw_key_req
          type: uni
          name: kmac_key
          act: req
          package: keymgr_pkg
          inst_name: keymgr
          width: 1
          top_type: broadcast
          top_signame: keymgr_kmac_key
          index: -1
        }
        {
          struct: kmac_data
          type: req_rsp
          name: kmac_data
          act: req
          package: keymgr_pkg
          inst_name: keymgr
          width: 1
          top_signame: keymgr_kmac_data
          index: -1
        }
        {
          struct: lc_data
          type: uni
          name: lc
          act: rcv
          package: keymgr_pkg
          inst_name: keymgr
          index: -1
        }
        {
          struct: otp_data
          type: uni
          name: otp
          act: rcv
          package: keymgr_pkg
          inst_name: keymgr
          index: -1
        }
        {
          struct: flash_key
          type: uni
          name: flash
          act: rcv
          package: keymgr_pkg
          inst_name: keymgr
          index: -1
        }
      ]
    }
    {
      name: csrng
      type: csrng
      clock_srcs:
      {
        clk_i: main
      }
      clock_group: trans
      reset_connections:
      {
        rst_ni: sys
      }
      base_addr: 0x41150000
      clock_connections:
      {
        clk_i: clkmgr_aon_clocks.clk_main_csrng
      }
      size: 0x1000
      bus_device: tlul
      bus_host: none
      available_input_list: []
      available_output_list: []
      available_inout_list: []
      interrupt_list:
      [
        {
          name: cs_cmd_req_done
          width: 1
          bits: "0"
          bitinfo:
          [
            1
            1
            0
          ]
          type: interrupt
        }
        {
          name: cs_fifo_err
          width: 1
          bits: "1"
          bitinfo:
          [
            2
            1
            1
          ]
          type: interrupt
        }
      ]
      alert_list: []
      wakeup_list: []
      scan: "false"
      inter_signal_list:
      [
        {
          struct: csrng
          type: req_rsp
          name: csrng_cmd
          act: rsp
          width: 3
          package: csrng_pkg
          inst_name: csrng
          top_signame: csrng_csrng_cmd
          index: -1
        }
        {
          struct: entropy_src_hw_if
          type: req_rsp
          name: entropy_src_hw_if
          act: req
          width: 1
          package: entropy_src_pkg
          inst_name: csrng
          top_signame: csrng_entropy_src_hw_if
          index: -1
        }
        {
          struct: logic
          type: uni
          name: efuse_sw_app_enable
          act: rcv
          width: 1
          package: ""
          inst_name: csrng
          index: -1
        }
      ]
    }
    {
      name: entropy_src
      type: entropy_src
      clock_srcs:
      {
        clk_i: main
      }
      clock_group: trans
      reset_connections:
      {
        rst_ni: sys
      }
      base_addr: 0x41160000
      clock_connections:
      {
        clk_i: clkmgr_aon_clocks.clk_main_entropy_src
      }
      size: 0x1000
      bus_device: tlul
      bus_host: none
      available_input_list: []
      available_output_list: []
      available_inout_list: []
      interrupt_list:
      [
        {
          name: es_entropy_valid
          width: 1
          bits: "0"
          bitinfo:
          [
            1
            1
            0
          ]
          type: interrupt
        }
        {
          name: es_rct_failed
          width: 1
          bits: "1"
          bitinfo:
          [
            2
            1
            1
          ]
          type: interrupt
        }
        {
          name: es_apt_failed
          width: 1
          bits: "2"
          bitinfo:
          [
            4
            1
            2
          ]
          type: interrupt
        }
        {
          name: es_fifo_err
          width: 1
          bits: "3"
          bitinfo:
          [
            8
            1
            3
          ]
          type: interrupt
        }
      ]
      alert_list: []
      wakeup_list: []
      scan: "false"
      inter_signal_list:
      [
        {
          struct: entropy_src_hw_if
          type: req_rsp
          name: entropy_src_hw_if
          act: rsp
          package: entropy_src_pkg
          inst_name: entropy_src
          width: 1
          top_signame: csrng_entropy_src_hw_if
          index: -1
        }
        {
          struct: entropy_src_rng
          type: req_rsp
          name: entropy_src_rng
          act: req
          package: entropy_src_pkg
          inst_name: entropy_src
          width: 1
          top_signame: entropy_src_entropy_src_rng
          index: -1
        }
        {
          struct: logic
          type: uni
          name: efuse_es_sw_reg_en
          width: 1
          act: rcv
          package: ""
          inst_name: entropy_src
          index: -1
        }
      ]
    }
    {
      name: otbn
      type: otbn
      clock_srcs:
      {
        clk_i: main
      }
      clock_group: trans
      reset_connections:
      {
        rst_ni: sys
      }
      base_addr: 0x50000000
      clock_connections:
      {
        clk_i: clkmgr_aon_clocks.clk_main_otbn
      }
      size: 0x400000
      bus_device: tlul
      bus_host: none
      available_input_list: []
      available_output_list: []
      available_inout_list: []
      interrupt_list:
      [
        {
          name: done
          width: 1
          bits: "0"
          bitinfo:
          [
            1
            1
            0
          ]
          type: interrupt
        }
        {
          name: err
          width: 1
          bits: "1"
          bitinfo:
          [
            2
            1
            1
          ]
          type: interrupt
        }
      ]
      alert_list:
      [
        {
          name: imem_uncorrectable
          width: 1
          type: alert
          async: 0
        }
        {
          name: dmem_uncorrectable
          width: 1
          type: alert
          async: 0
        }
        {
          name: reg_uncorrectable
          width: 1
          type: alert
          async: 0
        }
      ]
      wakeup_list: []
      scan: "false"
      inter_signal_list:
      [
        {
          name: idle
          type: uni
          struct: logic
          width: "1"
          act: req
          inst_name: otbn
          index: -1
        }
      ]
    }
  ]
  memory:
  [
    {
      name: rom
      clock_srcs:
      {
        clk_i: main
      }
      clock_group: infra
      reset_connections:
      {
        rst_ni: sys
      }
      type: rom
      base_addr: 0x00008000
      swaccess: ro
      size: 0x4000
      clock_connections:
      {
        clk_i: clkmgr_aon_clocks.clk_main_infra
      }
    }
    {
      name: ram_main
      clock_srcs:
      {
        clk_i: main
      }
      clock_group: infra
      reset_connections:
      {
        rst_ni: sys
      }
      type: ram_1p
      base_addr: 0x10000000
      size: 0x10000
      clock_connections:
      {
        clk_i: clkmgr_aon_clocks.clk_main_infra
      }
    }
    {
      name: ram_ret_aon
      clock_srcs:
      {
        clk_i: io
      }
      clock_group: infra
      reset_connections:
      {
        rst_ni: sys_io
      }
      type: ram_1p
      base_addr: 0x40510000
      size: 0x1000
      clock_connections:
      {
        clk_i: clkmgr_aon_clocks.clk_io_infra
      }
    }
    {
      name: eflash
      clock_srcs:
      {
        clk_i: main
      }
      clock_group: infra
      reset_connections:
      {
        rst_ni: lc
      }
      type: eflash
      base_addr: 0x20000000
      swaccess: ro
      size: 0x80000
      inter_signal_list:
      [
        {
          struct: flash
          type: req_rsp
          name: flash_ctrl
          act: rsp
          inst_name: eflash
          width: 1
          package: flash_ctrl_pkg
          top_signame: flash_ctrl_flash
          index: -1
        }
      ]
      clock_connections:
      {
        clk_i: clkmgr_aon_clocks.clk_main_infra
      }
    }
  ]
  inter_module:
  {
    connect:
    {
      flash_ctrl.flash:
      [
        eflash.flash_ctrl
      ]
      otp_ctrl.otp_flash_key:
      [
        flash_ctrl.otp
      ]
      otp_ctrl.otp_sram_key: []
      pwrmgr_aon.pwr_otp:
      [
        otp_ctrl.pwr_otp_init
      ]
      pwrmgr_aon.pwr_rst:
      [
        rstmgr_aon.pwr
      ]
      pwrmgr_aon.pwr_clk:
      [
        clkmgr_aon.pwr
      ]
      csrng.entropy_src_hw_if:
      [
        entropy_src.entropy_src_hw_if
      ]
      keymgr.kmac_key:
      [
        kmac.keymgr_key
      ]
      keymgr.kmac_data:
      [
        kmac.keymgr_data
      ]
      pwrmgr_aon.wakeups:
      [
        pinmux_aon.aon_wkup_req
      ]
    }
    top:
    [
      rstmgr_aon.resets
      rstmgr_aon.cpu
      pwrmgr_aon.pwr_cpu
      clkmgr_aon.clocks
      csrng.csrng_cmd
    ]
    external:
    [
      sensor_ctrl.ast_host
      sensor_ctrl.ast_dev
      sensor_ctrl.ast_status
      sensor_ctrl.ast_alert
      sensor_ctrl.ast_aux
      pwrmgr_aon.pwr_ast
      rstmgr_aon.ast
      usbdev_aon.usb_ref_pulse
      usbdev_aon.usb_ref_val
      entropy_src.entropy_src_rng
    ]
  }
  xbar:
  [
    {
      name: main
      clock_srcs:
      {
        clk_main_i: main
        clk_fixed_i: io
      }
      clock_group: infra
      reset: rst_main_ni
      reset_connections:
      {
        rst_main_ni: sys
        rst_fixed_ni: sys_io
      }
      clock_connections:
      {
        clk_main_i: clkmgr_aon_clocks.clk_main_infra
        clk_fixed_i: clkmgr_aon_clocks.clk_io_infra
      }
      connections:
      {
        corei:
        [
          rom
          debug_mem
          ram_main
          eflash
        ]
        cored:
        [
          rom
          debug_mem
          ram_main
          eflash
          peri
          aon
          flash_ctrl
          aes
          hmac
          kmac
          rv_plic
          alert_handler
          nmi_gen
          keymgr
          csrng
          entropy_src
          otbn
        ]
        dm_sba:
        [
          rom
          ram_main
          eflash
          peri
          aon
          flash_ctrl
          aes
          hmac
          kmac
          rv_plic
          alert_handler
          nmi_gen
          csrng
          entropy_src
          otbn
        ]
      }
      nodes:
      [
        {
          name: corei
          type: host
          clock: clk_main_i
          reset: rst_main_ni
          pipeline: "true"
          pipeline_byp: "false"
          xbar: false
          inst_type: rv_core_ibex
        }
        {
          name: cored
          type: host
          clock: clk_main_i
          reset: rst_main_ni
          pipeline: "true"
          pipeline_byp: "false"
          xbar: false
          inst_type: rv_core_ibex
        }
        {
          name: dm_sba
          type: host
          clock: clk_main_i
          reset: rst_main_ni
          pipeline: "false"
          xbar: false
          inst_type: rv_dm
          pipeline_byp: "true"
        }
        {
          name: rom
          type: device
          clock: clk_main_i
          reset: rst_main_ni
          pipeline: "false"
          inst_type: rom
          addr_range:
          [
            {
              base_addr: 0x00008000
              size_byte: 0x4000
            }
          ]
          xbar: false
          pipeline_byp: "true"
        }
        {
          name: debug_mem
          type: device
          clock: clk_main_i
          reset: rst_main_ni
          pipeline_byp: "false"
          inst_type: rv_dm
          addr_range:
          [
            {
              base_addr: 0x1A110000
              size_byte: 0x1000
            }
          ]
          xbar: false
          pipeline: "true"
        }
        {
          name: ram_main
          type: device
          clock: clk_main_i
          reset: rst_main_ni
          pipeline: "false"
          inst_type: ram_1p
          addr_range:
          [
            {
              base_addr: 0x10000000
              size_byte: 0x10000
            }
          ]
          xbar: false
          pipeline_byp: "true"
        }
        {
          name: eflash
          type: device
          clock: clk_main_i
          reset: rst_main_ni
          pipeline: "false"
          inst_type: eflash
          addr_range:
          [
            {
              base_addr: 0x20000000
              size_byte: 0x80000
            }
          ]
          xbar: false
          pipeline_byp: "true"
        }
        {
          name: peri
          type: device
          clock: clk_fixed_i
          reset: rst_fixed_ni
          pipeline_byp: "false"
          xbar: true
          pipeline: "true"
          addr_range:
          [
            {
              base_addr: 0x40000000
              size_byte: 0x1000
            }
            {
              base_addr: 0x40010000
              size_byte: 0x1000
            }
            {
              base_addr: 0x40020000
              size_byte: 0x1000
            }
            {
              base_addr: 0x40030000
              size_byte: 0x1000
            }
            {
              base_addr: 0x40040000
              size_byte: 0x1000
            }
            {
              base_addr: 0x40050000
              size_byte: 0x1000
            }
            {
              base_addr: 0x40100000
              size_byte: 0x1000
            }
            {
              base_addr: 0x40080000
              size_byte: 0x1000
            }
            {
              base_addr: 0x40090000
              size_byte: 0x1000
            }
            {
              base_addr: 0x400A0000
              size_byte: 0x1000
            }
            {
              base_addr: 0x400E0000
              size_byte: 0x1000
            }
            {
              base_addr: 0x40110000
              size_byte: 0x20000
            }
            {
              base_addr: 0x40130000
              size_byte: 0x1000
            }
          ]
        }
        {
          name: aon
          type: device
          clock: clk_fixed_i
          reset: rst_fixed_ni
          pipeline_byp: "false"
          xbar: true
          pipeline: "true"
          addr_range:
          [
            {
              base_addr: 0x40400000
              size_byte: 0x1000
            }
            {
              base_addr: 0x40410000
              size_byte: 0x1000
            }
            {
              base_addr: 0x40420000
              size_byte: 0x1000
            }
            {
              base_addr: 0x40430000
              size_byte: 0x1000
            }
            {
              base_addr: 0x40460000
              size_byte: 0x1000
            }
            {
              base_addr: 0x40470000
              size_byte: 0x1000
            }
            {
              base_addr: 0x40500000
              size_byte: 0x1000
            }
            {
              base_addr: 0x40510000
              size_byte: 0x1000
            }
          ]
        }
        {
          name: flash_ctrl
          type: device
          clock: clk_main_i
          reset: rst_main_ni
          pipeline_byp: "false"
          inst_type: flash_ctrl
          addr_range:
          [
            {
              base_addr: 0x41000000
              size_byte: 0x1000
            }
          ]
          xbar: false
          pipeline: "true"
        }
        {
          name: hmac
          type: device
          clock: clk_main_i
          reset: rst_main_ni
          pipeline: "false"
          inst_type: hmac
          addr_range:
          [
            {
              base_addr: 0x41110000
              size_byte: 0x1000
            }
          ]
          xbar: false
          pipeline_byp: "true"
        }
        {
          name: kmac
          type: device
          clock: clk_main_i
          reset: rst_main_ni
          pipeline: "false"
          inst_type: kmac
          addr_range:
          [
            {
              base_addr: 0x41120000
              size_byte: 0x1000
            }
          ]
          xbar: false
          pipeline_byp: "true"
        }
        {
          name: aes
          type: device
          clock: clk_main_i
          reset: rst_main_ni
          pipeline: "false"
          inst_type: aes
          addr_range:
          [
            {
              base_addr: 0x41100000
              size_byte: 0x1000
            }
          ]
          xbar: false
          pipeline_byp: "true"
        }
        {
          name: keymgr
          type: device
          clock: clk_main_i
          reset: rst_main_ni
          pipeline: "false"
          inst_type: keymgr
          addr_range:
          [
            {
              base_addr: 0x41130000
              size_byte: 0x1000
            }
          ]
          xbar: false
          pipeline_byp: "true"
        }
        {
          name: rv_plic
          type: device
          clock: clk_main_i
          reset: rst_main_ni
          inst_type: rv_plic
          addr_range:
          [
            {
              base_addr: 0x41010000
              size_byte: 0x1000
            }
          ]
          pipeline: "false"
          xbar: false
          pipeline_byp: "true"
        }
        {
          name: alert_handler
          type: device
          clock: clk_main_i
          inst_type: alert_handler
          pipeline: "false"
          addr_range:
          [
            {
              base_addr: 0x41170000
              size_byte: 0x1000
            }
          ]
          xbar: false
          pipeline_byp: "true"
        }
        {
          name: csrng
          type: device
          clock: clk_main_i
          inst_type: csrng
          pipeline: "false"
          addr_range:
          [
            {
              base_addr: 0x41150000
              size_byte: 0x1000
            }
          ]
          xbar: false
          pipeline_byp: "true"
        }
        {
          name: entropy_src
          type: device
          clock: clk_main_i
          inst_type: entropy_src
          pipeline: "false"
          addr_range:
          [
            {
              base_addr: 0x41160000
              size_byte: 0x1000
            }
          ]
          xbar: false
          pipeline_byp: "true"
        }
        {
          name: nmi_gen
          type: device
          clock: clk_main_i
          inst_type: nmi_gen
          pipeline: "false"
          addr_range:
          [
            {
              base_addr: 0x41180000
              size_byte: 0x1000
            }
          ]
          xbar: false
          pipeline_byp: "true"
        }
        {
          name: otbn
          type: device
          clock: clk_main_i
          reset: rst_main_ni
          pipeline_byp: "false"
          inst_type: otbn
          addr_range:
          [
            {
              base_addr: 0x50000000
              size_byte: 0x400000
            }
          ]
          xbar: false
          pipeline: "true"
        }
      ]
      clock: clk_main_i
    }
    {
      name: peri
      clock_srcs:
      {
        clk_peri_i: io
      }
      clock_group: infra
      reset: rst_peri_ni
      reset_connections:
      {
        rst_peri_ni: sys_io
      }
      clock_connections:
      {
        clk_peri_i: clkmgr_aon_clocks.clk_io_infra
      }
      connections:
      {
        main:
        [
          uart
          uart1
          uart2
          uart3
          gpio
          spi_device
          rv_timer
          i2c0
          i2c1
          i2c2
          pattgen
          sensor_ctrl
          otp_ctrl
        ]
      }
      nodes:
      [
        {
          name: main
          type: host
          clock: clk_peri_i
          reset: rst_peri_ni
          xbar: true
          pipeline: "false"
          inst_type: ""
          pipeline_byp: "true"
        }
        {
          name: uart
          type: device
          clock: clk_peri_i
          reset: rst_peri_ni
          pipeline: "false"
          inst_type: uart
          addr_range:
          [
            {
              base_addr: 0x40000000
              size_byte: 0x1000
            }
          ]
          xbar: false
          pipeline_byp: "true"
        }
        {
          name: uart1
          type: device
          clock: clk_peri_i
          reset: rst_peri_ni
          pipeline: "false"
          inst_type: uart
          addr_range:
          [
            {
              base_addr: 0x40010000
              size_byte: 0x1000
            }
          ]
          xbar: false
          pipeline_byp: "true"
        }
        {
          name: uart2
          type: device
          clock: clk_peri_i
          reset: rst_peri_ni
          pipeline: "false"
          inst_type: uart
          addr_range:
          [
            {
              base_addr: 0x40020000
              size_byte: 0x1000
            }
          ]
          xbar: false
          pipeline_byp: "true"
        }
        {
          name: uart3
          type: device
          clock: clk_peri_i
          reset: rst_peri_ni
          pipeline: "false"
          inst_type: uart
          addr_range:
          [
            {
              base_addr: 0x40030000
              size_byte: 0x1000
            }
          ]
          xbar: false
          pipeline_byp: "true"
        }
        {
          name: gpio
          type: device
          clock: clk_peri_i
          reset: rst_peri_ni
          pipeline: "false"
          inst_type: gpio
          addr_range:
          [
            {
              base_addr: 0x40040000
              size_byte: 0x1000
            }
          ]
          xbar: false
          pipeline_byp: "true"
        }
        {
          name: spi_device
          type: device
          clock: clk_peri_i
          reset: rst_peri_ni
          pipeline: "false"
          inst_type: spi_device
          addr_range:
          [
            {
              base_addr: 0x40050000
              size_byte: 0x1000
            }
          ]
          xbar: false
          pipeline_byp: "true"
        }
        {
          name: rv_timer
          type: device
          clock: clk_peri_i
          reset: rst_peri_ni
          pipeline: "false"
          inst_type: rv_timer
          addr_range:
          [
            {
              base_addr: 0x40100000
              size_byte: 0x1000
            }
          ]
          xbar: false
          pipeline_byp: "true"
        }
        {
          name: i2c0
          type: device
          clock: clk_peri_i
          reset: rst_peri_ni
          pipeline: "false"
          inst_type: i2c
          addr_range:
          [
            {
              base_addr: 0x40080000
              size_byte: 0x1000
            }
          ]
          xbar: false
          pipeline_byp: "true"
        }
        {
          name: i2c1
          type: device
          clock: clk_peri_i
          reset: rst_peri_ni
          pipeline: "false"
          inst_type: i2c
          addr_range:
          [
            {
              base_addr: 0x40090000
              size_byte: 0x1000
            }
          ]
          xbar: false
          pipeline_byp: "true"
        }
        {
          name: i2c2
          type: device
          clock: clk_peri_i
          reset: rst_peri_ni
          pipeline: "false"
          inst_type: i2c
          addr_range:
          [
            {
              base_addr: 0x400A0000
              size_byte: 0x1000
            }
          ]
          xbar: false
          pipeline_byp: "true"
        }
        {
          name: pattgen
          type: device
          clock: clk_peri_i
          reset: rst_peri_ni
          pipeline: "false"
          inst_type: pattgen
          addr_range:
          [
            {
              base_addr: 0x400E0000
              size_byte: 0x1000
            }
          ]
          xbar: false
          pipeline_byp: "true"
        }
        {
          name: sensor_ctrl
          type: device
          clock: clk_peri_i
          reset: rst_peri_ni
          pipeline: "false"
          inst_type: sensor_ctrl
          addr_range:
          [
            {
              base_addr: 0x40110000
              size_byte: 0x20000
            }
          ]
          xbar: false
          pipeline_byp: "true"
        }
        {
          name: otp_ctrl
          type: device
          clock: clk_peri_i
          reset: rst_peri_ni
          pipeline: "false"
          inst_type: otp_ctrl
          addr_range:
          [
            {
              base_addr: 0x40130000
              size_byte: 0x1000
            }
          ]
          xbar: false
          pipeline_byp: "true"
        }
      ]
      clock: clk_peri_i
    }
    {
      name: aon
      clock_srcs:
      {
        clk_aon_i: io
      }
      clock_group: infra
      reset: rst_aon_ni
      reset_connections:
      {
        rst_aon_ni: sys_io
      }
      clock_connections:
      {
        clk_aon_i: clkmgr_aon_clocks.clk_io_infra
      }
      connections:
      {
        main:
        [
          pwrmgr_aon
          rstmgr_aon
          clkmgr_aon
          pinmux_aon
          padctrl_aon
          usbdev_aon
          rbox_aon
          ram_ret_aon
        ]
      }
      nodes:
      [
        {
          name: main
          type: host
          clock: clk_aon_i
          reset: rst_aon_ni
          xbar: true
          pipeline: "false"
          inst_type: ""
          pipeline_byp: "true"
        }
        {
          name: pwrmgr_aon
          type: device
          clock: clk_aon_i
          reset: rst_aon_ni
          pipeline: "false"
          inst_type: pwrmgr
          addr_range:
          [
            {
              base_addr: 0x40400000
              size_byte: 0x1000
            }
          ]
          xbar: false
          pipeline_byp: "true"
        }
        {
          name: rstmgr_aon
          type: device
          clock: clk_aon_i
          reset: rst_aon_ni
          pipeline: "false"
          inst_type: rstmgr
          addr_range:
          [
            {
              base_addr: 0x40410000
              size_byte: 0x1000
            }
          ]
          xbar: false
          pipeline_byp: "true"
        }
        {
          name: clkmgr_aon
          type: device
          clock: clk_aon_i
          reset: rst_aon_ni
          pipeline: "false"
          inst_type: clkmgr
          addr_range:
          [
            {
              base_addr: 0x40420000
              size_byte: 0x1000
            }
          ]
          xbar: false
          pipeline_byp: "true"
        }
        {
          name: rbox_aon
          type: device
          clock: clk_aon_i
          reset: rst_aon_ni
          pipeline: "false"
          inst_type: rbox
          addr_range:
          [
            {
              base_addr: 0x40430000
              size_byte: 0x1000
            }
          ]
          xbar: false
          pipeline_byp: "true"
        }
        {
          name: pinmux_aon
          type: device
          inst_type: pinmux
          clock: clk_aon_i
          reset: rst_aon_ni
          pipeline: "false"
          addr_range:
          [
            {
              base_addr: 0x40460000
              size_byte: 0x1000
            }
          ]
          xbar: false
          pipeline_byp: "true"
        }
        {
          name: padctrl_aon
          type: device
          clock: clk_aon_i
          reset: rst_aon_ni
          inst_type: padctrl
          pipeline: "false"
          addr_range:
          [
            {
              base_addr: 0x40470000
              size_byte: 0x1000
            }
          ]
          xbar: false
          pipeline_byp: "true"
        }
        {
          name: usbdev_aon
          type: device
          clock: clk_aon_i
          reset: rst_aon_ni
          pipeline: "false"
          inst_type: usbdev
          addr_range:
          [
            {
              base_addr: 0x40500000
              size_byte: 0x1000
            }
          ]
          xbar: false
          pipeline_byp: "true"
        }
        {
          name: ram_ret_aon
          type: device
          clock: clk_aon_i
          reset: rst_aon_ni
          pipeline_byp: "true"
          inst_type: ram_1p
          addr_range:
          [
            {
              base_addr: 0x40510000
              size_byte: 0x1000
            }
          ]
          xbar: false
          pipeline: "true"
        }
      ]
      clock: clk_aon_i
    }
  ]
  interrupt_module:
  [
    gpio
    uart
    spi_device
    flash_ctrl
    keymgr
    hmac
    kmac
    alert_handler
    nmi_gen
    usbdev_aon
    pwrmgr_aon
    otp_ctrl
    uart1
    uart2
    uart3
    i2c0
    i2c1
    i2c2
    otbn
  ]
  interrupt:
  [
    {
      name: gpio_gpio
      width: 32
      bits: 31:0
      bitinfo:
      [
        4294967295
        32
        0
      ]
      type: interrupt
      module_name: gpio
    }
    {
      name: uart_tx_watermark
      width: 1
      bits: "0"
      bitinfo:
      [
        1
        1
        0
      ]
      type: interrupt
      module_name: uart
    }
    {
      name: uart_rx_watermark
      width: 1
      bits: "1"
      bitinfo:
      [
        2
        1
        1
      ]
      type: interrupt
      module_name: uart
    }
    {
      name: uart_tx_empty
      width: 1
      bits: "2"
      bitinfo:
      [
        4
        1
        2
      ]
      type: interrupt
      module_name: uart
    }
    {
      name: uart_rx_overflow
      width: 1
      bits: "3"
      bitinfo:
      [
        8
        1
        3
      ]
      type: interrupt
      module_name: uart
    }
    {
      name: uart_rx_frame_err
      width: 1
      bits: "4"
      bitinfo:
      [
        16
        1
        4
      ]
      type: interrupt
      module_name: uart
    }
    {
      name: uart_rx_break_err
      width: 1
      bits: "5"
      bitinfo:
      [
        32
        1
        5
      ]
      type: interrupt
      module_name: uart
    }
    {
      name: uart_rx_timeout
      width: 1
      bits: "6"
      bitinfo:
      [
        64
        1
        6
      ]
      type: interrupt
      module_name: uart
    }
    {
      name: uart_rx_parity_err
      width: 1
      bits: "7"
      bitinfo:
      [
        128
        1
        7
      ]
      type: interrupt
      module_name: uart
    }
    {
      name: spi_device_rxf
      width: 1
      bits: "0"
      bitinfo:
      [
        1
        1
        0
      ]
      type: interrupt
      module_name: spi_device
    }
    {
      name: spi_device_rxlvl
      width: 1
      bits: "1"
      bitinfo:
      [
        2
        1
        1
      ]
      type: interrupt
      module_name: spi_device
    }
    {
      name: spi_device_txlvl
      width: 1
      bits: "2"
      bitinfo:
      [
        4
        1
        2
      ]
      type: interrupt
      module_name: spi_device
    }
    {
      name: spi_device_rxerr
      width: 1
      bits: "3"
      bitinfo:
      [
        8
        1
        3
      ]
      type: interrupt
      module_name: spi_device
    }
    {
      name: spi_device_rxoverflow
      width: 1
      bits: "4"
      bitinfo:
      [
        16
        1
        4
      ]
      type: interrupt
      module_name: spi_device
    }
    {
      name: spi_device_txunderflow
      width: 1
      bits: "5"
      bitinfo:
      [
        32
        1
        5
      ]
      type: interrupt
      module_name: spi_device
    }
    {
      name: flash_ctrl_prog_empty
      width: 1
      bits: "0"
      bitinfo:
      [
        1
        1
        0
      ]
      type: interrupt
      module_name: flash_ctrl
    }
    {
      name: flash_ctrl_prog_lvl
      width: 1
      bits: "1"
      bitinfo:
      [
        2
        1
        1
      ]
      type: interrupt
      module_name: flash_ctrl
    }
    {
      name: flash_ctrl_rd_full
      width: 1
      bits: "2"
      bitinfo:
      [
        4
        1
        2
      ]
      type: interrupt
      module_name: flash_ctrl
    }
    {
      name: flash_ctrl_rd_lvl
      width: 1
      bits: "3"
      bitinfo:
      [
        8
        1
        3
      ]
      type: interrupt
      module_name: flash_ctrl
    }
    {
      name: flash_ctrl_op_done
      width: 1
      bits: "4"
      bitinfo:
      [
        16
        1
        4
      ]
      type: interrupt
      module_name: flash_ctrl
    }
    {
      name: flash_ctrl_op_error
      width: 1
      bits: "5"
      bitinfo:
      [
        32
        1
        5
      ]
      type: interrupt
      module_name: flash_ctrl
    }
    {
      name: keymgr_op_done
      width: 1
      bits: "0"
      bitinfo:
      [
        1
        1
        0
      ]
      type: interrupt
      module_name: keymgr
    }
    {
      name: hmac_hmac_done
      width: 1
      bits: "0"
      bitinfo:
      [
        1
        1
        0
      ]
      type: interrupt
      module_name: hmac
    }
    {
      name: hmac_fifo_empty
      width: 1
      bits: "1"
      bitinfo:
      [
        2
        1
        1
      ]
      type: interrupt
      module_name: hmac
    }
    {
      name: hmac_hmac_err
      width: 1
      bits: "2"
      bitinfo:
      [
        4
        1
        2
      ]
      type: interrupt
      module_name: hmac
    }
    {
      name: kmac_kmac_done
      width: 1
      bits: "0"
      bitinfo:
      [
        1
        1
        0
      ]
      type: interrupt
      module_name: kmac
    }
    {
      name: kmac_fifo_empty
      width: 1
      bits: "1"
      bitinfo:
      [
        2
        1
        1
      ]
      type: interrupt
      module_name: kmac
    }
    {
      name: kmac_kmac_err
      width: 1
      bits: "2"
      bitinfo:
      [
        4
        1
        2
      ]
      type: interrupt
      module_name: kmac
    }
    {
      name: alert_handler_classa
      width: 1
      bits: "0"
      bitinfo:
      [
        1
        1
        0
      ]
      type: interrupt
      module_name: alert_handler
    }
    {
      name: alert_handler_classb
      width: 1
      bits: "1"
      bitinfo:
      [
        2
        1
        1
      ]
      type: interrupt
      module_name: alert_handler
    }
    {
      name: alert_handler_classc
      width: 1
      bits: "2"
      bitinfo:
      [
        4
        1
        2
      ]
      type: interrupt
      module_name: alert_handler
    }
    {
      name: alert_handler_classd
      width: 1
      bits: "3"
      bitinfo:
      [
        8
        1
        3
      ]
      type: interrupt
      module_name: alert_handler
    }
    {
      name: nmi_gen_esc0
      width: 1
      bits: "0"
      bitinfo:
      [
        1
        1
        0
      ]
      type: interrupt
      module_name: nmi_gen
    }
    {
      name: nmi_gen_esc1
      width: 1
      bits: "1"
      bitinfo:
      [
        2
        1
        1
      ]
      type: interrupt
      module_name: nmi_gen
    }
    {
      name: nmi_gen_esc2
      width: 1
      bits: "2"
      bitinfo:
      [
        4
        1
        2
      ]
      type: interrupt
      module_name: nmi_gen
    }
    {
      name: nmi_gen_esc3
      width: 1
      bits: "3"
      bitinfo:
      [
        8
        1
        3
      ]
      type: interrupt
      module_name: nmi_gen
    }
    {
      name: usbdev_aon_pkt_received
      width: 1
      bits: "0"
      bitinfo:
      [
        1
        1
        0
      ]
      type: interrupt
      module_name: usbdev_aon
    }
    {
      name: usbdev_aon_pkt_sent
      width: 1
      bits: "1"
      bitinfo:
      [
        2
        1
        1
      ]
      type: interrupt
      module_name: usbdev_aon
    }
    {
      name: usbdev_aon_disconnected
      width: 1
      bits: "2"
      bitinfo:
      [
        4
        1
        2
      ]
      type: interrupt
      module_name: usbdev_aon
    }
    {
      name: usbdev_aon_host_lost
      width: 1
      bits: "3"
      bitinfo:
      [
        8
        1
        3
      ]
      type: interrupt
      module_name: usbdev_aon
    }
    {
      name: usbdev_aon_link_reset
      width: 1
      bits: "4"
      bitinfo:
      [
        16
        1
        4
      ]
      type: interrupt
      module_name: usbdev_aon
    }
    {
      name: usbdev_aon_link_suspend
      width: 1
      bits: "5"
      bitinfo:
      [
        32
        1
        5
      ]
      type: interrupt
      module_name: usbdev_aon
    }
    {
      name: usbdev_aon_link_resume
      width: 1
      bits: "6"
      bitinfo:
      [
        64
        1
        6
      ]
      type: interrupt
      module_name: usbdev_aon
    }
    {
      name: usbdev_aon_av_empty
      width: 1
      bits: "7"
      bitinfo:
      [
        128
        1
        7
      ]
      type: interrupt
      module_name: usbdev_aon
    }
    {
      name: usbdev_aon_rx_full
      width: 1
      bits: "8"
      bitinfo:
      [
        256
        1
        8
      ]
      type: interrupt
      module_name: usbdev_aon
    }
    {
      name: usbdev_aon_av_overflow
      width: 1
      bits: "9"
      bitinfo:
      [
        512
        1
        9
      ]
      type: interrupt
      module_name: usbdev_aon
    }
    {
      name: usbdev_aon_link_in_err
      width: 1
      bits: "10"
      bitinfo:
      [
        1024
        1
        10
      ]
      type: interrupt
      module_name: usbdev_aon
    }
    {
      name: usbdev_aon_rx_crc_err
      width: 1
      bits: "11"
      bitinfo:
      [
        2048
        1
        11
      ]
      type: interrupt
      module_name: usbdev_aon
    }
    {
      name: usbdev_aon_rx_pid_err
      width: 1
      bits: "12"
      bitinfo:
      [
        4096
        1
        12
      ]
      type: interrupt
      module_name: usbdev_aon
    }
    {
      name: usbdev_aon_rx_bitstuff_err
      width: 1
      bits: "13"
      bitinfo:
      [
        8192
        1
        13
      ]
      type: interrupt
      module_name: usbdev_aon
    }
    {
      name: usbdev_aon_frame
      width: 1
      bits: "14"
      bitinfo:
      [
        16384
        1
        14
      ]
      type: interrupt
      module_name: usbdev_aon
    }
    {
      name: usbdev_aon_connected
      width: 1
      bits: "15"
      bitinfo:
      [
        32768
        1
        15
      ]
      type: interrupt
      module_name: usbdev_aon
    }
    {
      name: pwrmgr_aon_wakeup
      width: 1
      bits: "0"
      bitinfo:
      [
        1
        1
        0
      ]
      type: interrupt
      module_name: pwrmgr_aon
    }
    {
      name: otp_ctrl_otp_access_done
      width: 1
      bits: "0"
      bitinfo:
      [
        1
        1
        0
      ]
      type: interrupt
      module_name: otp_ctrl
    }
    {
      name: otp_ctrl_otp_ctrl_err
      width: 1
      bits: "1"
      bitinfo:
      [
        2
        1
        1
      ]
      type: interrupt
      module_name: otp_ctrl
    }
    {
      name: uart1_tx_watermark
      width: 1
      bits: "0"
      bitinfo:
      [
        1
        1
        0
      ]
      type: interrupt
      module_name: uart1
    }
    {
      name: uart1_rx_watermark
      width: 1
      bits: "1"
      bitinfo:
      [
        2
        1
        1
      ]
      type: interrupt
      module_name: uart1
    }
    {
      name: uart1_tx_empty
      width: 1
      bits: "2"
      bitinfo:
      [
        4
        1
        2
      ]
      type: interrupt
      module_name: uart1
    }
    {
      name: uart1_rx_overflow
      width: 1
      bits: "3"
      bitinfo:
      [
        8
        1
        3
      ]
      type: interrupt
      module_name: uart1
    }
    {
      name: uart1_rx_frame_err
      width: 1
      bits: "4"
      bitinfo:
      [
        16
        1
        4
      ]
      type: interrupt
      module_name: uart1
    }
    {
      name: uart1_rx_break_err
      width: 1
      bits: "5"
      bitinfo:
      [
        32
        1
        5
      ]
      type: interrupt
      module_name: uart1
    }
    {
      name: uart1_rx_timeout
      width: 1
      bits: "6"
      bitinfo:
      [
        64
        1
        6
      ]
      type: interrupt
      module_name: uart1
    }
    {
      name: uart1_rx_parity_err
      width: 1
      bits: "7"
      bitinfo:
      [
        128
        1
        7
      ]
      type: interrupt
      module_name: uart1
    }
    {
      name: uart2_tx_watermark
      width: 1
      bits: "0"
      bitinfo:
      [
        1
        1
        0
      ]
      type: interrupt
      module_name: uart2
    }
    {
      name: uart2_rx_watermark
      width: 1
      bits: "1"
      bitinfo:
      [
        2
        1
        1
      ]
      type: interrupt
      module_name: uart2
    }
    {
      name: uart2_tx_empty
      width: 1
      bits: "2"
      bitinfo:
      [
        4
        1
        2
      ]
      type: interrupt
      module_name: uart2
    }
    {
      name: uart2_rx_overflow
      width: 1
      bits: "3"
      bitinfo:
      [
        8
        1
        3
      ]
      type: interrupt
      module_name: uart2
    }
    {
      name: uart2_rx_frame_err
      width: 1
      bits: "4"
      bitinfo:
      [
        16
        1
        4
      ]
      type: interrupt
      module_name: uart2
    }
    {
      name: uart2_rx_break_err
      width: 1
      bits: "5"
      bitinfo:
      [
        32
        1
        5
      ]
      type: interrupt
      module_name: uart2
    }
    {
      name: uart2_rx_timeout
      width: 1
      bits: "6"
      bitinfo:
      [
        64
        1
        6
      ]
      type: interrupt
      module_name: uart2
    }
    {
      name: uart2_rx_parity_err
      width: 1
      bits: "7"
      bitinfo:
      [
        128
        1
        7
      ]
      type: interrupt
      module_name: uart2
    }
    {
      name: uart3_tx_watermark
      width: 1
      bits: "0"
      bitinfo:
      [
        1
        1
        0
      ]
      type: interrupt
      module_name: uart3
    }
    {
      name: uart3_rx_watermark
      width: 1
      bits: "1"
      bitinfo:
      [
        2
        1
        1
      ]
      type: interrupt
      module_name: uart3
    }
    {
      name: uart3_tx_empty
      width: 1
      bits: "2"
      bitinfo:
      [
        4
        1
        2
      ]
      type: interrupt
      module_name: uart3
    }
    {
      name: uart3_rx_overflow
      width: 1
      bits: "3"
      bitinfo:
      [
        8
        1
        3
      ]
      type: interrupt
      module_name: uart3
    }
    {
      name: uart3_rx_frame_err
      width: 1
      bits: "4"
      bitinfo:
      [
        16
        1
        4
      ]
      type: interrupt
      module_name: uart3
    }
    {
      name: uart3_rx_break_err
      width: 1
      bits: "5"
      bitinfo:
      [
        32
        1
        5
      ]
      type: interrupt
      module_name: uart3
    }
    {
      name: uart3_rx_timeout
      width: 1
      bits: "6"
      bitinfo:
      [
        64
        1
        6
      ]
      type: interrupt
      module_name: uart3
    }
    {
      name: uart3_rx_parity_err
      width: 1
      bits: "7"
      bitinfo:
      [
        128
        1
        7
      ]
      type: interrupt
      module_name: uart3
    }
    {
      name: i2c0_fmt_watermark
      width: 1
      bits: "0"
      bitinfo:
      [
        1
        1
        0
      ]
      type: interrupt
      module_name: i2c0
    }
    {
      name: i2c0_rx_watermark
      width: 1
      bits: "1"
      bitinfo:
      [
        2
        1
        1
      ]
      type: interrupt
      module_name: i2c0
    }
    {
      name: i2c0_fmt_overflow
      width: 1
      bits: "2"
      bitinfo:
      [
        4
        1
        2
      ]
      type: interrupt
      module_name: i2c0
    }
    {
      name: i2c0_rx_overflow
      width: 1
      bits: "3"
      bitinfo:
      [
        8
        1
        3
      ]
      type: interrupt
      module_name: i2c0
    }
    {
      name: i2c0_nak
      width: 1
      bits: "4"
      bitinfo:
      [
        16
        1
        4
      ]
      type: interrupt
      module_name: i2c0
    }
    {
      name: i2c0_scl_interference
      width: 1
      bits: "5"
      bitinfo:
      [
        32
        1
        5
      ]
      type: interrupt
      module_name: i2c0
    }
    {
      name: i2c0_sda_interference
      width: 1
      bits: "6"
      bitinfo:
      [
        64
        1
        6
      ]
      type: interrupt
      module_name: i2c0
    }
    {
      name: i2c0_stretch_timeout
      width: 1
      bits: "7"
      bitinfo:
      [
        128
        1
        7
      ]
      type: interrupt
      module_name: i2c0
    }
    {
      name: i2c0_sda_unstable
      width: 1
      bits: "8"
      bitinfo:
      [
        256
        1
        8
      ]
      type: interrupt
      module_name: i2c0
    }
    {
      name: i2c1_fmt_watermark
      width: 1
      bits: "0"
      bitinfo:
      [
        1
        1
        0
      ]
      type: interrupt
      module_name: i2c1
    }
    {
      name: i2c1_rx_watermark
      width: 1
      bits: "1"
      bitinfo:
      [
        2
        1
        1
      ]
      type: interrupt
      module_name: i2c1
    }
    {
      name: i2c1_fmt_overflow
      width: 1
      bits: "2"
      bitinfo:
      [
        4
        1
        2
      ]
      type: interrupt
      module_name: i2c1
    }
    {
      name: i2c1_rx_overflow
      width: 1
      bits: "3"
      bitinfo:
      [
        8
        1
        3
      ]
      type: interrupt
      module_name: i2c1
    }
    {
      name: i2c1_nak
      width: 1
      bits: "4"
      bitinfo:
      [
        16
        1
        4
      ]
      type: interrupt
      module_name: i2c1
    }
    {
      name: i2c1_scl_interference
      width: 1
      bits: "5"
      bitinfo:
      [
        32
        1
        5
      ]
      type: interrupt
      module_name: i2c1
    }
    {
      name: i2c1_sda_interference
      width: 1
      bits: "6"
      bitinfo:
      [
        64
        1
        6
      ]
      type: interrupt
      module_name: i2c1
    }
    {
      name: i2c1_stretch_timeout
      width: 1
      bits: "7"
      bitinfo:
      [
        128
        1
        7
      ]
      type: interrupt
      module_name: i2c1
    }
    {
      name: i2c1_sda_unstable
      width: 1
      bits: "8"
      bitinfo:
      [
        256
        1
        8
      ]
      type: interrupt
      module_name: i2c1
    }
    {
      name: i2c2_fmt_watermark
      width: 1
      bits: "0"
      bitinfo:
      [
        1
        1
        0
      ]
      type: interrupt
      module_name: i2c2
    }
    {
      name: i2c2_rx_watermark
      width: 1
      bits: "1"
      bitinfo:
      [
        2
        1
        1
      ]
      type: interrupt
      module_name: i2c2
    }
    {
      name: i2c2_fmt_overflow
      width: 1
      bits: "2"
      bitinfo:
      [
        4
        1
        2
      ]
      type: interrupt
      module_name: i2c2
    }
    {
      name: i2c2_rx_overflow
      width: 1
      bits: "3"
      bitinfo:
      [
        8
        1
        3
      ]
      type: interrupt
      module_name: i2c2
    }
    {
      name: i2c2_nak
      width: 1
      bits: "4"
      bitinfo:
      [
        16
        1
        4
      ]
      type: interrupt
      module_name: i2c2
    }
    {
      name: i2c2_scl_interference
      width: 1
      bits: "5"
      bitinfo:
      [
        32
        1
        5
      ]
      type: interrupt
      module_name: i2c2
    }
    {
      name: i2c2_sda_interference
      width: 1
      bits: "6"
      bitinfo:
      [
        64
        1
        6
      ]
      type: interrupt
      module_name: i2c2
    }
    {
      name: i2c2_stretch_timeout
      width: 1
      bits: "7"
      bitinfo:
      [
        128
        1
        7
      ]
      type: interrupt
      module_name: i2c2
    }
    {
      name: i2c2_sda_unstable
      width: 1
      bits: "8"
      bitinfo:
      [
        256
        1
        8
      ]
      type: interrupt
      module_name: i2c2
    }
    {
      name: otbn_done
      width: 1
      bits: "0"
      bitinfo:
      [
        1
        1
        0
      ]
      type: interrupt
      module_name: otbn
    }
    {
      name: otbn_err
      width: 1
      bits: "1"
      bitinfo:
      [
        2
        1
        1
      ]
      type: interrupt
      module_name: otbn
    }
  ]
  alert_module:
  [
    hmac
    kmac
    sensor_ctrl
    otp_ctrl
    otbn
  ]
  alert:
  [
    {
      name: hmac_msg_push_sha_disabled
      width: 1
      type: alert
      async: 0
      module_name: hmac
    }
    {
      name: kmac_sram_uncorrectable
      width: 1
      type: alert
      async: 0
      module_name: kmac
    }
    {
      name: kmac_data_parity
      width: 1
      type: alert
      async: 0
      module_name: kmac
    }
    {
      name: sensor_ctrl_ast_alerts
      width: 7
      type: alert
      async: 1
      module_name: sensor_ctrl
    }
    {
      name: otp_ctrl_otp_reg_parity_mismatch
      width: 1
      type: alert
      async: 1
      module_name: otp_ctrl
    }
    {
      name: otp_ctrl_otp_reg_digest_mismatch
      width: 1
      type: alert
      async: 1
      module_name: otp_ctrl
    }
    {
      name: otbn_imem_uncorrectable
      width: 1
      type: alert
      async: 0
      module_name: otbn
    }
    {
      name: otbn_dmem_uncorrectable
      width: 1
      type: alert
      async: 0
      module_name: otbn
    }
    {
      name: otbn_reg_uncorrectable
      width: 1
      type: alert
      async: 0
      module_name: otbn
    }
  ]
  pinmux:
  {
    num_mio: 32
    dio_modules:
    [
      {
        name: spi_device
        pad:
        [
          ChB[0..3]
        ]
      }
      {
        name: uart
        pad:
        [
          ChA[0..1]
        ]
      }
      {
        name: usbdev_aon
        pad:
        [
          ChC[0..8]
        ]
      }
      {
        name: rbox_aon
        pad:
        [
          ChD[0..13]
        ]
      }
    ]
    mio_modules:
    [
      uart1
      uart2
      uart3
      gpio
      i2c0
      i2c1
      i2c2
    ]
    nc_modules:
    [
      rv_timer
      hmac
    ]
    num_wkup_detect: 8
    wkup_cnt_width: 8
    dio:
    [
      {
        name: spi_device_sck
        width: 1
        type: input
        module_name: spi_device
        pad:
        [
          {
            name: ChB
            index: 0
          }
        ]
      }
      {
        name: spi_device_csb
        width: 1
        type: input
        module_name: spi_device
        pad:
        [
          {
            name: ChB
            index: 1
          }
        ]
      }
      {
        name: spi_device_mosi
        width: 1
        type: input
        module_name: spi_device
        pad:
        [
          {
            name: ChB
            index: 2
          }
        ]
      }
      {
        name: spi_device_miso
        width: 1
        type: output
        module_name: spi_device
        pad:
        [
          {
            name: ChB
            index: 3
          }
        ]
      }
      {
        name: uart_rx
        width: 1
        type: input
        module_name: uart
        pad:
        [
          {
            name: ChA
            index: 0
          }
        ]
      }
      {
        name: uart_tx
        width: 1
        type: output
        module_name: uart
        pad:
        [
          {
            name: ChA
            index: 1
          }
        ]
      }
      {
        name: usbdev_aon_sense
        width: 1
        type: input
        module_name: usbdev_aon
        pad:
        [
          {
            name: ChC
            index: 0
          }
        ]
      }
      {
        name: usbdev_aon_se0
        width: 1
        type: output
        module_name: usbdev_aon
        pad:
        [
          {
            name: ChC
            index: 1
          }
        ]
      }
      {
        name: usbdev_aon_dp_pullup
        width: 1
        type: output
        module_name: usbdev_aon
        pad:
        [
          {
            name: ChC
            index: 2
          }
        ]
      }
      {
        name: usbdev_aon_dn_pullup
        width: 1
        type: output
        module_name: usbdev_aon
        pad:
        [
          {
            name: ChC
            index: 3
          }
        ]
      }
      {
        name: usbdev_aon_tx_mode_se
        width: 1
        type: output
        module_name: usbdev_aon
        pad:
        [
          {
            name: ChC
            index: 4
          }
        ]
      }
      {
        name: usbdev_aon_suspend
        width: 1
        type: output
        module_name: usbdev_aon
        pad:
        [
          {
            name: ChC
            index: 5
          }
        ]
      }
      {
        name: usbdev_aon_d
        width: 1
        type: inout
        module_name: usbdev_aon
        pad:
        [
          {
            name: ChC
            index: 6
          }
        ]
      }
      {
        name: usbdev_aon_dp
        width: 1
        type: inout
        module_name: usbdev_aon
        pad:
        [
          {
            name: ChC
            index: 7
          }
        ]
      }
      {
        name: usbdev_aon_dn
        width: 1
        type: inout
        module_name: usbdev_aon
        pad:
        [
          {
            name: ChC
            index: 8
          }
        ]
      }
      {
        name: rbox_aon_ac_present
        width: 1
        type: input
        module_name: rbox_aon
        pad:
        [
          {
            name: ChD
            index: 0
          }
        ]
      }
      {
        name: rbox_aon_ec_entering_rw
        width: 1
        type: input
        module_name: rbox_aon
        pad:
        [
          {
            name: ChD
            index: 1
          }
        ]
      }
      {
        name: rbox_aon_key0_in
        width: 1
        type: input
        module_name: rbox_aon
        pad:
        [
          {
            name: ChD
            index: 2
          }
        ]
      }
      {
        name: rbox_aon_key1_in
        width: 1
        type: input
        module_name: rbox_aon
        pad:
        [
          {
            name: ChD
            index: 3
          }
        ]
      }
      {
        name: rbox_aon_key2_in
        width: 1
        type: input
        module_name: rbox_aon
        pad:
        [
          {
            name: ChD
            index: 4
          }
        ]
      }
      {
        name: rbox_aon_pwrb_in
        width: 1
        type: input
        module_name: rbox_aon
        pad:
        [
          {
            name: ChD
            index: 5
          }
        ]
      }
      {
        name: rbox_aon_bat_en
        width: 1
        type: output
        module_name: rbox_aon
        pad:
        [
          {
            name: ChD
            index: 6
          }
        ]
      }
      {
        name: rbox_aon_ec_in_rw
        width: 1
        type: output
        module_name: rbox_aon
        pad:
        [
          {
            name: ChD
            index: 7
          }
        ]
      }
      {
        name: rbox_aon_ec_rst_l
        width: 1
        type: output
        module_name: rbox_aon
        pad:
        [
          {
            name: ChD
            index: 8
          }
        ]
      }
      {
        name: rbox_aon_flash_wp_l
        width: 1
        type: output
        module_name: rbox_aon
        pad:
        [
          {
            name: ChD
            index: 9
          }
        ]
      }
      {
        name: rbox_aon_key0_out
        width: 1
        type: output
        module_name: rbox_aon
        pad:
        [
          {
            name: ChD
            index: 10
          }
        ]
      }
      {
        name: rbox_aon_key1_out
        width: 1
        type: output
        module_name: rbox_aon
        pad:
        [
          {
            name: ChD
            index: 11
          }
        ]
      }
      {
        name: rbox_aon_key2_out
        width: 1
        type: output
        module_name: rbox_aon
        pad:
        [
          {
            name: ChD
            index: 12
          }
        ]
      }
      {
        name: rbox_aon_pwrb_out
        width: 1
        type: output
        module_name: rbox_aon
        pad:
        [
          {
            name: ChD
            index: 13
          }
        ]
      }
    ]
    inputs:
    [
      {
        name: uart1_rx
        width: 1
        type: input
        module_name: uart1
      }
      {
        name: uart2_rx
        width: 1
        type: input
        module_name: uart2
      }
      {
        name: uart3_rx
        width: 1
        type: input
        module_name: uart3
      }
    ]
    outputs:
    [
      {
        name: uart1_tx
        width: 1
        type: output
        module_name: uart1
      }
      {
        name: uart2_tx
        width: 1
        type: output
        module_name: uart2
      }
      {
        name: uart3_tx
        width: 1
        type: output
        module_name: uart3
      }
    ]
    inouts:
    [
      {
        name: gpio_gpio
        width: 32
        type: inout
        module_name: gpio
      }
      {
        name: i2c0_sda
        width: 1
        type: inout
        module_name: i2c0
      }
      {
        name: i2c0_scl
        width: 1
        type: inout
        module_name: i2c0
      }
      {
        name: i2c1_sda
        width: 1
        type: inout
        module_name: i2c1
      }
      {
        name: i2c1_scl
        width: 1
        type: inout
        module_name: i2c1
      }
      {
        name: i2c2_sda
        width: 1
        type: inout
        module_name: i2c2
      }
      {
        name: i2c2_scl
        width: 1
        type: inout
        module_name: i2c2
      }
    ]
  }
  padctrl:
  {
    attr_default:
    [
      STRONG
    ]
    pads:
    [
      {
        name: ChA
        type: IO_33V
        count: 32
      }
      {
        name: ChB
        type: IO_33V
        count: 4
        attr:
        [
          KEEP
          WEAK
        ]
      }
      {
        name: ChC
        type: IO_33V
        count: 4
        attr:
        [
          KEEP
          STRONG
        ]
      }
      {
        name: ChD
        type: IO_33V
        count: 14
        attr:
        [
          KEEP
          WEAK
        ]
      }
    ]
  }
  reset_paths:
  {
    rst_ni: rst_ni
    por_aon: rstmgr_aon_resets.rst_por_aon_n
    por: rstmgr_aon_resets.rst_por_n
    por_io: rstmgr_aon_resets.rst_por_io_n
    por_usb: rstmgr_aon_resets.rst_por_usb_n
    lc: rstmgr_aon_resets.rst_lc_n
    sys: rstmgr_aon_resets.rst_sys_n
    sys_io: rstmgr_aon_resets.rst_sys_io_n
    sys_aon: rstmgr_aon_resets.rst_sys_aon_n
    spi_device: rstmgr_aon_resets.rst_spi_device_n
    usb: rstmgr_aon_resets.rst_usb_n
  }
  wakeups:
  [
    pinmux_aon.aon_wkup_req
  ]
  inter_signal:
  {
    signals:
    [
      {
        struct: flash
        type: req_rsp
        name: flash
        act: req
        package: flash_ctrl_pkg
        inst_name: flash_ctrl
        width: 1
        top_signame: flash_ctrl_flash
        index: -1
      }
      {
        struct: flash_key
        type: uni
        name: otp
        act: rcv
        package: otp_ctrl_pkg
        inst_name: flash_ctrl
        width: 1
        top_signame: otp_ctrl_otp_flash_key
        index: -1
      }
      {
        struct: tl_h2d
        type: uni
        name: ast_host
        act: req
        package: tlul_pkg
        inst_name: sensor_ctrl
        width: 1
        top_signame: sensor_ctrl_ast_host
        index: -1
      }
      {
        struct: tl_d2h
        type: uni
        name: ast_dev
        act: rcv
        package: tlul_pkg
        inst_name: sensor_ctrl
        width: 1
        top_signame: sensor_ctrl_ast_dev
        index: -1
      }
      {
        struct: ast_aux
        type: uni
        name: ast_aux
        act: req
        package: sensor_ctrl_pkg
        inst_name: sensor_ctrl
        width: 1
        top_signame: sensor_ctrl_ast_aux
        index: -1
      }
      {
        struct: ast_alert
        type: req_rsp
        name: ast_alert
        act: rsp
        package: ast_wrapper_pkg
        inst_name: sensor_ctrl
        width: 1
        top_signame: sensor_ctrl_ast_alert
        index: -1
      }
      {
        struct: ast_status
        type: uni
        name: ast_status
        act: rcv
        package: ast_wrapper_pkg
        inst_name: sensor_ctrl
        width: 1
        top_signame: sensor_ctrl_ast_status
        index: -1
      }
      {
        struct: pwr_otp
        type: req_rsp
        name: pwr_otp_init
        act: rsp
        package: pwrmgr_pkg
        inst_name: otp_ctrl
        width: 1
        top_signame: pwrmgr_aon_pwr_otp
        index: -1
      }
      {
        struct: otp_pwr_state
        type: uni
        name: otp_pwr_state
        act: req
        package: otp_ctrl_pkg
        inst_name: otp_ctrl
        index: -1
      }
      {
        struct: lc_otp_program
        type: req_rsp
        name: lc_otp_program
        act: rsp
        package: otp_ctrl_pkg
        inst_name: otp_ctrl
        index: -1
      }
      {
        struct: otp_lc_data
        type: uni
        name: otp_lc_data
        act: req
        package: otp_ctrl_pkg
        inst_name: otp_ctrl
        index: -1
      }
      {
        struct: lc_tx
        type: uni
        name: lc_provision_en
        act: rsp
        package: otp_ctrl_pkg
        inst_name: otp_ctrl
        index: -1
      }
      {
        struct: lc_tx
        type: uni
        name: lc_test_en
        act: rsp
        package: otp_ctrl_pkg
        inst_name: otp_ctrl
        index: -1
      }
      {
        struct: keymgr_key
        type: uni
        name: otp_keymgr_key
        act: req
        package: otp_ctrl_pkg
        inst_name: otp_ctrl
        index: -1
      }
      {
        struct: flash_key
        type: uni
        name: otp_flash_key
        act: req
        package: otp_ctrl_pkg
        inst_name: otp_ctrl
        width: 1
        top_type: broadcast
        top_signame: otp_ctrl_otp_flash_key
        index: -1
      }
      {
        struct: sram_key
        type: uni
        name: otp_sram_key
        act: req
        package: otp_ctrl_pkg
        inst_name: otp_ctrl
        width: 1
        top_type: broadcast
        top_signame: otp_ctrl_otp_sram_key
        index: -1
      }
      {
        struct: hw_key_req
        type: uni
        name: keymgr_key
        act: rcv
        package: keymgr_pkg
        inst_name: kmac
        width: 1
        top_signame: keymgr_kmac_key
        index: -1
      }
      {
        struct: kmac_data
        type: req_rsp
        name: keymgr_data
        act: rsp
        package: keymgr_pkg
        inst_name: kmac
        width: 1
        top_signame: keymgr_kmac_data
        index: -1
      }
      {
        struct: lc_pinmux_strap
        type: req_rsp
        name: lc_pinmux_strap
        act: rsp
        package: pinmux_pkg
        inst_name: pinmux_aon
        index: -1
      }
      {
        struct: logic
        type: uni
        name: sleep_en
        act: rcv
        package: ""
        inst_name: pinmux_aon
        index: -1
      }
      {
        struct: logic
        type: uni
        name: aon_wkup_req
        act: req
        package: ""
        inst_name: pinmux_aon
        width: 1
        top_signame: pwrmgr_aon_wakeups
        index: -1
      }
      {
        struct: pwr_ast
        type: req_rsp
        name: pwr_ast
        act: req
        package: pwrmgr_pkg
        inst_name: pwrmgr_aon
        width: 1
        top_signame: pwrmgr_aon_pwr_ast
        index: -1
      }
      {
        struct: pwr_rst
        type: req_rsp
        name: pwr_rst
        act: req
        package: pwrmgr_pkg
        inst_name: pwrmgr_aon
        width: 1
        top_signame: pwrmgr_aon_pwr_rst
        index: -1
      }
      {
        struct: pwr_clk
        type: req_rsp
        name: pwr_clk
        act: req
        package: pwrmgr_pkg
        inst_name: pwrmgr_aon
        width: 1
        top_signame: pwrmgr_aon_pwr_clk
        index: -1
      }
      {
        struct: pwr_otp
        type: req_rsp
        name: pwr_otp
        act: req
        package: pwrmgr_pkg
        inst_name: pwrmgr_aon
        width: 1
        top_signame: pwrmgr_aon_pwr_otp
        index: -1
      }
      {
        struct: pwr_lc
        type: req_rsp
        name: pwr_lc
        act: req
        package: pwrmgr_pkg
        inst_name: pwrmgr_aon
        index: -1
      }
      {
        struct: pwr_flash
        type: uni
        name: pwr_flash
        act: rcv
        package: pwrmgr_pkg
        inst_name: pwrmgr_aon
        index: -1
      }
      {
        struct: pwr_cpu
        type: uni
        name: pwr_cpu
        act: rcv
        package: pwrmgr_pkg
        inst_name: pwrmgr_aon
        width: 1
        top_signame: pwrmgr_aon_pwr_cpu
        index: -1
      }
      {
        struct: logic
        width: 1
        type: uni
        name: wakeups
        act: rcv
        package: ""
        inst_name: pwrmgr_aon
        top_type: broadcast
        top_signame: pwrmgr_aon_wakeups
        index: -1
      }
      {
        struct: logic
        width: 2
        type: uni
        name: rstreqs
        act: rcv
        package: ""
        inst_name: pwrmgr_aon
        index: -1
      }
      {
        struct: pwr_rst
        type: req_rsp
        name: pwr
        act: rsp
        inst_name: rstmgr_aon
        width: 1
        package: pwrmgr_pkg
        top_signame: pwrmgr_aon_pwr_rst
        index: -1
      }
      {
        struct: rstmgr_out
        type: uni
        name: resets
        act: req
        package: rstmgr_pkg
        inst_name: rstmgr_aon
        width: 1
        top_signame: rstmgr_aon_resets
        index: -1
      }
      {
        struct: ast_rst
        type: uni
        name: ast
        act: rcv
        package: ast_wrapper_pkg
        inst_name: rstmgr_aon
        width: 1
        top_signame: rstmgr_aon_ast
        index: -1
      }
      {
        struct: rstmgr_cpu
        type: uni
        name: cpu
        act: rcv
        package: rstmgr_pkg
        inst_name: rstmgr_aon
        width: 1
        top_signame: rstmgr_aon_cpu
        index: -1
      }
      {
        struct: rstmgr_peri
        type: uni
        name: peri
        act: rcv
        package: rstmgr_pkg
        inst_name: rstmgr_aon
        index: -1
      }
      {
        struct: clkmgr_out
        type: uni
        name: clocks
        act: req
        package: clkmgr_pkg
        inst_name: clkmgr_aon
        width: 1
        top_signame: clkmgr_aon_clocks
        index: -1
      }
      {
        struct: pwr_clk
        type: req_rsp
        name: pwr
        act: rsp
        inst_name: clkmgr_aon
        width: 1
        package: pwrmgr_pkg
        top_signame: pwrmgr_aon_pwr_clk
        index: -1
      }
      {
        struct: clk_dft
        type: uni
        name: dft
        act: rcv
        package: clkmgr_pkg
        inst_name: clkmgr_aon
        index: -1
      }
      {
        struct: clk_hint_status
        type: uni
        name: status
        act: rcv
        package: clkmgr_pkg
        inst_name: clkmgr_aon
        index: -1
      }
      {
        name: usb_ref_val
        type: uni
        act: req
        package: ""
        struct: logic
        width: 1
        inst_name: usbdev_aon
        top_signame: usbdev_aon_usb_ref_val
        index: -1
      }
      {
        name: usb_ref_pulse
        type: uni
        act: req
        package: ""
        struct: logic
        width: 1
        inst_name: usbdev_aon
        top_signame: usbdev_aon_usb_ref_pulse
        index: -1
      }
      {
        struct: hw_key_req
        type: uni
        name: aes_key
        act: req
        package: keymgr_pkg
        inst_name: keymgr
        index: -1
      }
      {
        struct: hw_key_req
        type: uni
        name: hmac_key
        act: req
        package: keymgr_pkg
        inst_name: keymgr
        index: -1
      }
      {
        struct: hw_key_req
        type: uni
        name: kmac_key
        act: req
        package: keymgr_pkg
        inst_name: keymgr
        width: 1
        top_type: broadcast
        top_signame: keymgr_kmac_key
        index: -1
      }
      {
        struct: kmac_data
        type: req_rsp
        name: kmac_data
        act: req
        package: keymgr_pkg
        inst_name: keymgr
        width: 1
        top_signame: keymgr_kmac_data
        index: -1
      }
      {
        struct: lc_data
        type: uni
        name: lc
        act: rcv
        package: keymgr_pkg
        inst_name: keymgr
        index: -1
      }
      {
        struct: otp_data
        type: uni
        name: otp
        act: rcv
        package: keymgr_pkg
        inst_name: keymgr
        index: -1
      }
      {
        struct: flash_key
        type: uni
        name: flash
        act: rcv
        package: keymgr_pkg
        inst_name: keymgr
        index: -1
      }
      {
        struct: csrng
        type: req_rsp
        name: csrng_cmd
        act: rsp
        width: 3
        package: csrng_pkg
        inst_name: csrng
        top_signame: csrng_csrng_cmd
        index: -1
      }
      {
        struct: entropy_src_hw_if
        type: req_rsp
        name: entropy_src_hw_if
        act: req
        width: 1
        package: entropy_src_pkg
        inst_name: csrng
        top_signame: csrng_entropy_src_hw_if
        index: -1
      }
      {
        struct: logic
        type: uni
        name: efuse_sw_app_enable
        act: rcv
        width: 1
        package: ""
        inst_name: csrng
        index: -1
      }
      {
        struct: entropy_src_hw_if
        type: req_rsp
        name: entropy_src_hw_if
        act: rsp
        package: entropy_src_pkg
        inst_name: entropy_src
        width: 1
        top_signame: csrng_entropy_src_hw_if
        index: -1
      }
      {
        struct: entropy_src_rng
        type: req_rsp
        name: entropy_src_rng
        act: req
        package: entropy_src_pkg
        inst_name: entropy_src
        width: 1
        top_signame: entropy_src_entropy_src_rng
        index: -1
      }
      {
        struct: logic
        type: uni
        name: efuse_es_sw_reg_en
        width: 1
        act: rcv
        package: ""
        inst_name: entropy_src
        index: -1
      }
      {
        name: idle
        type: uni
        struct: logic
        width: "1"
        act: req
        inst_name: otbn
        index: -1
      }
      {
        struct: flash
        type: req_rsp
        name: flash_ctrl
        act: rsp
        inst_name: eflash
        width: 1
        package: flash_ctrl_pkg
        top_signame: flash_ctrl_flash
        index: -1
      }
    ]
    external:
    [
      {
        package: tlul_pkg
        struct: tl_h2d
        signame: sensor_ctrl_ast_host
        width: 1
        type: uni
        direction: out
      }
      {
        package: tlul_pkg
        struct: tl_d2h
        signame: sensor_ctrl_ast_dev
        width: 1
        type: uni
        direction: in
      }
      {
        package: ast_wrapper_pkg
        struct: ast_status
        signame: sensor_ctrl_ast_status
        width: 1
        type: uni
        direction: in
      }
      {
        package: ast_wrapper_pkg
        struct: ast_alert_req
        signame: sensor_ctrl_ast_alert_req
        width: 1
        type: req_rsp
        direction: in
      }
      {
        package: ast_wrapper_pkg
        struct: ast_alert_rsp
        signame: sensor_ctrl_ast_alert_rsp
        width: 1
        type: req_rsp
        direction: out
      }
      {
        package: sensor_ctrl_pkg
        struct: ast_aux
        signame: sensor_ctrl_ast_aux
        width: 1
        type: uni
        direction: out
      }
      {
        package: pwrmgr_pkg
        struct: pwr_ast_req
        signame: pwrmgr_aon_pwr_ast_req
        width: 1
        type: req_rsp
        direction: out
      }
      {
        package: pwrmgr_pkg
        struct: pwr_ast_rsp
        signame: pwrmgr_aon_pwr_ast_rsp
        width: 1
        type: req_rsp
        direction: in
      }
      {
        package: ast_wrapper_pkg
        struct: ast_rst
        signame: rstmgr_aon_ast
        width: 1
        type: uni
        direction: in
      }
      {
        package: ""
        struct: logic
        signame: usbdev_aon_usb_ref_pulse
        width: 1
        type: uni
        direction: out
      }
      {
        package: ""
        struct: logic
        signame: usbdev_aon_usb_ref_val
        width: 1
        type: uni
        direction: out
      }
      {
        package: entropy_src_pkg
        struct: entropy_src_rng_req
        signame: entropy_src_entropy_src_rng_req
        width: 1
        type: req_rsp
        direction: out
      }
      {
        package: entropy_src_pkg
        struct: entropy_src_rng_rsp
        signame: entropy_src_entropy_src_rng_rsp
        width: 1
        type: req_rsp
        direction: in
      }
    ]
    definitions:
    [
      {
        package: flash_ctrl_pkg
        struct: flash_req
        signame: flash_ctrl_flash_req
        width: 1
        type: req_rsp
      }
      {
        package: flash_ctrl_pkg
        struct: flash_rsp
        signame: flash_ctrl_flash_rsp
        width: 1
        type: req_rsp
      }
      {
        package: otp_ctrl_pkg
        struct: flash_key
        signame: otp_ctrl_otp_flash_key
        width: 1
        type: uni
      }
      {
        package: otp_ctrl_pkg
        struct: sram_key
        signame: otp_ctrl_otp_sram_key
        width: 1
        type: uni
      }
      {
        package: pwrmgr_pkg
        struct: pwr_otp_req
        signame: pwrmgr_aon_pwr_otp_req
        width: 1
        type: req_rsp
      }
      {
        package: pwrmgr_pkg
        struct: pwr_otp_rsp
        signame: pwrmgr_aon_pwr_otp_rsp
        width: 1
        type: req_rsp
      }
      {
        package: pwrmgr_pkg
        struct: pwr_rst_req
        signame: pwrmgr_aon_pwr_rst_req
        width: 1
        type: req_rsp
      }
      {
        package: pwrmgr_pkg
        struct: pwr_rst_rsp
        signame: pwrmgr_aon_pwr_rst_rsp
        width: 1
        type: req_rsp
      }
      {
        package: pwrmgr_pkg
        struct: pwr_clk_req
        signame: pwrmgr_aon_pwr_clk_req
        width: 1
        type: req_rsp
      }
      {
        package: pwrmgr_pkg
        struct: pwr_clk_rsp
        signame: pwrmgr_aon_pwr_clk_rsp
        width: 1
        type: req_rsp
      }
      {
        package: entropy_src_pkg
        struct: entropy_src_hw_if_req
        signame: csrng_entropy_src_hw_if_req
        width: 1
        type: req_rsp
      }
      {
        package: entropy_src_pkg
        struct: entropy_src_hw_if_rsp
        signame: csrng_entropy_src_hw_if_rsp
        width: 1
        type: req_rsp
      }
      {
        package: keymgr_pkg
        struct: hw_key_req
        signame: keymgr_kmac_key
        width: 1
        type: uni
      }
      {
        package: keymgr_pkg
        struct: kmac_data_req
        signame: keymgr_kmac_data_req
        width: 1
        type: req_rsp
      }
      {
        package: keymgr_pkg
        struct: kmac_data_rsp
        signame: keymgr_kmac_data_rsp
        width: 1
        type: req_rsp
      }
      {
        package: ""
        struct: logic
        signame: pwrmgr_aon_wakeups
        width: 1
        type: uni
      }
      {
        package: rstmgr_pkg
        struct: rstmgr_out
        signame: rstmgr_aon_resets
        width: 1
        type: uni
      }
      {
        package: rstmgr_pkg
        struct: rstmgr_cpu
        signame: rstmgr_aon_cpu
        width: 1
        type: uni
      }
      {
        package: pwrmgr_pkg
        struct: pwr_cpu
        signame: pwrmgr_aon_pwr_cpu
        width: 1
        type: uni
      }
      {
        package: clkmgr_pkg
        struct: clkmgr_out
        signame: clkmgr_aon_clocks
        width: 1
        type: uni
      }
      {
        package: csrng_pkg
        struct: csrng_req
        signame: csrng_csrng_cmd_req
        width: 3
        type: req_rsp
      }
      {
        package: csrng_pkg
        struct: csrng_rsp
        signame: csrng_csrng_cmd_rsp
        width: 3
        type: req_rsp
      }
    ]
  }
}