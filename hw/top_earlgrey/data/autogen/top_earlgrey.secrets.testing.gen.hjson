// Copyright lowRISC contributors (OpenTitan project).
// Licensed under the Apache License, Version 2.0, see LICENSE for details.
// SPDX-License-Identifier: Apache-2.0
//
// ------------------- W A R N I N G: A U T O - G E N E R A T E D   C O D E !! -------------------//
// PLEASE DO NOT HAND-EDIT THIS FILE. IT HAS BEEN AUTO-GENERATED WITH THE FOLLOWING COMMAND:
// util/topgen.py -t hw/top_earlgrey/data/top_earlgrey.hjson
//                -o hw/top_earlgrey/
{
  seed:
  {
    topgen_seed:
    {
      seed_mode: testing
      value: 1017106219537032642877583828875051302543807092889754935647094601236425074047
    }
    otp_img_seed:
    {
      seed_mode: testing
      value: 52408960416235844780753299194502148156786072650816676092165912261205302331741
    }
    lc_ctrl_seed:
    {
      seed_mode: testing
      value: 40182201019264397688411770949626922549663256047001778394918990008320537410392
    }
  }
  module:
  [
    {
      name: otp_ctrl
      type: otp_ctrl
      base_addrs:
      {
        core:
        {
          hart: 0x40130000
        }
      }
      memory: {}
      param_list:
      [
        {
          name: RndCnstLfsrSeed
          desc: Compile-time random bits for initial LFSR seed
          type: otp_ctrl_top_specific_pkg::lfsr_seed_t
          randcount: 40
          randtype: data
          name_top: RndCnstOtpCtrlLfsrSeed
          default: 0x1f8e09d92d
          randwidth: 40
        }
        {
          name: RndCnstLfsrPerm
          desc: Compile-time random permutation for LFSR output
          type: otp_ctrl_top_specific_pkg::lfsr_perm_t
          randcount: 40
          randtype: perm
          name_top: RndCnstOtpCtrlLfsrPerm
          default: 0x4431c56669df09018424e8634cb89c35b7606815cc60895559429291e00f
          randwidth: 240
        }
        {
          name: RndCnstScrmblKeyInit
          desc: Compile-time random permutation for scrambling key/nonce register reset value
          type: otp_ctrl_top_specific_pkg::scrmbl_key_init_t
          randcount: 256
          randtype: data
          name_top: RndCnstOtpCtrlScrmblKeyInit
          default: 0x530010117f58c9e9946c11180407feb4710f404e6e4face59b972d1fdcaf711c
          randwidth: 256
        }
        {
          name: RndCnstScrmblKey0
          desc: Compile-time scrambling key
          type: otp_ctrl_top_specific_pkg::key_t
          randcount: 128
          randtype: extdata
          name_top: RndCnstOtpCtrlScrmblKey0
          default: 0x8e023b1e052dac1e0fcebeac537edc
          randwidth: 128
        }
        {
          name: RndCnstScrmblKey1
          desc: Compile-time scrambling key
          type: otp_ctrl_top_specific_pkg::key_t
          randcount: 128
          randtype: extdata
          name_top: RndCnstOtpCtrlScrmblKey1
          default: 0x7848da13345040c295fcbd76684e7170
          randwidth: 128
        }
        {
          name: RndCnstScrmblKey2
          desc: Compile-time scrambling key
          type: otp_ctrl_top_specific_pkg::key_t
          randcount: 128
          randtype: extdata
          name_top: RndCnstOtpCtrlScrmblKey2
          default: 0x57af03288e6c3c383a73e698950bfab6
          randwidth: 128
        }
        {
          name: RndCnstDigestConst0
          desc: Compile-time digest const
          type: otp_ctrl_top_specific_pkg::digest_const_t
          randcount: 128
          randtype: extdata
          name_top: RndCnstOtpCtrlDigestConst0
          default: 0xea1ea059dc5c584c99e3e946397824f3
          randwidth: 128
        }
        {
          name: RndCnstDigestConst1
          desc: Compile-time digest const
          type: otp_ctrl_top_specific_pkg::digest_const_t
          randcount: 128
          randtype: extdata
          name_top: RndCnstOtpCtrlDigestConst1
          default: 0xc0a5a56f968fd7e98071ef1bff0c99f0
          randwidth: 128
        }
        {
          name: RndCnstDigestConst2
          desc: Compile-time digest const
          type: otp_ctrl_top_specific_pkg::digest_const_t
          randcount: 128
          randtype: extdata
          name_top: RndCnstOtpCtrlDigestConst2
          default: 0xc02abd645fc814bcbc1cfcff9f3e4cd4
          randwidth: 128
        }
        {
          name: RndCnstDigestConst3
          desc: Compile-time digest const
          type: otp_ctrl_top_specific_pkg::digest_const_t
          randcount: 128
          randtype: extdata
          name_top: RndCnstOtpCtrlDigestConst3
          default: 0x2214d76208e9943a43242540d2120889
          randwidth: 128
        }
        {
          name: RndCnstDigestIV0
          desc: Compile-time digest initial vector
          type: otp_ctrl_top_specific_pkg::digest_iv_t
          randcount: 64
          randtype: extdata
          name_top: RndCnstOtpCtrlDigestIV0
          default: 0x9acf416ad5455d1d
          randwidth: 64
        }
        {
          name: RndCnstDigestIV1
          desc: Compile-time digest initial vector
          type: otp_ctrl_top_specific_pkg::digest_iv_t
          randcount: 64
          randtype: extdata
          name_top: RndCnstOtpCtrlDigestIV1
          default: 0x74e7b5c15957663a
          randwidth: 64
        }
        {
          name: RndCnstDigestIV2
          desc: Compile-time digest initial vector
          type: otp_ctrl_top_specific_pkg::digest_iv_t
          randcount: 64
          randtype: extdata
          name_top: RndCnstOtpCtrlDigestIV2
          default: 0x7a827e95a7385b32
          randwidth: 64
        }
        {
          name: RndCnstDigestIV3
          desc: Compile-time digest initial vector
          type: otp_ctrl_top_specific_pkg::digest_iv_t
          randcount: 64
          randtype: extdata
          name_top: RndCnstOtpCtrlDigestIV3
          default: 0xfe6728d0d0879ec6
          randwidth: 64
        }
        {
          name: RndCnstPartInvDefault
          desc: OTP invalid partition default for buffered partitions
          type: logic [16383:0]
          randcount: 16384
          randtype: extdata
          name_top: RndCnstOtpCtrlPartInvDefault
          default:
          [
            {
              size: 704
              items:
              [
                {
                  size: 320
                  inv_default: 865483628382388783833486223527103700372238712096558284441157138736665418385845619121574525406131
                }
                {
                  size: 384
                  inv_default: 15714797660047341488534127627579808491169430382015215327234153171472129925346611664487816925151944674070104822711062
                }
              ]
            }
            {
              size: 704
              items:
              [
                {
                  size: 64
                  inv_default: 8058422133488400218
                }
                {
                  size: 256
                  inv_default: 60522346507929435416391309954626740383218998467738884573186599633244939263479
                }
                {
                  size: 256
                  inv_default: 44567343500516902319007325717195865352697728552885620263692795830659649726468
                }
                {
                  size: 128
                  inv_default: 334671433878751700697199779069205613746
                }
              ]
            }
            {
              size: 704
              items:
              [
                {
                  size: 64
                  inv_default: 5286285299921024260
                }
                {
                  size: 128
                  inv_default: 135837942677254952990104010255834134273
                }
                {
                  size: 256
                  inv_default: 42760053834267273387871423107414336620784207480021495990050142110767371612573
                }
                {
                  size: 256
                  inv_default: 114154205722399252869850894030766882783782099707479450552335841877429576047902
                }
              ]
            }
            {
              size: 320
              items:
              [
                {
                  size: 64
                  inv_default: 9984016280323298770
                }
                {
                  size: 128
                  inv_default: 230748029623541578864187550162391519735
                }
                {
                  size: 128
                  inv_default: 232795746524822262786724684828264059333
                }
              ]
            }
            {
              size: 128
              items:
              [
                {
                  size: 64
                  inv_default: 3220671226818894432
                }
                {
                  comment: unallocated space
                  size: 40
                  inv_default: 0
                }
                {
                  size: 8
                  inv_default: 105
                }
                {
                  size: 8
                  inv_default: 105
                }
                {
                  size: 8
                  inv_default: 105
                }
              ]
            }
            {
              size: 576
              items:
              [
                {
                  size: 64
                  inv_default: 1301679241270694456
                }
                {
                  size: 256
                  inv_default: 73732138675274264303788256961686404944759477002619436661173137973430400193623
                }
                {
                  size: 256
                  inv_default: 101994044936824639612461447164778906738787223995885395958442779952147640154081
                }
              ]
            }
            {
              size: 320
              items:
              [
                {
                  size: 64
                  inv_default: 4965525511854572725
                }
                {
                  size: 32
                  inv_default: 0
                }
                {
                  size: 32
                  inv_default: 0
                }
                {
                  size: 32
                  inv_default: 0
                }
                {
                  size: 32
                  inv_default: 0
                }
                {
                  size: 32
                  inv_default: 0
                }
                {
                  size: 32
                  inv_default: 0
                }
                {
                  size: 32
                  inv_default: 0
                }
                {
                  size: 32
                  inv_default: 0
                }
              ]
            }
            {
              size: 3776
              items:
              [
                {
                  size: 64
                  inv_default: 1662255584663227314
                }
                {
                  size: 256
                  inv_default: 0
                }
                {
                  size: 32
                  inv_default: 0
                }
                {
                  size: 256
                  inv_default: 0
                }
                {
                  size: 32
                  inv_default: 0
                }
                {
                  size: 32
                  inv_default: 0
                }
                {
                  size: 256
                  inv_default: 0
                }
                {
                  size: 32
                  inv_default: 0
                }
                {
                  size: 32
                  inv_default: 0
                }
                {
                  size: 256
                  inv_default: 0
                }
                {
                  size: 32
                  inv_default: 0
                }
                {
                  size: 32
                  inv_default: 0
                }
                {
                  size: 256
                  inv_default: 0
                }
                {
                  size: 32
                  inv_default: 0
                }
                {
                  size: 512
                  inv_default: 0
                }
                {
                  size: 32
                  inv_default: 0
                }
                {
                  size: 512
                  inv_default: 0
                }
                {
                  size: 32
                  inv_default: 0
                }
                {
                  size: 512
                  inv_default: 0
                }
                {
                  size: 32
                  inv_default: 0
                }
                {
                  size: 512
                  inv_default: 0
                }
                {
                  size: 32
                  inv_default: 0
                }
              ]
            }
            {
              size: 5440
              items:
              [
                {
                  size: 64
                  inv_default: 11638191378943044423
                }
                {
                  comment: unallocated space
                  size: 96
                  inv_default: 0
                }
                {
                  size: 768
                  inv_default: 0
                }
                {
                  size: 32
                  inv_default: 0
                }
                {
                  size: 32
                  inv_default: 0
                }
                {
                  size: 32
                  inv_default: 0
                }
                {
                  size: 32
                  inv_default: 0
                }
                {
                  size: 32
                  inv_default: 0
                }
                {
                  size: 96
                  inv_default: 0
                }
                {
                  size: 32
                  inv_default: 0
                }
                {
                  size: 32
                  inv_default: 0
                }
                {
                  size: 32
                  inv_default: 0
                }
                {
                  size: 32
                  inv_default: 0
                }
                {
                  size: 32
                  inv_default: 0
                }
                {
                  size: 32
                  inv_default: 0
                }
                {
                  size: 32
                  inv_default: 0
                }
                {
                  size: 32
                  inv_default: 0
                }
                {
                  size: 32
                  inv_default: 0
                }
                {
                  size: 512
                  inv_default: 0
                }
                {
                  size: 128
                  inv_default: 0
                }
                {
                  size: 128
                  inv_default: 0
                }
                {
                  size: 512
                  inv_default: 0
                }
                {
                  size: 2560
                  inv_default: 0
                }
                {
                  size: 32
                  inv_default: 0
                }
                {
                  size: 32
                  inv_default: 0
                }
                {
                  size: 32
                  inv_default: 0
                }
                {
                  size: 32
                  inv_default: 0
                }
              ]
            }
            {
              size: 3200
              items:
              [
                {
                  size: 64
                  inv_default: 16706844895266615817
                }
                {
                  comment: unallocated space
                  size: 64
                  inv_default: 0
                }
                {
                  size: 256
                  inv_default: 0
                }
                {
                  size: 32
                  inv_default: 0
                }
                {
                  size: 32
                  inv_default: 0
                }
                {
                  size: 32
                  inv_default: 0
                }
                {
                  size: 32
                  inv_default: 0
                }
                {
                  size: 32
                  inv_default: 0
                }
                {
                  size: 32
                  inv_default: 0
                }
                {
                  size: 32
                  inv_default: 0
                }
                {
                  size: 32
                  inv_default: 0
                }
                {
                  size: 32
                  inv_default: 0
                }
                {
                  size: 32
                  inv_default: 0
                }
                {
                  size: 32
                  inv_default: 0
                }
                {
                  size: 32
                  inv_default: 0
                }
                {
                  size: 32
                  inv_default: 0
                }
                {
                  size: 32
                  inv_default: 0
                }
                {
                  size: 32
                  inv_default: 0
                }
                {
                  size: 32
                  inv_default: 0
                }
                {
                  size: 32
                  inv_default: 0
                }
                {
                  size: 32
                  inv_default: 0
                }
                {
                  size: 32
                  inv_default: 0
                }
                {
                  size: 32
                  inv_default: 0
                }
                {
                  size: 32
                  inv_default: 0
                }
                {
                  size: 32
                  inv_default: 0
                }
                {
                  size: 32
                  inv_default: 0
                }
                {
                  size: 32
                  inv_default: 0
                }
                {
                  size: 32
                  inv_default: 0
                }
                {
                  size: 32
                  inv_default: 0
                }
                {
                  size: 32
                  inv_default: 0
                }
                {
                  size: 32
                  inv_default: 0
                }
                {
                  size: 32
                  inv_default: 0
                }
                {
                  size: 32
                  inv_default: 0
                }
                {
                  size: 32
                  inv_default: 0
                }
                {
                  size: 32
                  inv_default: 0
                }
                {
                  size: 32
                  inv_default: 0
                }
                {
                  size: 32
                  inv_default: 0
                }
                {
                  size: 1728
                  inv_default: 0
                }
              ]
            }
            {
              size: 512
              items:
              [
                {
                  size: 64
                  inv_default: 1777012990741967443
                }
                {
                  size: 448
                  inv_default: 0
                }
              ]
            }
          ]
          randwidth: 16384
        }
      ]
      template_type: otp_ctrl
      otp_mmap:
      {
        otp:
        {
          width: 2
          depth: 1024
          size: 2048
          addr_width: 10
          byte_addr_width: 11
        }
        scrambling:
        {
          key_size: 16
          iv_size: 8
          cnst_size: 16
          keys:
          [
            {
              name: Secret0Key
              value: 737351402483551773424408676158111452
            }
            {
              name: Secret1Key
              value: 159885627954823336570095967134108512624
            }
            {
              name: Secret2Key
              value: 116551551643964307065576810321281809078
            }
          ]
          digests:
          [
            {
              name: CnstyDigest
              iv_value: 11155206729120439581
              cnst_value: 311198372224467747442533110710661555443
            }
            {
              name: NvmDataKey
              iv_value: 8423901470052017722
              cnst_value: 256071859610869383246747191689480018416
            }
            {
              name: NvmAddrKey
              iv_value: 8827757400820308786
              cnst_value: 255433692986636610975896359571933777108
            }
            {
              name: SramDataKey
              iv_value: 18331665685551750854
              cnst_value: 45301966279040807517875905792635439241
            }
          ]
          num_keys: 3
          num_digests: 4
        }
        partitions:
        [
          {
            name: VENDOR_TEST
            variant: Unbuffered
            secret: false
            sw_digest: true
            hw_digest: false
            write_lock: Digest
            read_lock: CSR
            key_sel: NoKey
            integrity: false
            bkout_type: false
            skip_sw_header: true
            items:
            [
              {
                name: SCRATCH
                size: 56
                isdigest: false
                iszer: false
                ismubi: false
                iskeymgr_creator: false
                iskeymgr_owner: false
                inv_default: 0
                offset: 0
              }
              {
                name: VENDOR_TEST_DIGEST
                size: 8
                offset: 56
                ismubi: false
                isdigest: true
                iszer: false
                inv_default: 1777012990741967443
                iskeymgr_creator: false
                iskeymgr_owner: false
              }
            ]
            desc:
              '''
              Vendor test partition.
              This is reserved for manufacturing smoke checks. The OTP wrapper
              control logic inside otp_macro is allowed to read/write to this
              region. ECC uncorrectable errors seen on the functional otp_macro
              interface will not lead to an alert for this partition.
              Instead, such errors will be reported as correctable ECC errors.
              '''
            absorb: false
            iskeymgr_creator: false
            iskeymgr_owner: false
            zeroizable: false
            ignore_read_lock_in_rma: false
            size: 64
            offset: 0
          }
          {
            name: CREATOR_SW_CFG
            variant: Unbuffered
            absorb: true
            secret: false
            sw_digest: true
            hw_digest: false
            write_lock: Digest
            read_lock: CSR
            key_sel: NoKey
            integrity: true
            bkout_type: false
            items:
            [
              {
                name: CREATOR_SW_CFG_AST_CFG
                size: 216
                desc:
                  '''
                  AST configuration data. These values get blindly copied to
                  the AST CSRs during ROM execution.
                  '''
                isdigest: false
                iszer: false
                ismubi: false
                iskeymgr_creator: false
                iskeymgr_owner: false
                inv_default: 0
                offset: 64
              }
              {
                name: CREATOR_SW_CFG_AST_INIT_EN
                size: 4
                desc:
                  '''
                  Controls whether or not the CREATOR_SW_CFG_AST_CFG values
                  get copied to the AST CSRs during ROM execution.
                  A value of kMultiBitBool4True enables copying; all other
                  values disable.
                  '''
                isdigest: false
                iszer: false
                ismubi: false
                iskeymgr_creator: false
                iskeymgr_owner: false
                inv_default: 0
                offset: 280
              }
              {
                name: CREATOR_SW_CFG_ROM_EXT_SKU
                size: 4
                desc: SKU identifier metadata. Unused by SiliconCreator software.
                isdigest: false
                iszer: false
                ismubi: false
                iskeymgr_creator: false
                iskeymgr_owner: false
                inv_default: 0
                offset: 284
              }
              {
                name: CREATOR_SW_CFG_SIGVERIFY_SPX_EN
                size: 4
                desc:
                  '''
                  Controls whether or not SPHINCS+ signature verification will
                  be executed when the ROM attempts to boot the ROM_EXT.
                  A value of kSigverifySpxDisabledOtp disables SPHINCS+
                  signature verification, while all other values enable it.
                  Note, SPHINCS+ signature verification is always disabled in
                  TEST_UNLOCKED* LC states.
                  '''
                isdigest: false
                iszer: false
                ismubi: false
                iskeymgr_creator: false
                iskeymgr_owner: false
                inv_default: 0
                offset: 288
              }
              {
                name: CREATOR_SW_CFG_NVM_DATA_DEFAULT_CFG
                size: 4
                desc:
                  '''
                  The default scrambling, ECC, and high endurance
                  configuration settings for NVM (flash or RRAM) data pages
                  set during ROM execution.
                  '''
                isdigest: false
                iszer: false
                ismubi: false
                iskeymgr_creator: false
                iskeymgr_owner: false
                inv_default: 0
                offset: 292
              }
              {
                name: CREATOR_SW_CFG_NVM_INFO_BOOT_DATA_CFG
                size: 4
                desc:
                  '''
                  The scrambling, ECC, and high endurance configuration
                  settings for the boot data NVM (flash or RRAM) info pages
                  set during ROM execution.
                  '''
                isdigest: false
                iszer: false
                ismubi: false
                iskeymgr_creator: false
                iskeymgr_owner: false
                inv_default: 0
                offset: 296
              }
              {
                name: CREATOR_SW_CFG_NVM_HW_INFO_CFG_OVERRIDE
                size: 4
                desc:
                  '''
                  Scrambling and ECC configuration overrides (set by the ROM)
                  for the Creator and OwnerSeed NVM (flash or RRAM) info
                  pages that are hardwired to the keygmr. By default,
                  scrambling and ECC on these info pages must be enabled in
                  order to successfully crank the keygmr (in the ROM_EXT).
                  However, values of kMultiBitBool4True for each subfield in
                  this field will disable this requirement. See the
                  HW_INFO_CFG_OVERRIDE flash_ctrl/rram_ctrl CSR for more
                  details.
                  '''
                isdigest: false
                iszer: false
                ismubi: false
                iskeymgr_creator: false
                iskeymgr_owner: false
                inv_default: 0
                offset: 300
              }
              {
                name: CREATOR_SW_CFG_RNG_EN
                size: 4
                desc:
                  '''
                  Whether or not to enable use of hardware generated entropy
                  (from the entropy complex via EDN) in the `rnd_uint32`
                  function. A value of kHardenedBoolTrue enables the use of
                  hardware generated entropy, while all other values disable.
                  '''
                isdigest: false
                iszer: false
                ismubi: false
                iskeymgr_creator: false
                iskeymgr_owner: false
                inv_default: 0
                offset: 304
              }
              {
                name: CREATOR_SW_CFG_JITTER_EN
                size: 4
                desc:
                  '''
                  Whether or not to enable clock jitter. A value of
                  kMultiBitBool4False disables, while all other values enable.
                  '''
                isdigest: false
                iszer: false
                ismubi: false
                iskeymgr_creator: false
                iskeymgr_owner: false
                inv_default: 0
                offset: 308
              }
              {
                name: CREATOR_SW_CFG_RET_RAM_RESET_MASK
                size: 4
                desc:
                  '''
                  Reset reason mask used to initialize (by overwriting with
                  random data) retention SRAM during ROM execution. A value of
                  0 only initializes retention SRAM on power-on-resets.See
                  rstmgr RESET_INFO CSR documentation for more details.
                  '''
                isdigest: false
                iszer: false
                ismubi: false
                iskeymgr_creator: false
                iskeymgr_owner: false
                inv_default: 0
                offset: 312
              }
              {
                name: CREATOR_SW_CFG_MANUF_STATE
                size: 4
                desc:
                  '''
                  Manufacturing state binding field. For use by
                  SiliconCreators or SiliconOwners to bind ROM_EXT images to a
                  specific device or set of devices.
                  '''
                isdigest: false
                iszer: false
                ismubi: false
                iskeymgr_creator: false
                iskeymgr_owner: false
                inv_default: 0
                offset: 316
              }
              {
                name: CREATOR_SW_CFG_ROM_EXEC_EN
                size: 4
                desc:
                  '''
                  Whether or not to enable execution of ROM. A value of 0
                  disables, while all other values enable. This enables
                  provisioning flows to attach JTAG connections and halt the
                  CPU before the device has been fully provisioned. All SKUs
                  should set this field to a non-zero value. Provisioning
                  flows shall take care to program this field at the
                  appropriate time during.
                  '''
                isdigest: false
                iszer: false
                ismubi: false
                iskeymgr_creator: false
                iskeymgr_owner: false
                inv_default: 0
                offset: 320
              }
              {
                name: CREATOR_SW_CFG_CPUCTRL
                size: 4
                desc:
                  '''
                  Value to write to the Ibex CPUCTRL CSR during ROM execution.
                  This field controls settings such as ICACHE enablement. See
                  Ibex documentation for more information.
                  '''
                isdigest: false
                iszer: false
                ismubi: false
                iskeymgr_creator: false
                iskeymgr_owner: false
                inv_default: 0
                offset: 324
              }
              {
                name: CREATOR_SW_CFG_MIN_SEC_VER_ROM_EXT
                size: 4
                desc:
                  '''
                  Value of the min_security_version_rom_ext field of the
                  default boot data.
                  '''
                isdigest: false
                iszer: false
                ismubi: false
                iskeymgr_creator: false
                iskeymgr_owner: false
                inv_default: 0
                offset: 328
              }
              {
                name: CREATOR_SW_CFG_MIN_SEC_VER_BL0
                size: 4
                desc:
                  '''
                  Value of the min_security_version_bl0 field of the
                  default boot data.
                  '''
                isdigest: false
                iszer: false
                ismubi: false
                iskeymgr_creator: false
                iskeymgr_owner: false
                inv_default: 0
                offset: 332
              }
              {
                name: CREATOR_SW_CFG_DEFAULT_BOOT_DATA_IN_PROD_EN
                size: 4
                desc:
                  '''
                  Whether or not to enable the default boot data in PROD and
                  PROD_END life cycle states. A value of kHardenedBoolTrue
                  enables, all other values disable. If left disabled,
                  provisioning flows are required to setup boot data pages
                  prior to enabling ROM execution. The default personalization
                  flow in `ft_personalize.c` configures these pages.
                  '''
                isdigest: false
                iszer: false
                ismubi: false
                iskeymgr_creator: false
                iskeymgr_owner: false
                inv_default: 0
                offset: 336
              }
              {
                name: CREATOR_SW_CFG_RMA_SPIN_EN
                size: 4
                desc:
                  '''
                  Whether or not to enable a busy-wait delay loop in the ROM,
                  when a specific SW strapping configuration is applied during
                  boot, to provide time to trigger an RMA lifecycle transition
                  over JTAG. A value of kHardenedBoolTrue enables, all other
                  values disable.
                  '''
                isdigest: false
                iszer: false
                ismubi: false
                iskeymgr_creator: false
                iskeymgr_owner: false
                inv_default: 0
                offset: 340
              }
              {
                name: CREATOR_SW_CFG_RMA_SPIN_CYCLES
                size: 4
                desc:
                  '''
                  The number of Ibex clock cycles to spin for when waiting for
                  an RMA transition. Used in combination with the
                  CREATOR_SW_CFG_RMA_SPIN_EN field.
                  '''
                isdigest: false
                iszer: false
                ismubi: false
                iskeymgr_creator: false
                iskeymgr_owner: false
                inv_default: 0
                offset: 344
              }
              {
                name: CREATOR_SW_CFG_RNG_REPCNT_THRESHOLDS
                size: 4
                desc:
                  '''
                  The repetition count health test thresholds to enable
                  entropy_src with during ROM execution.
                  This must be configured if CREATOR_SW_CFG_RNG_EN is true.
                  The LSBs contain the boot-time / bypass mode threshold
                  value.
                  The MSBs contain the value for the FIPS / CC compliant mode.
                  See entropy_src documentation for more details.
                  '''
                isdigest: false
                iszer: false
                ismubi: false
                iskeymgr_creator: false
                iskeymgr_owner: false
                inv_default: 0
                offset: 348
              }
              {
                name: CREATOR_SW_CFG_RNG_REPCNTS_THRESHOLDS
                size: 4
                desc:
                  '''
                  The repetition count symbol health test thresholds to enable
                  entropy_src with during ROM execution.
                  This must be configured if CREATOR_SW_CFG_RNG_EN is true.
                  The LSBs contain the boot-time / bypass mode threshold
                  value.
                  The MSBs contain the value for the FIPS / CC compliant mode.
                  See entropy_src documentation for more details.
                  '''
                isdigest: false
                iszer: false
                ismubi: false
                iskeymgr_creator: false
                iskeymgr_owner: false
                inv_default: 0
                offset: 352
              }
              {
                name: CREATOR_SW_CFG_RNG_ADAPTP_HI_THRESHOLDS
                size: 4
                desc:
                  '''
                  The adaptive proportion health test high thresholds to
                  enable entropy_src with during ROM execution.
                  This must be configured if CREATOR_SW_CFG_RNG_EN is true.
                  The LSBs contain the boot-time / bypass mode threshold
                  value.
                  The MSBs contain the value for the FIPS / CC compliant mode.
                  See entropy_src documentation for more details.
                  '''
                isdigest: false
                iszer: false
                ismubi: false
                iskeymgr_creator: false
                iskeymgr_owner: false
                inv_default: 0
                offset: 356
              }
              {
                name: CREATOR_SW_CFG_RNG_ADAPTP_LO_THRESHOLDS
                size: 4
                desc:
                  '''
                  The adaptive proportion health test low thresholds to enable
                  entropy_src with during ROM execution.
                  This must be configured if CREATOR_SW_CFG_RNG_EN is true.
                  The LSBs contain the boot-time / bypass mode threshold
                  value.
                  The MSBs contain the value for the FIPS / CC compliant mode.
                  See entropy_src documentation for more details.
                  '''
                isdigest: false
                iszer: false
                ismubi: false
                iskeymgr_creator: false
                iskeymgr_owner: false
                inv_default: 0
                offset: 360
              }
              {
                name: CREATOR_SW_CFG_RNG_BUCKET_THRESHOLDS
                size: 4
                desc:
                  '''
                  The bucket health test thresholds to enable entropy_src with
                  during ROM execution.
                  This must be configured if CREATOR_SW_CFG_RNG_EN is true.
                  The LSBs contain the boot-time / bypass mode threshold
                  value.
                  The MSBs contain the value for the FIPS / CC compliant mode.
                  See entropy_src documentation for more details.
                  '''
                isdigest: false
                iszer: false
                ismubi: false
                iskeymgr_creator: false
                iskeymgr_owner: false
                inv_default: 0
                offset: 364
              }
              {
                name: CREATOR_SW_CFG_RNG_MARKOV_HI_THRESHOLDS
                size: 4
                desc:
                  '''
                  The Markov health test high thresholds to enable entropy_src
                  with during ROM execution.
                  This must be configured if CREATOR_SW_CFG_RNG_EN is true.
                  The LSBs contain the boot-time / bypass mode threshold
                  value.
                  The MSBs contain the value for the FIPS / CC compliant mode.
                  See entropy_src documentation for more details.
                  '''
                isdigest: false
                iszer: false
                ismubi: false
                iskeymgr_creator: false
                iskeymgr_owner: false
                inv_default: 0
                offset: 368
              }
              {
                name: CREATOR_SW_CFG_RNG_MARKOV_LO_THRESHOLDS
                size: 4
                desc:
                  '''
                  The Markov health test low thresholds to enable entropy_src
                  with during ROM execution.
                  This must be configured if CREATOR_SW_CFG_RNG_EN is true.
                  The LSBs contain the boot-time / bypass mode threshold
                  value.
                  The MSBs contain the value for the FIPS / CC compliant mode.
                  See entropy_src documentation for more details.
                  '''
                isdigest: false
                iszer: false
                ismubi: false
                iskeymgr_creator: false
                iskeymgr_owner: false
                inv_default: 0
                offset: 372
              }
              {
                name: CREATOR_SW_CFG_RNG_EXTHT_HI_THRESHOLDS
                size: 4
                desc:
                  '''
                  The external health test high thresholds to enable the
                  entropy_src with during ROM execution.
                  This must be configured if CREATOR_SW_CFG_RNG_EN is true.
                  The LSBs contain the boot-time / bypass mode threshold
                  value.
                  The MSBs contain the value for the FIPS / CC compliant mode.
                  See entropy_src documentation for more details.
                  '''
                isdigest: false
                iszer: false
                ismubi: false
                iskeymgr_creator: false
                iskeymgr_owner: false
                inv_default: 0
                offset: 376
              }
              {
                name: CREATOR_SW_CFG_RNG_EXTHT_LO_THRESHOLDS
                size: 4
                desc:
                  '''
                  The external health test low thresholds to enable the
                  entropy_src with during ROM execution.
                  This must be configured if CREATOR_SW_CFG_RNG_EN is true.
                  The LSBs contain the boot-time / bypass mode threshold
                  value.
                  The MSBs contain the value for the FIPS / CC compliant mode.
                  See entropy_src documentation for more details.
                  '''
                isdigest: false
                iszer: false
                ismubi: false
                iskeymgr_creator: false
                iskeymgr_owner: false
                inv_default: 0
                offset: 380
              }
              {
                name: CREATOR_SW_CFG_RNG_BOOT_ALERT_THRESHOLD
                size: 4
                desc:
                  '''
                  The alert threshold to configure the entropy_src with during
                  ROM execution in boot-time / bypass mode.
                  This must be configured if CREATOR_SW_CFG_RNG_EN is true.
                  See entropy_src documentation for more details.
                  '''
                isdigest: false
                iszer: false
                ismubi: false
                iskeymgr_creator: false
                iskeymgr_owner: false
                inv_default: 0
                offset: 384
              }
              {
                name: CREATOR_SW_CFG_RNG_FIPS_ALERT_THRESHOLD
                size: 4
                desc:
                  '''
                  The alert threshold to configure the entropy_src with during
                  ROM execution in FIPS / CC compliant mode.
                  This must be configured if CREATOR_SW_CFG_RNG_EN is true.
                  See entropy_src documentation for more details.
                  '''
                isdigest: false
                iszer: false
                ismubi: false
                iskeymgr_creator: false
                iskeymgr_owner: false
                inv_default: 0
                offset: 388
              }
              {
                name: CREATOR_SW_CFG_RNG_BOOT_CONFIG_DIGEST
                size: 4
                desc:
                  '''
                  A CRC32 digest of the entropy_src configuration above for
                  boot-time / bypass mode.
                  This must be configured if CREATOR_SW_CFG_RNG_EN is true.
                  See entropy_src documentation for more details.
                  '''
                isdigest: false
                iszer: false
                ismubi: false
                iskeymgr_creator: false
                iskeymgr_owner: false
                inv_default: 0
                offset: 392
              }
              {
                name: CREATOR_SW_CFG_RNG_FIPS_CONFIG_DIGEST
                size: 4
                desc:
                  '''
                  A CRC32 digest of the entropy_src configuration above for
                  FIPS / CC compliant mode.
                  This must be configured if CREATOR_SW_CFG_RNG_EN is true.
                  See entropy_src documentation for more details.
                  '''
                isdigest: false
                iszer: false
                ismubi: false
                iskeymgr_creator: false
                iskeymgr_owner: false
                inv_default: 0
                offset: 396
              }
              {
                name: CREATOR_SW_CFG_SRAM_KEY_RENEW_AND_INIT_EN
                size: 4
                desc:
                  '''
                  Whether or not the ROM should request SRAM to be rescrambled
                  with a new key on every boot. This includes renewing the
                  scrambling key and then initializing SRAM with pseudo-random
                  data. kHardenedBoolFalse disables, while all other values
                  enable.
                  '''
                isdigest: false
                iszer: false
                ismubi: false
                iskeymgr_creator: false
                iskeymgr_owner: false
                inv_default: 0
                offset: 400
              }
              {
                name: CREATOR_SW_CFG_IMMUTABLE_ROM_EXT_EN
                size: 4
                desc:
                  '''
                  Enablement of the ROM_EXT immutable code section.
                  A value of kHardenedBoolTrue enables the feature.
                  All other values disable it.
                  '''
                isdigest: false
                iszer: false
                ismubi: false
                iskeymgr_creator: false
                iskeymgr_owner: false
                inv_default: 0
                offset: 404
              }
              {
                name: CREATOR_SW_CFG_IMMUTABLE_ROM_EXT_START_OFFSET
                size: 4
                desc:
                  '''
                  Relative offset from the start of the ROM_EXT slot to
                  find the immutable code section at.
                  '''
                isdigest: false
                iszer: false
                ismubi: false
                iskeymgr_creator: false
                iskeymgr_owner: false
                inv_default: 0
                offset: 408
              }
              {
                name: CREATOR_SW_CFG_IMMUTABLE_ROM_EXT_LENGTH
                size: 4
                desc: Length (in bytes) of the immutable code section.
                isdigest: false
                iszer: false
                ismubi: false
                iskeymgr_creator: false
                iskeymgr_owner: false
                inv_default: 0
                offset: 412
              }
              {
                name: CREATOR_SW_CFG_IMMUTABLE_ROM_EXT_SHA256_HASH
                size: 32
                desc: SHA256 hash of the immutable ROM_EXT section.
                isdigest: false
                iszer: false
                ismubi: false
                iskeymgr_creator: false
                iskeymgr_owner: false
                inv_default: 0
                offset: 416
              }
              {
                name: CREATOR_SW_CFG_DIGEST
                size: 8
                offset: 456
                ismubi: false
                isdigest: true
                iszer: false
                inv_default: 16706844895266615817
                iskeymgr_creator: false
                iskeymgr_owner: false
              }
            ]
            desc:
              '''
              Software configuration partition.
              This is for device-specific calibration data, e.g, clock, LDO, RNG,
              and configuration settings set by the ROM.
              '''
            iskeymgr_creator: false
            iskeymgr_owner: false
            zeroizable: false
            ignore_read_lock_in_rma: false
            size: 400
            offset: 64
          }
          {
            name: OWNER_SW_CFG
            variant: Unbuffered
            absorb: true
            secret: false
            sw_digest: true
            hw_digest: false
            write_lock: Digest
            read_lock: CSR
            key_sel: NoKey
            integrity: true
            bkout_type: false
            items:
            [
              {
                name: OWNER_SW_CFG_ROM_ERROR_REPORTING
                size: 4
                desc:
                  '''
                  The shutdown error reporting verbosity used by the ROM.
                  Should be configured to one of several
                  `shutdown_error_redact_t` values. See
                  `sw/device/silicon_creator/lib/shutdown.h` for more details.
                  '''
                isdigest: false
                iszer: false
                ismubi: false
                iskeymgr_creator: false
                iskeymgr_owner: false
                inv_default: 0
                offset: 464
              }
              {
                name: OWNER_SW_CFG_ROM_BOOTSTRAP_DIS
                size: 4
                desc:
                  '''
                  Whether or not to disable ROM bootstrap mechanism. A value
                  of kHardenedBoolTrue disable bootstrap mechanism in the ROM,
                  while all other values enable it. Note, the provisioning
                  flow should take care when to program this field if it is
                  used by a SKU, as there is no way to get firmware into flash
                  in a PROD LC state if a valid ROM_EXT does not already exist
                  in flash once this value is configured to true.
                  '''
                isdigest: false
                iszer: false
                ismubi: false
                iskeymgr_creator: false
                iskeymgr_owner: false
                inv_default: 0
                offset: 468
              }
              {
                name: OWNER_SW_CFG_ROM_ALERT_CLASS_EN
                size: 4
                desc:
                  '''
                  A four byte packed field, where each byte controls whether
                  or not the ROM enables each alert class (A through D) of the
                  alert_handler. The byte-sized subfields are arranged from D
                  to A, MSB to LSB. Each byte should be set to an
                  `alert_enable_t` value accordingly. See the alert_handler
                  documentation for more details.
                  '''
                isdigest: false
                iszer: false
                ismubi: false
                iskeymgr_creator: false
                iskeymgr_owner: false
                inv_default: 0
                offset: 472
              }
              {
                name: OWNER_SW_CFG_ROM_ALERT_ESCALATION
                size: 4
                desc:
                  '''
                  A four byte packed field, where each byte controls the
                  escalation configuration for each alert class (A through D)
                  of the alert_handler configured by the ROM. The byte-sized
                  subfields are arranged from D to A, MSB to LSB. Each byte
                  should be set to an `alert_escalate_t` value accordingly.
                  See the alert_handler documentation for more details.
                  '''
                isdigest: false
                iszer: false
                ismubi: false
                iskeymgr_creator: false
                iskeymgr_owner: false
                inv_default: 0
                offset: 476
              }
              {
                name: OWNER_SW_CFG_ROM_ALERT_CLASSIFICATION
                size: 320
                desc:
                  '''
                  The alert classifications (A through D) for each alert
                  source of the alert_handler to be configured by the ROM. The
                  field consists of a contiguous 320-byte block, or 80 32-bit
                  words. The four bytes in each word encode the configuration
                  of a single alert source across four lifecycle states, in
                  order from LSB to MSB: PROD, PROD_END, DEV, and RMA. Each
                  byte should be set to an `alert_class_t` value accordingly.
                  The order of the 80 32-bit words, from LSB to MSB can be
                  found in the EARLGREY_ALERTS list in `rules/const.bzl`.
                  See the alert_handler documentation for more details.
                  '''
                isdigest: false
                iszer: false
                ismubi: false
                iskeymgr_creator: false
                iskeymgr_owner: false
                inv_default: 0
                offset: 480
              }
              {
                name: OWNER_SW_CFG_ROM_LOCAL_ALERT_CLASSIFICATION
                size: 64
                desc:
                  '''
                  Same as the `OWNER_SW_CFG_ROM_ALERT_CLASSIFICATION` field,
                  except these configuration correspond to the local alert
                  sources found in the `EARLGREY_LOC_ALERTS list in
                  `rules/const.bzl`.
                  '''
                isdigest: false
                iszer: false
                ismubi: false
                iskeymgr_creator: false
                iskeymgr_owner: false
                inv_default: 0
                offset: 800
              }
              {
                name: OWNER_SW_CFG_ROM_ALERT_ACCUM_THRESH
                size: 16
                desc:
                  '''
                  The alert accumulation threshold values for each alert class
                  (A through D) of the alert_handler to be configured by the
                  ROM. This field consists of four 32-bit words encoding the
                  accumulation thresholds for each alert class A through D
                  arranged LSW to MSW. See the alert_handler documentation for
                  more details.
                  '''
                isdigest: false
                iszer: false
                ismubi: false
                iskeymgr_creator: false
                iskeymgr_owner: false
                inv_default: 0
                offset: 864
              }
              {
                name: OWNER_SW_CFG_ROM_ALERT_TIMEOUT_CYCLES
                size: 16
                desc:
                  '''
                  Same as the `OWNER_SW_CFG_ROM_ALERT_ACCUM_THRESH` field,
                  except each value corresponds to the interrupt timeout
                  configuration of an alert class.
                  '''
                isdigest: false
                iszer: false
                ismubi: false
                iskeymgr_creator: false
                iskeymgr_owner: false
                inv_default: 0
                offset: 880
              }
              {
                name: OWNER_SW_CFG_ROM_ALERT_PHASE_CYCLES
                size: 64
                desc:
                  '''
                  The alert escalation phase durations, measured in clock
                  cycles, the ROM will configure the four alert phases for
                  each alert class of the alert_handler. This field consists
                  of a contiguous 64-byte block, or an array of four 128-bit
                  fields. Each 128-bit subfield encodes four 32-bit words that
                  contain the alert phase cycle count configurations for alert
                  escalation phases 0 to 3, from LSW to MSW. Each 128-bit
                  subfield is contains all configurations for a single alert
                  class, arranged from class A to D, from LS to MS. For
                  example, the cycle durations of each escalation phase in
                  this field should be configured as such, from LSB to MSB:
                  <classA,phase0>...<classA,phase3>...<classD,phase0>...
                  <classD,phase3>. See the alert_handler documentation for
                  more details.
                  '''
                isdigest: false
                iszer: false
                ismubi: false
                iskeymgr_creator: false
                iskeymgr_owner: false
                inv_default: 0
                offset: 896
              }
              {
                name: OWNER_SW_CFG_ROM_ALERT_DIGEST_PROD
                size: 4
                desc:
                  '''
                  The expected CRC32 digest over all of the alert_handler
                  configurations set up by the ROM for a device operating in
                  the PROD LC state. The ROM reads this field and checks it
                  against a digest it computes over the alert_handler
                  configuration it programmed. This field is expected to be
                  automatically computed by the `otp_alert_digest()` Bazel
                  rule. See the `alert_config_crc32()` function in the
                  SiliconCreator alert_handler driver for more details on what
                  configurations are included in this digest.
                  '''
                isdigest: false
                iszer: false
                ismubi: false
                iskeymgr_creator: false
                iskeymgr_owner: false
                inv_default: 0
                offset: 960
              }
              {
                name: OWNER_SW_CFG_ROM_ALERT_DIGEST_PROD_END
                size: 4
                desc:
                  '''
                  Same as the `OWNER_SW_CFG_ROM_ALERT_DIGEST_PROD` field,
                  except the expected digest is for chips operating in the
                  PROD_END LC state.
                  '''
                isdigest: false
                iszer: false
                ismubi: false
                iskeymgr_creator: false
                iskeymgr_owner: false
                inv_default: 0
                offset: 964
              }
              {
                name: OWNER_SW_CFG_ROM_ALERT_DIGEST_DEV
                size: 4
                desc:
                  '''
                  Same as the `OWNER_SW_CFG_ROM_ALERT_DIGEST_PROD` field,
                  except the expected digest is for chips operating in the
                  DEV LC state.
                  '''
                isdigest: false
                iszer: false
                ismubi: false
                iskeymgr_creator: false
                iskeymgr_owner: false
                inv_default: 0
                offset: 968
              }
              {
                name: OWNER_SW_CFG_ROM_ALERT_DIGEST_RMA
                size: 4
                desc:
                  '''
                  Same as the `OWNER_SW_CFG_ROM_ALERT_DIGEST_PROD` field,
                  except the expected digest is for chips operating in the
                  RMA LC state.
                  '''
                isdigest: false
                iszer: false
                ismubi: false
                iskeymgr_creator: false
                iskeymgr_owner: false
                inv_default: 0
                offset: 972
              }
              {
                name: OWNER_SW_CFG_ROM_WATCHDOG_BITE_THRESHOLD_CYCLES
                size: 4
                desc: Watchdog timer bite threshold (in cycles) configured by the ROM.
                isdigest: false
                iszer: false
                ismubi: false
                iskeymgr_creator: false
                iskeymgr_owner: false
                inv_default: 0
                offset: 976
              }
              {
                name: OWNER_SW_CFG_ROM_KEYMGR_OTP_MEAS_EN
                size: 4
                desc:
                  '''
                  Whether or not to configure the attestation SW binding CSRs
                  of the keymgr with the value in ROM_EXT manifest or the
                  measurement of the OTP CreatorSwCfg, OwnerSwCfg, and
                  secure boot key integrity digest. A value of
                  kHardenedBoolTrue uses the ROM computed OTP measurements,
                  while all other values trigger the use of the binding values
                  included in the ROM_EXT manifest.
                  '''
                isdigest: false
                iszer: false
                ismubi: false
                iskeymgr_creator: false
                iskeymgr_owner: false
                inv_default: 0
                offset: 980
              }
              {
                name: OWNER_SW_CFG_MANUF_STATE
                size: 4
                desc:
                  '''
                  Manufacturing state binding field. For use by
                  SiliconCreators or SiliconOwners to bind BL0 images to a
                  specific device or set of devices.
                  '''
                isdigest: false
                iszer: false
                ismubi: false
                iskeymgr_creator: false
                iskeymgr_owner: false
                inv_default: 0
                offset: 984
              }
              {
                name: OWNER_SW_CFG_ROM_RSTMGR_INFO_EN
                size: 4
                desc:
                  '''
                  A two byte packed word that indicates the expected rstmgr
                  alert and CPU info dump enable states, configured in the
                  rstmgr's ALERT_INFO_CTRL and CPU_INFO_CTRL CSRs respectively.
                  The expected format of this fields is
                  {0,0,kHardenedBool*,kHardenedBool*}, read MSB to LSB, where
                  the left most kHardenedBool* entry indicates the expected
                  enablement state of the ALERT_INFO_CTRL, and the right most
                  indicates the enablement state of the CPU_INFO_CTRL. Since
                  the ROM expects both to be disabled upon handing over
                  execution control to the ROM_EXT, this entire OTP field
                  **should be left unprovisioned, or set to all 0**.
                  '''
                isdigest: false
                iszer: false
                ismubi: false
                iskeymgr_creator: false
                iskeymgr_owner: false
                inv_default: 0
                offset: 988
              }
              {
                name: OWNER_SW_CFG_ROM_EXT_BOOTSTRAP_EN
                size: 4
                desc: Unused. Set to 0.
                isdigest: false
                iszer: false
                ismubi: false
                iskeymgr_creator: false
                iskeymgr_owner: false
                inv_default: 0
                offset: 992
              }
              {
                name: OWNER_SW_CFG_ROM_SENSOR_CTRL_ALERT_CFG
                size: 12
                desc:
                  '''
                  Alert configuration values for the sensor_ctrl block
                  that will be configured by the ROM. This field is 12 bytes
                  long, where each byte contains two 4-bit packed subfields,
                  encoding two four bit boolean values (kMultiBitBool4False or
                  kMultiBitBool4True), as follows (read MSB to LSB):
                  {fatality, enablement}. For example, the byte 0x69 would
                  encode the alert is: 1) recoverable, and 2) disabled.

                  Currently, there are only 11 alerts in sensor_ctrl to
                  configure, thus only the least significant bytes in this
                  field are used.
                  '''
                isdigest: false
                iszer: false
                ismubi: false
                iskeymgr_creator: false
                iskeymgr_owner: false
                inv_default: 0
                offset: 996
              }
              {
                name: OWNER_SW_CFG_ROM_SRAM_READBACK_EN
                size: 4
                desc:
                  '''
                  This field encodes the enablements of the readback security
                  features for the main and retention SRAMs to be configured
                  by the ROM. This field is four bytes, but the LSB contains
                  two 4-bit packed kMultiBitBool4* values that indicate the
                  enablement of the feature for the retention SRAM and
                  main SRAM, from MSB to LSB respectively. See the READBACK
                  CSR of the sram_ctrl for more details on this feature.
                  '''
                isdigest: false
                iszer: false
                ismubi: false
                iskeymgr_creator: false
                iskeymgr_owner: false
                inv_default: 0
                offset: 1008
              }
              {
                name: OWNER_SW_CFG_ROM_PRESERVE_RESET_REASON_EN
                size: 4
                desc:
                  '''
                  Whether or not the ROM should preserve the reset reasons CSR
                  state in the rstmgr, or clear it. A value of
                  kHardenedBoolTrue preserves the CSR, while other values
                  trigger the ROM to clear the CSR after copying the reason to
                  the retention SRAM.
                  '''
                isdigest: false
                iszer: false
                ismubi: false
                iskeymgr_creator: false
                iskeymgr_owner: false
                inv_default: 0
                offset: 1012
              }
              {
                name: OWNER_SW_CFG_ROM_RESET_REASON_CHECK_VALUE
                size: 4
                desc:
                  '''
                  Two packed 16-bit values that indicate whether the ROM
                  should perform a validation check on the the reset reasons
                  during boot. The validation check is a hardening mechanism
                  that checks the reset reasons for consistency at two
                  different points in time. Both packed values should be the
                  same. Values of kHardenedBoolFalse will instruct the ROM to
                  skip the reset reasons validation check, while all other
                  values will instruct the ROM to perform the check.
                  '''
                isdigest: false
                iszer: false
                ismubi: false
                iskeymgr_creator: false
                iskeymgr_owner: false
                inv_default: 0
                offset: 1016
              }
              {
                name: OWNER_SW_CFG_ROM_BANNER_EN
                size: 4
                desc:
                  '''
                  Whether or not the ROM should print a banner message to the
                  console UART during boot. A value of kHardenedBoolFalse
                  disables the message printing, while all other values enable
                  it.
                  '''
                isdigest: false
                iszer: false
                ismubi: false
                iskeymgr_creator: false
                iskeymgr_owner: false
                inv_default: 0
                offset: 1020
              }
              {
                name: OWNER_SW_CFG_ROM_NVM_ECC_EXC_HANDLER_EN
                size: 4
                desc:
                  '''
                  Whether or not the ROM should use the NVM (flash or RRAM)
                  ECC exception handler during execution. A value of
                  kHardenedBoolTrue allows the ROM to use the exception
                  handler that recovers gracefully and continues the boot
                  process if an NVM ECC error is encountered during
                  verification of a specific ROM_EXT slot. This enables the
                  ROM to attempt booting the next ROM_EXT slot if the first
                  slot attempted has been corrupted. All other values
                  trigger default ROM exception handling, which is all
                  exceptions trigger a chip shutdown and reset.
                  '''
                isdigest: false
                iszer: false
                ismubi: false
                iskeymgr_creator: false
                iskeymgr_owner: false
                inv_default: 0
                offset: 1024
              }
              {
                name: OWNER_SW_CFG_RESERVED
                size: 96
                desc:
                  '''
                  Unused bits in the OWNER_SW_CFG OTP partition. These can be
                  claimed by software as needed.
                  '''
                isdigest: false
                iszer: false
                ismubi: false
                iskeymgr_creator: false
                iskeymgr_owner: false
                inv_default: 0
                offset: 1028
              }
              {
                name: OWNER_SW_CFG_DIGEST
                size: 8
                offset: 1136
                ismubi: false
                isdigest: true
                iszer: false
                inv_default: 11638191378943044423
                iskeymgr_creator: false
                iskeymgr_owner: false
              }
            ]
            desc:
              '''
              Software configuration partition.
              This contains data that changes software behavior in the ROM, for
              example enabling defensive features in ROM or selecting failure
              modes if verification fails.
              '''
            iskeymgr_creator: false
            iskeymgr_owner: false
            zeroizable: false
            ignore_read_lock_in_rma: false
            size: 680
            offset: 464
          }
          {
            name: ROT_CREATOR_AUTH_CODESIGN
            variant: Unbuffered
            absorb: false
            secret: false
            sw_digest: true
            hw_digest: false
            write_lock: Digest
            read_lock: CSR
            key_sel: NoKey
            integrity: true
            bkout_type: false
            items:
            [
              {
                name: ROT_CREATOR_AUTH_CODESIGN_ECDSA_KEY_TYPE0
                size: 4
                isdigest: false
                iszer: false
                ismubi: false
                iskeymgr_creator: false
                iskeymgr_owner: false
                inv_default: 0
                offset: 1144
              }
              {
                name: ROT_CREATOR_AUTH_CODESIGN_ECDSA_KEY0
                size: 64
                isdigest: false
                iszer: false
                ismubi: false
                iskeymgr_creator: false
                iskeymgr_owner: false
                inv_default: 0
                offset: 1148
              }
              {
                name: ROT_CREATOR_AUTH_CODESIGN_ECDSA_KEY_TYPE1
                size: 4
                isdigest: false
                iszer: false
                ismubi: false
                iskeymgr_creator: false
                iskeymgr_owner: false
                inv_default: 0
                offset: 1212
              }
              {
                name: ROT_CREATOR_AUTH_CODESIGN_ECDSA_KEY1
                size: 64
                isdigest: false
                iszer: false
                ismubi: false
                iskeymgr_creator: false
                iskeymgr_owner: false
                inv_default: 0
                offset: 1216
              }
              {
                name: ROT_CREATOR_AUTH_CODESIGN_ECDSA_KEY_TYPE2
                size: 4
                isdigest: false
                iszer: false
                ismubi: false
                iskeymgr_creator: false
                iskeymgr_owner: false
                inv_default: 0
                offset: 1280
              }
              {
                name: ROT_CREATOR_AUTH_CODESIGN_ECDSA_KEY2
                size: 64
                isdigest: false
                iszer: false
                ismubi: false
                iskeymgr_creator: false
                iskeymgr_owner: false
                inv_default: 0
                offset: 1284
              }
              {
                name: ROT_CREATOR_AUTH_CODESIGN_ECDSA_KEY_TYPE3
                size: 4
                isdigest: false
                iszer: false
                ismubi: false
                iskeymgr_creator: false
                iskeymgr_owner: false
                inv_default: 0
                offset: 1348
              }
              {
                name: ROT_CREATOR_AUTH_CODESIGN_ECDSA_KEY3
                size: 64
                isdigest: false
                iszer: false
                ismubi: false
                iskeymgr_creator: false
                iskeymgr_owner: false
                inv_default: 0
                offset: 1352
              }
              {
                name: ROT_CREATOR_AUTH_CODESIGN_SPX_KEY_TYPE0
                size: 4
                isdigest: false
                iszer: false
                ismubi: false
                iskeymgr_creator: false
                iskeymgr_owner: false
                inv_default: 0
                offset: 1416
              }
              {
                name: ROT_CREATOR_AUTH_CODESIGN_SPX_KEY0
                size: 32
                isdigest: false
                iszer: false
                ismubi: false
                iskeymgr_creator: false
                iskeymgr_owner: false
                inv_default: 0
                offset: 1420
              }
              {
                name: ROT_CREATOR_AUTH_CODESIGN_SPX_KEY_CONFIG0
                size: 4
                isdigest: false
                iszer: false
                ismubi: false
                iskeymgr_creator: false
                iskeymgr_owner: false
                inv_default: 0
                offset: 1452
              }
              {
                name: ROT_CREATOR_AUTH_CODESIGN_SPX_KEY_TYPE1
                size: 4
                isdigest: false
                iszer: false
                ismubi: false
                iskeymgr_creator: false
                iskeymgr_owner: false
                inv_default: 0
                offset: 1456
              }
              {
                name: ROT_CREATOR_AUTH_CODESIGN_SPX_KEY1
                size: 32
                isdigest: false
                iszer: false
                ismubi: false
                iskeymgr_creator: false
                iskeymgr_owner: false
                inv_default: 0
                offset: 1460
              }
              {
                name: ROT_CREATOR_AUTH_CODESIGN_SPX_KEY_CONFIG1
                size: 4
                isdigest: false
                iszer: false
                ismubi: false
                iskeymgr_creator: false
                iskeymgr_owner: false
                inv_default: 0
                offset: 1492
              }
              {
                name: ROT_CREATOR_AUTH_CODESIGN_SPX_KEY_TYPE2
                size: 4
                isdigest: false
                iszer: false
                ismubi: false
                iskeymgr_creator: false
                iskeymgr_owner: false
                inv_default: 0
                offset: 1496
              }
              {
                name: ROT_CREATOR_AUTH_CODESIGN_SPX_KEY2
                size: 32
                isdigest: false
                iszer: false
                ismubi: false
                iskeymgr_creator: false
                iskeymgr_owner: false
                inv_default: 0
                offset: 1500
              }
              {
                name: ROT_CREATOR_AUTH_CODESIGN_SPX_KEY_CONFIG2
                size: 4
                isdigest: false
                iszer: false
                ismubi: false
                iskeymgr_creator: false
                iskeymgr_owner: false
                inv_default: 0
                offset: 1532
              }
              {
                name: ROT_CREATOR_AUTH_CODESIGN_SPX_KEY_TYPE3
                size: 4
                isdigest: false
                iszer: false
                ismubi: false
                iskeymgr_creator: false
                iskeymgr_owner: false
                inv_default: 0
                offset: 1536
              }
              {
                name: ROT_CREATOR_AUTH_CODESIGN_SPX_KEY3
                size: 32
                isdigest: false
                iszer: false
                ismubi: false
                iskeymgr_creator: false
                iskeymgr_owner: false
                inv_default: 0
                offset: 1540
              }
              {
                name: ROT_CREATOR_AUTH_CODESIGN_SPX_KEY_CONFIG3
                size: 4
                isdigest: false
                iszer: false
                ismubi: false
                iskeymgr_creator: false
                iskeymgr_owner: false
                inv_default: 0
                offset: 1572
              }
              {
                name: ROT_CREATOR_AUTH_CODESIGN_BLOCK_SHA2_256_HASH
                size: 32
                isdigest: false
                iszer: false
                ismubi: false
                iskeymgr_creator: false
                iskeymgr_owner: false
                inv_default: 0
                offset: 1576
              }
              {
                name: ROT_CREATOR_AUTH_CODESIGN_DIGEST
                size: 8
                offset: 1608
                ismubi: false
                isdigest: true
                iszer: false
                inv_default: 1662255584663227314
                iskeymgr_creator: false
                iskeymgr_owner: false
              }
            ]
            desc:
              '''
              This OTP partition is used to store four P-256 keys
              and four Sphincs+ keys. The partition requires 464
              bytes of software visible storage. The partition is
              locked at manufacturing time to protect against
              malicious write attempts.
              '''
            iskeymgr_creator: false
            iskeymgr_owner: false
            zeroizable: false
            ignore_read_lock_in_rma: false
            size: 472
            offset: 1144
          }
          {
            name: ROT_CREATOR_AUTH_STATE
            variant: Unbuffered
            absorb: false
            secret: false
            sw_digest: true
            hw_digest: false
            write_lock: Digest
            read_lock: CSR
            key_sel: NoKey
            integrity: true
            bkout_type: false
            items:
            [
              {
                name: ROT_CREATOR_AUTH_STATE_ECDSA_KEY0
                size: 4
                isdigest: false
                iszer: false
                ismubi: false
                iskeymgr_creator: false
                iskeymgr_owner: false
                inv_default: 0
                offset: 1616
              }
              {
                name: ROT_CREATOR_AUTH_STATE_ECDSA_KEY1
                size: 4
                isdigest: false
                iszer: false
                ismubi: false
                iskeymgr_creator: false
                iskeymgr_owner: false
                inv_default: 0
                offset: 1620
              }
              {
                name: ROT_CREATOR_AUTH_STATE_ECDSA_KEY2
                size: 4
                isdigest: false
                iszer: false
                ismubi: false
                iskeymgr_creator: false
                iskeymgr_owner: false
                inv_default: 0
                offset: 1624
              }
              {
                name: ROT_CREATOR_AUTH_STATE_ECDSA_KEY3
                size: 4
                isdigest: false
                iszer: false
                ismubi: false
                iskeymgr_creator: false
                iskeymgr_owner: false
                inv_default: 0
                offset: 1628
              }
              {
                name: ROT_CREATOR_AUTH_STATE_SPX_KEY0
                size: 4
                isdigest: false
                iszer: false
                ismubi: false
                iskeymgr_creator: false
                iskeymgr_owner: false
                inv_default: 0
                offset: 1632
              }
              {
                name: ROT_CREATOR_AUTH_STATE_SPX_KEY1
                size: 4
                isdigest: false
                iszer: false
                ismubi: false
                iskeymgr_creator: false
                iskeymgr_owner: false
                inv_default: 0
                offset: 1636
              }
              {
                name: ROT_CREATOR_AUTH_STATE_SPX_KEY2
                size: 4
                isdigest: false
                iszer: false
                ismubi: false
                iskeymgr_creator: false
                iskeymgr_owner: false
                inv_default: 0
                offset: 1640
              }
              {
                name: ROT_CREATOR_AUTH_STATE_SPX_KEY3
                size: 4
                isdigest: false
                iszer: false
                ismubi: false
                iskeymgr_creator: false
                iskeymgr_owner: false
                inv_default: 0
                offset: 1644
              }
              {
                name: ROT_CREATOR_AUTH_STATE_DIGEST
                size: 8
                offset: 1648
                ismubi: false
                isdigest: true
                iszer: false
                inv_default: 4965525511854572725
                iskeymgr_creator: false
                iskeymgr_owner: false
              }
            ]
            desc:
              '''
              This OTP partition is used to capture the state of
              each key slot. Each key can be in one of the
              following states: BLANK, ENABLED, DISABLED. The
              encoded values are such that transitions between
              BLANK -> ENABLED ->  DISABLED are possible without
              causing ECC errors (this is a mechanism similar to
              how we manage life cycle state transitions). The
              partition is left unlocked to allow STATE updates in
              the field. The ROM_EXT is required to lock access to
              the OTP Direct Access Interface to prevent DoS
              attacks from malicious code executing on Silicon
              Owner partitions. DAI write locking is available in
              EarlGrey.
              '''
            iskeymgr_creator: false
            iskeymgr_owner: false
            zeroizable: false
            ignore_read_lock_in_rma: false
            size: 40
            offset: 1616
          }
          {
            name: HW_CFG0
            variant: Buffered
            secret: false
            sw_digest: false
            hw_digest: true
            write_lock: Digest
            read_lock: None
            key_sel: NoKey
            integrity: true
            bkout_type: true
            skip_sw_header: true
            items:
            [
              {
                name: DEVICE_ID
                size: 32
                inv_default: 101994044936824639612461447164778906738787223995885395958442779952147640154081
                desc:
                  '''
                  Unique device identifier that is always exposed through the
                  lifecycle JTAG tap. See OpenTitan documentation on Device
                  Identifiers.
                  '''
                isdigest: false
                iszer: false
                ismubi: false
                iskeymgr_creator: false
                iskeymgr_owner: false
                offset: 1656
              }
              {
                name: MANUF_STATE
                size: 32
                inv_default: 73732138675274264303788256961686404944759477002619436661173137973430400193623
                desc:
                  '''
                  Field to capture manufacturing status. Currently unused. Set
                  to 0.
                  '''
                isdigest: false
                iszer: false
                ismubi: false
                iskeymgr_creator: false
                iskeymgr_owner: false
                offset: 1688
              }
              {
                name: HW_CFG0_DIGEST
                size: 8
                offset: 1720
                ismubi: false
                isdigest: true
                iszer: false
                inv_default: 1301679241270694456
                iskeymgr_creator: false
                iskeymgr_owner: false
              }
            ]
            desc:
              '''
              Hardware configuration 0 partition.
              This contains a device identifier and manufacturing state.
              '''
            absorb: false
            iskeymgr_creator: false
            iskeymgr_owner: false
            zeroizable: false
            ignore_read_lock_in_rma: false
            size: 72
            offset: 1656
          }
          {
            name: HW_CFG1
            variant: Buffered
            secret: false
            sw_digest: false
            hw_digest: true
            write_lock: Digest
            read_lock: None
            key_sel: NoKey
            integrity: true
            bkout_type: true
            skip_sw_header: true
            items:
            [
              {
                name: EN_SRAM_IFETCH
                size: 1
                ismubi: true
                inv_default: 105
                desc:
                  '''
                  Enablement of execute from SRAM switch in the sram_ctrl (see
                  EXEC CSR). A kMultiBitBool8True value enables, while all
                  other values disable.
                  '''
                isdigest: false
                iszer: false
                iskeymgr_creator: false
                iskeymgr_owner: false
                offset: 1728
              }
              {
                name: EN_CSRNG_SW_APP_READ
                size: 1
                ismubi: true
                inv_default: 105
                desc:
                  '''
                  Enablement of CSRNG software application interface. A
                  kMultiBitBool8True value enables, while all other values
                  disable. Enablement is required to extract output from
                  CSRNG via software.
                  '''
                isdigest: false
                iszer: false
                iskeymgr_creator: false
                iskeymgr_owner: false
                offset: 1729
              }
              {
                name: DIS_RV_DM_LATE_DEBUG
                size: 1
                ismubi: true
                inv_default: 105
                desc:
                  '''
                  Disablement of RV_DM late debug feature (see rv_dm
                  documentation). A kMultiBitBool8True disables the late debug
                  feature and renders the rv_dm fully ungated in DEV lifecycle
                  states. All other values gate rv_dm reachability based on
                  the value of LATE_DEBUG_ENABLE CSR in the rv_dm block.
                  '''
                isdigest: false
                iszer: false
                iskeymgr_creator: false
                iskeymgr_owner: false
                offset: 1730
              }
              {
                name: HW_CFG1_DIGEST
                size: 8
                offset: 1736
                ismubi: false
                isdigest: true
                iszer: false
                inv_default: 3220671226818894432
                iskeymgr_creator: false
                iskeymgr_owner: false
              }
            ]
            desc:
              '''
              Hardware configuration 1 partition.
              This contains several hardware feature switches.
              '''
            absorb: false
            iskeymgr_creator: false
            iskeymgr_owner: false
            zeroizable: false
            ignore_read_lock_in_rma: false
            size: 16
            offset: 1728
          }
          {
            name: SECRET0
            variant: Buffered
            secret: true
            sw_digest: false
            hw_digest: true
            write_lock: Digest
            read_lock: Digest
            ignore_read_lock_in_rma: true
            key_sel: Secret0Key
            integrity: true
            bkout_type: false
            skip_sw_header: true
            items:
            [
              {
                name: TEST_UNLOCK_TOKEN
                inv_default: 232795746524822262786724684828264059333
                size: 16
                isdigest: false
                iszer: false
                ismubi: false
                iskeymgr_creator: false
                iskeymgr_owner: false
                offset: 1744
              }
              {
                name: TEST_EXIT_TOKEN
                inv_default: 230748029623541578864187550162391519735
                size: 16
                isdigest: false
                iszer: false
                ismubi: false
                iskeymgr_creator: false
                iskeymgr_owner: false
                offset: 1760
              }
              {
                name: SECRET0_DIGEST
                size: 8
                offset: 1776
                ismubi: false
                isdigest: true
                iszer: false
                inv_default: 9984016280323298770
                iskeymgr_creator: false
                iskeymgr_owner: false
              }
            ]
            desc:
              '''
              Secret partition 0.
              This contains TEST lifecycle unlock tokens.
              '''
            absorb: false
            iskeymgr_creator: false
            iskeymgr_owner: false
            zeroizable: false
            size: 40
            offset: 1744
          }
          {
            name: SECRET1
            variant: Buffered
            secret: true
            sw_digest: false
            hw_digest: true
            write_lock: Digest
            read_lock: Digest
            ignore_read_lock_in_rma: true
            key_sel: Secret1Key
            integrity: true
            bkout_type: false
            skip_sw_header: true
            items:
            [
              {
                name: NVM_ADDR_KEY_SEED
                inv_default: 114154205722399252869850894030766882783782099707479450552335841877429576047902
                size: 32
                isdigest: false
                iszer: false
                ismubi: false
                iskeymgr_creator: false
                iskeymgr_owner: false
                offset: 1784
              }
              {
                name: NVM_DATA_KEY_SEED
                inv_default: 42760053834267273387871423107414336620784207480021495990050142110767371612573
                size: 32
                isdigest: false
                iszer: false
                ismubi: false
                iskeymgr_creator: false
                iskeymgr_owner: false
                offset: 1816
              }
              {
                name: SRAM_DATA_KEY_SEED
                inv_default: 135837942677254952990104010255834134273
                size: 16
                isdigest: false
                iszer: false
                ismubi: false
                iskeymgr_creator: false
                iskeymgr_owner: false
                offset: 1848
              }
              {
                name: SECRET1_DIGEST
                size: 8
                offset: 1864
                ismubi: false
                isdigest: true
                iszer: false
                inv_default: 5286285299921024260
                iskeymgr_creator: false
                iskeymgr_owner: false
              }
            ]
            desc:
              '''
              Secret partition 1.
              This contains SRAM and NVM scrambling keys.
              '''
            absorb: false
            iskeymgr_creator: false
            iskeymgr_owner: false
            zeroizable: false
            size: 88
            offset: 1784
          }
          {
            name: SECRET2
            variant: Buffered
            secret: true
            sw_digest: false
            hw_digest: true
            write_lock: Digest
            read_lock: Digest
            ignore_read_lock_in_rma: true
            key_sel: Secret2Key
            integrity: true
            bkout_type: false
            skip_sw_header: true
            items:
            [
              {
                name: RMA_TOKEN
                inv_default: 334671433878751700697199779069205613746
                size: 16
                isdigest: false
                iszer: false
                ismubi: false
                iskeymgr_creator: false
                iskeymgr_owner: false
                offset: 1872
              }
              {
                name: CREATOR_ROOT_KEY_SHARE0
                inv_default: 44567343500516902319007325717195865352697728552885620263692795830659649726468
                size: 32
                iskeymgr_creator: true
                isdigest: false
                iszer: false
                ismubi: false
                iskeymgr_owner: false
                offset: 1888
              }
              {
                name: CREATOR_ROOT_KEY_SHARE1
                inv_default: 60522346507929435416391309954626740383218998467738884573186599633244939263479
                size: 32
                iskeymgr_creator: true
                isdigest: false
                iszer: false
                ismubi: false
                iskeymgr_owner: false
                offset: 1920
              }
              {
                name: SECRET2_DIGEST
                size: 8
                offset: 1952
                ismubi: false
                isdigest: true
                iszer: false
                inv_default: 8058422133488400218
                iskeymgr_creator: false
                iskeymgr_owner: false
              }
            ]
            desc:
              '''
              Secret partition 2.
              This contains RMA unlock token, creator root key, and creator seed.
              '''
            absorb: false
            iskeymgr_creator: true
            iskeymgr_owner: false
            zeroizable: false
            size: 88
            offset: 1872
          }
          {
            name: LIFE_CYCLE
            variant: LifeCycle
            secret: false
            sw_digest: false
            hw_digest: false
            write_lock: None
            read_lock: None
            key_sel: NoKey
            integrity: true
            bkout_type: false
            skip_sw_header: true
            items:
            [
              {
                name: LC_TRANSITION_CNT
                inv_default: 15714797660047341488534127627579808491169430382015215327234153171472129925346611664487816925151944674070104822711062
                size: 48
                isdigest: false
                iszer: false
                ismubi: false
                iskeymgr_creator: false
                iskeymgr_owner: false
                offset: 1960
              }
              {
                name: LC_STATE
                inv_default: 865483628382388783833486223527103700372238712096558284441157138736665418385845619121574525406131
                size: 40
                isdigest: false
                iszer: false
                ismubi: false
                iskeymgr_creator: false
                iskeymgr_owner: false
                offset: 2008
              }
            ]
            desc:
              '''
              Lifecycle partition.
              This contains lifecycle transition count and state. This partition
              cannot be locked since the life cycle state needs to advance to RMA
              in-field. Note that while this partition is not marked secret, it
              is not readable nor writeable via the DAI. Only the LC controller
              can access this partition, and even via the LC controller it is not
              possible to read the raw manufacturing life cycle state in encoded
              form, since that encoding is considered a netlist secret. The LC
              controller only exposes a decoded version of this state.
              '''
            absorb: false
            iskeymgr_creator: false
            iskeymgr_owner: false
            zeroizable: false
            ignore_read_lock_in_rma: false
            size: 88
            offset: 1960
          }
        ]
      }
    }
    {
      name: lc_ctrl
      type: lc_ctrl
      base_addrs:
      {
        regs:
        {
          hart: 0x40140000
        }
      }
      memory: {}
      param_list:
      [
        {
          name: RndCnstLcKeymgrDivInvalid
          desc: Diversification value used for all invalid life cycle states.
          type: lc_ctrl_pkg::lc_keymgr_div_t
          randcount: 128
          randtype: data
          name_top: RndCnstLcCtrlLcKeymgrDivInvalid
          default: 0x569397bfc41976ac86b02bf2b89be21
          randwidth: 128
        }
        {
          name: RndCnstLcKeymgrDivTestUnlocked
          desc: Diversification value used for the TEST_UNLOCKED* life cycle states.
          type: lc_ctrl_pkg::lc_keymgr_div_t
          randcount: 128
          randtype: data
          name_top: RndCnstLcCtrlLcKeymgrDivTestUnlocked
          default: 0x8eced8859f464d1d910540eec6ba0486
          randwidth: 128
        }
        {
          name: RndCnstLcKeymgrDivDev
          desc: Diversification value used for the DEV life cycle state.
          type: lc_ctrl_pkg::lc_keymgr_div_t
          randcount: 128
          randtype: data
          name_top: RndCnstLcCtrlLcKeymgrDivDev
          default: 0xf07cffaf7b8b9213bd8dc7b927797c09
          randwidth: 128
        }
        {
          name: RndCnstLcKeymgrDivProduction
          desc: Diversification value used for the PROD/PROD_END life cycle states.
          type: lc_ctrl_pkg::lc_keymgr_div_t
          randcount: 128
          randtype: data
          name_top: RndCnstLcCtrlLcKeymgrDivProduction
          default: 0xdfeaf1272b92abc409056cfa513aed0d
          randwidth: 128
        }
        {
          name: RndCnstLcKeymgrDivRma
          desc: Diversification value used for the RMA life cycle state.
          type: lc_ctrl_pkg::lc_keymgr_div_t
          randcount: 128
          randtype: data
          name_top: RndCnstLcCtrlLcKeymgrDivRma
          default: 0xe2186c2b2a4874e4adaca4c6809e571b
          randwidth: 128
        }
        {
          name: RndCnstInvalidTokens
          desc: Compile-time random bits used for invalid tokens in the token mux
          type: lc_ctrl_pkg::lc_token_mux_t
          randcount: 1024
          randtype: data
          name_top: RndCnstLcCtrlInvalidTokens
          default: 0x351756bf8d18e24be7e1c96737b726a4c6f04993b3e6aae70f22aaf748b57c320264e157e2c74a28033261ee6cec10075c55a820f842d43ee1ab1b3d78f992d223469898eb2afe18de121f1e164eac29042563ae4733313ad2696788a8735b27982f5007a24a125f876c9ca6ddeb52ac92f5600d2a41bc465efe57aa3b59bd6b
          randwidth: 1024
        }
      ]
    }
    {
      name: alert_handler
      type: alert_handler
      base_addrs:
      {
        null:
        {
          hart: 0x40150000
        }
      }
      memory: {}
      param_list:
      [
        {
          name: RndCnstLfsrSeed
          desc: Compile-time random bits for initial LFSR seed
          type: alert_handler_pkg::lfsr_seed_t
          randcount: 32
          randtype: data
          name_top: RndCnstAlertHandlerLfsrSeed
          default: 0xa402163
          randwidth: 32
        }
        {
          name: RndCnstLfsrPerm
          desc: Compile-time random permutation for LFSR output
          type: alert_handler_pkg::lfsr_perm_t
          randcount: 32
          randtype: perm
          name_top: RndCnstAlertHandlerLfsrPerm
          default: 0xcdbeea7bb1c7369808d553c85b9dab94f430050c
          randwidth: 160
        }
      ]
      template_type: alert_handler
    }
    {
      name: sram_ctrl_ret
      type: sram_ctrl
      base_addrs:
      {
        regs:
        {
          hart: 0x40500000
        }
        ram:
        {
          hart: 0x40600000
        }
      }
      memory:
      {
        ram:
        {
          label: ram_ret_aon
          swaccess: rw
          data_intg_passthru: "true"
          exec: True
          byte_write: True
          size: 0x1000
        }
      }
      param_list:
      [
        {
          name: RndCnstSramKey
          desc: Compile-time random reset value for SRAM scrambling key.
          type: otp_ctrl_pkg::sram_key_t
          randcount: 128
          randtype: data
          name_top: RndCnstSramCtrlRetSramKey
          default: 0x5e456f3b26d15f5584bb9879bd249785
          randwidth: 128
        }
        {
          name: RndCnstSramNonce
          desc: Compile-time random reset value for SRAM scrambling nonce.
          type: otp_ctrl_pkg::sram_nonce_t
          randcount: 128
          randtype: data
          name_top: RndCnstSramCtrlRetSramNonce
          default: 0x2c23d0fa289c3348ce364ed534970e1f
          randwidth: 128
        }
        {
          name: RndCnstLfsrSeed
          desc: Compile-time random bits for initial LFSR seed
          type: sram_ctrl_pkg::lfsr_seed_t
          randcount: 64
          randtype: data
          name_top: RndCnstSramCtrlRetLfsrSeed
          default: 0xd45ec606be134fc0
          randwidth: 64
        }
        {
          name: RndCnstLfsrPerm
          desc: Compile-time random permutation for LFSR output
          type: sram_ctrl_pkg::lfsr_perm_t
          randcount: 64
          randtype: perm
          name_top: RndCnstSramCtrlRetLfsrPerm
          default: 0xb716fd895f8eba6c21018c91ee7936a68fcbd735d35a5487adf70de78414d1a1493faa8320476304c799dc2f2c2af1a0
          randwidth: 384
        }
      ]
    }
    {
      name: rram_ctrl
      type: rram_ctrl
      base_addrs:
      {
        core:
        {
          hart: 0x41010000
        }
        host:
        {
          hart: 0x30000000
        }
      }
      memory:
      {
        host:
        {
          label: rram
          swaccess: ro
          data_intg_passthru: "true"
          exec: True
          byte_write: False
          size: 0x200000
        }
      }
      param_list:
      [
        {
          name: RndCnstAddrKey
          desc: Compile-time random bits for default address key
          type: rram_ctrl_pkg::rram_key_t
          randcount: 128
          randtype: data
          name_top: RndCnstRramCtrlAddrKey
          default: 0xeee27cfa19ea576ca8a8225c8e17053e
          randwidth: 128
        }
        {
          name: RndCnstDataKey
          desc: Compile-time random bits for default data key
          type: rram_ctrl_pkg::rram_key_t
          randcount: 128
          randtype: data
          name_top: RndCnstRramCtrlDataKey
          default: 0x44b68dd7822a6859f2cf52a55fd181b0
          randwidth: 128
        }
        {
          name: RndCnstAllSeeds
          desc: Compile-time random bits for default seeds
          type: rram_ctrl_pkg::all_seeds_t
          randcount: 512
          randtype: data
          name_top: RndCnstRramCtrlAllSeeds
          default: 0x82d03c583756f11aa5b37f9544c4aa90eb97e1c0f8086f627a281c5681d6566641eecccc88876ad113c50ad1be4d94dce8fca54128a3860ae1d3493fbef6b9ba
          randwidth: 512
        }
        {
          name: RndCnstLfsrSeed
          desc: Compile-time random bits for initial LFSR seed
          type: rram_ctrl_pkg::lfsr_seed_t
          randcount: 64
          randtype: data
          name_top: RndCnstRramCtrlLfsrSeed
          default: 0x5dfe4463a4615ef4
          randwidth: 64
        }
        {
          name: RndCnstLfsrPerm
          desc: Compile-time random permutation for LFSR output
          type: rram_ctrl_pkg::lfsr_perm_t
          randcount: 64
          randtype: perm
          name_top: RndCnstRramCtrlLfsrPerm
          default: 0x4041e76e2e74bc2a21f8a3b58e43c0b7f45cc73ac1c8bf5720ced44f6dde0d5b38812e8db9d146f2625a7d6c2a969619
          randwidth: 384
        }
      ]
    }
    {
      name: aes
      type: aes
      base_addrs:
      {
        null:
        {
          hart: 0x41100000
        }
      }
      memory: {}
      param_list:
      [
        {
          name: RndCnstClearingLfsrSeed
          desc: Default seed of the PRNG used for register clearing.
          type: aes_pkg::clearing_lfsr_seed_t
          randcount: 64
          randtype: data
          name_top: RndCnstAesClearingLfsrSeed
          default: 0xb4ba169a6cd82fad
          randwidth: 64
        }
        {
          name: RndCnstClearingLfsrPerm
          desc: Permutation applied to the LFSR of the PRNG used for clearing.
          type: aes_pkg::clearing_lfsr_perm_t
          randcount: 64
          randtype: perm
          name_top: RndCnstAesClearingLfsrPerm
          default: 0xa8006d986b0aff3ac5bd23e29fdf9c83764cd8b9577545848480e3d1e6b51f8371255f32e98edb3b97d392e090c29a11
          randwidth: 384
        }
        {
          name: RndCnstClearingSharePerm
          desc: Permutation applied to the clearing PRNG output for clearing the second share of registers.
          type: aes_pkg::clearing_lfsr_perm_t
          randcount: 64
          randtype: perm
          name_top: RndCnstAesClearingSharePerm
          default: 0xddea700ac773fa8d404e769664e2092e0522b52566d3f3113ca62faa55c490617b6cde0342eac7c7af6307973c7f6872
          randwidth: 384
        }
        {
          name: RndCnstMaskingLfsrSeed
          desc: Default seed of the PRNG used for masking.
          type: aes_pkg::masking_lfsr_seed_t
          randcount: 288
          randtype: data
          name_top: RndCnstAesMaskingLfsrSeed
          default: 0xfcedcf2832a66ceacf8ed4d5b616177dd43b56fa754e1f53ad658193b563d9bdc6d2aee8
          randwidth: 288
        }
        {
          name: RndCnstMaskingLfsrPerm
          desc: Permutation applied to the output of the PRNG used for masking.
          type: aes_pkg::masking_lfsr_perm_t
          randcount: 160
          randtype: perm
          name_top: RndCnstAesMaskingLfsrPerm
          default: 0x6b5e1b0f8836111d5f9c436212605d66704a4f8e7f86422894211046352c3b1531335a2a4e7d03822498302704642906474177503d442e3780618c591c17237c7e0567583f890e408f97001e53073e789d019e9f0c3c0a9995020913924d56683990169b8b49385b0b6a187b691f932f450883320d2d4c637219878d2665555485577a1a762296258481752b915c748a20796e9a6d344b146c516f3a71735248
          randwidth: 1280
        }
      ]
    }
    {
      name: kmac
      type: kmac
      base_addrs:
      {
        null:
        {
          hart: 0x41120000
        }
      }
      memory: {}
      param_list:
      [
        {
          name: RndCnstLfsrSeed
          desc: Compile-time random data for PRNG default seed
          type: kmac_pkg::lfsr_seed_t
          randcount: 288
          randtype: data
          name_top: RndCnstKmacLfsrSeed
          default: 0xffaff9760f5e838bd8e2413ab956b106ca7139a07effee457dee82b6e06663c291739ff
          randwidth: 288
        }
        {
          name: RndCnstLfsrPerm
          desc: Compile-time random permutation for PRNG output
          type: kmac_pkg::lfsr_perm_t
          randcount: 800
          randtype: perm
          name_top: RndCnstKmacLfsrPerm
          default: 0x3e00a0169fb2307079798431c1b24c985d555e314ae1f294acb2c7b78000189af02eecc1017c6edca14a793abc1f5d7b9d4a8d9aa434b2332fe9904d4b15464da10d9feb96f061da607d90231ce27a135b6a8260da8f0454fe500c16cc01375598c34b0329a9149711ada7004d0a119194d0d13f470474996cd7c0f81160686882185351420c2b2b9856014748c8e6b8435983d8d06f945e88cd3573552b8cd44b9885a6ce1a0533e4b91519b200a096a77251bf6242f1d9f9c78d6a52402cd7b96de93a0ed5e1b2c16ab2dc89b11ed832aa762d2a58fc4b5fc1c9ea5bb0b0413cbe1c663438c3848a112095890b30521b4c775a8e3604a1de65c5eb56f1439f9ab8a19db06ee212d46c479215ee8a49ac74c3bf05fa0cd9b55013b21a920e58aad93fae80d1955c09b5e9eb724f6a270ab60197c23fbff06825ef06a9bc3dd3484403393639d1628b0c9a2adb7d175790b7051ba42391d60f8e84f662f5a4c964ce6a9188756c03402c7a76a1ac5c5b90372a81b47cdf11d5d97107768e3a2940ae815c5ad30071a8712aa72fd3c235585ac815725be998c13d039f54695832672b28f515d8e788e239129829c709a5872d659f124a04e9a4ac99e2695ce60081ff3ae8f12e14c36faa9e2c07138c525d2fc8d0fd150c68c0b2da0e9c879a328f429569509bd035548856577b16fb7954f8e1f4add1c6497e582736d4b8a946e508580857f670ab0b5be510b41fddf846981862b4c414890c0a2d087f5c3693132f66c5d99f8594e590979497d0a14809db0c61a390c3b1f05a499e480e042093b38002964c4b9a5f666cd1809c3dda76526e0b835532b05d4ee3e906c26cf170f34bc44246ac8b859b89ec744b0194517021b88463bdd68afe2f748d02f1046b663026006d2d74e701399cc176f17ceb29524d77249524562ed0961af91e96ba8886a209d7e951248eaa913a035d9b86454cab8b0a178096ac5493154cfba8cab5825628b5822ed60eef6dd849e841979d035642aa4de57d9aa08c501c8a0623eaf8bebd83c2b5de374a80486b9296298a57acd45441a5286971f9bd7c53e256802ea5305ae0b6d9e6a196865ba08e959f5f8ab8c19d6eb9c60e4786a03e557126608997a1d3088c9f8881daf4f219153775a03d0c61e18f28e06431a919ac09050260ac3c4a7602227a9b0889af23862d7dcc83360d9e67bb78db4610ea680648873c0abbb41fb750fbc7c81a824b3c5b9414b119e0762edd896af178c278c3335db882c71a79419d0495d0af0aa6d8dd67a8ddb5c5f6b180c849f21a44216cb6ad0a9ba5e1c42b9688748792791ed1138d38ec8f3be6701128874509aca4132f4bcde7a34ff090cbc654b93dca4454673e7f43d125720144dc20c9bb910dc22db68556364439
          randwidth: 8000
        }
        {
          name: RndCnstBufferLfsrSeed
          desc: Compile-time random data for PRNG buffer default seed
          type: kmac_pkg::buffer_lfsr_seed_t
          randcount: 800
          randtype: data
          name_top: RndCnstKmacBufferLfsrSeed
          default: 0x7b316d6c12ea819870d451dc29ee296da1850be6bed073f6ee870f58b89fabfe08c827837c7867eec58ff573db5aaf6e95644dfad4262a7adb7f05d963e4282ae9ddb8fbe7a138d956ac336341a536f70c3ee90caeae11cb84b65fdc5c702578f9f893c2
          randwidth: 800
        }
        {
          name: RndCnstMsgPerm
          desc: Compile-time random permutation for LFSR Message output
          type: kmac_pkg::msg_perm_t
          randcount: 64
          randtype: perm
          name_top: RndCnstKmacMsgPerm
          default: 0x3d3ac5d24e50a9a523d8b8b34b771b2601169580df391757b3a18805eb70026bfcc8dd619f133df87feea29e15ed9282
          randwidth: 384
        }
      ]
    }
    {
      name: otbn
      type: otbn
      base_addrs:
      {
        null:
        {
          hart: 0x41130000
        }
      }
      memory: {}
      param_list:
      [
        {
          name: RndCnstUrndPrngSeed
          desc: Default seed of the PRNG used for URND.
          type: otbn_pkg::urnd_prng_seed_t
          randcount: 288
          randtype: data
          name_top: RndCnstOtbnUrndPrngSeed
          default: 0x1e398fa71326e77156c7f9f68f102298ab6a1d31ed166a85ea4fd12c45b2868f68727e0e
          randwidth: 288
        }
        {
          name: RndCnstUrndPerm
          desc: Compile-time random permutation applied to the primary URND output, directly after the PRNG and before it is distributed to the rest of the design.
          type: otbn_pkg::urnd_perm_t
          randcount: 389
          randtype: perm
          name_top: RndCnstOtbnUrndPerm
          default: 0xfd2039db25b0760e38621f801791369909f07c693deb64ca7d2eaa1c325222ac643ad5dc8c489f9766b8445dd66d9c88704fc6d3317243781963a0d884fc262f7fcb102c7339fed2fb825dda13270a8c10d4b3011610fb9d1874b4a53c4e49abb570121b59d790567abd2649358544628058cc25e6031d8994c789088dcb6050c1dc76d2d2746e342526c7ae2c09110698646017054951be34d73633e44b766ad87c5d34516610ea04157e660cc6c152503590ea9f61ceeb33e9b9c1402c0c3bc0e6a5505958de459c4b8e9b13b65b4c102208f124807d4af98c2a4a3569c5d1d4556e3d4184e46a712c74a11e994b227deaf25ebda000289111055144701827a3c240a65e3256b745aae45310fa0fbe4d0f6248304a2c467b338a74d7f325ab368f0c0e77f4939057684b82d1c953480aa30d420dab13a8105efa6e919dda32e60a15f54726b2dad5f73506d43818ac454dbbc18de4941aca5be15b09613c93858cc8b281287a4e284795835522840548114cd0c9661b95b2c75053db83b1f9e5fa62ec17219e8276c17ee16555e11d010612bc72c524d3a192081d50ed715d5760014934ceb4522bafadea23caf6ea5995dad8153
          randwidth: 3501
        }
        {
          name: RndCnstBnMacUrndPerm
          desc: Compile-time random permutation for URND permutation in BN MAC.
          type: otbn_pkg::bn_mac_urnd_perm_t
          randcount: 256
          randtype: perm
          name_top: RndCnstOtbnBnMacUrndPerm
          default: 0xc2e533708cf2c04dabcb1602e203a6ae6f05f88f54f52c2f6b931f1cd0b35a7daaa17ee4e96c9cc90cdf87f0b87b914bc1d62ef43965957ca510f348fbfc126e2d6929ba35a4a2404e41f964b7d8a384668d8236ff831d6d0d4c941a017762fdb19000245d09ed49d5e3721737ad1132e0c4313fa7cd8b57e69f85084f0aef2b0652b25f8aa09d23bb741e1988d913dabebccc760b2173de5edd464adb6875b5bdebd1635b5cac9ebfc667f6f138c8b928af7971890e7a80c53c3b476a9634ce510f60c39ac78ecf0714271b5961444215dcfa2a7ff7eed29bca92563ea9263de118048645e8b6b42298308197d45058b0d73ae72025ec43fed3ea559953a878
          randwidth: 2048
        }
        {
          name: RndCnstMaiUrndPerm
          desc: Compile-time random permutation for URND permutation in MAI.
          type: otbn_pkg::mai_urnd_perm_t
          randcount: 389
          randtype: perm
          name_top: RndCnstOtbnMaiUrndPerm
          default: 0x968ea2199406b18626b119dc45c4a4bade4a14c037676411d0d4196e848d1c24eba1a59ea830039be7d13b9da1282d86e057d049743e1a568fd8f6b7b3f23804690ca600742d420aef65516bb164e95d5e2a3c5586c9e080901b847c3882f1918861736f03191d88d1d80e86125fd7d6ad7994886e5021360f875b1468596da13ba5f1826195bce622d78df6724479ef073b560164348022e059871ee8f0349125157f802c99b2a74bd1363888a6a57645d884ab83bf23dd68416ca4eea7609fa6ef2419cea8bdb338c4c95c114d8a023954d847a6c845603c82006e4205b54a1f2e85cd6d48c38198b816388bd225a050e4dafe93c800a6aa7b961ad511d6ce91036251a70a80d285029a49608155863ea984d23392d0005a289d48128a7c4559a5bec5693c0bf57ca191b1a704b744cd573c535e25b76b0d06ca98a897d0c629f9e6c71b518c1861e68d3ab4634e13ef6a444aa56647b9aead2ae0e2f0fef38ace59746768f67a87645e60cb89f22d80a54cb1104a0934d0a815702a81e252f570a575a6cb1a8f022422246778ab1f21dabb6a6256bba007cff6486690db8a4e9eb17be372d86b67582428e09d12f536341ba491f
          randwidth: 3501
        }
        {
          name: RndCnstOtbnKey
          desc: Compile-time random reset value for IMem/DMem scrambling key.
          type: otp_ctrl_pkg::otbn_key_t
          randcount: 128
          randtype: data
          name_top: RndCnstOtbnOtbnKey
          default: 0xb63f28779e797d828390e5e4a8356f89
          randwidth: 128
        }
        {
          name: RndCnstOtbnNonce
          desc: Compile-time random reset value for IMem/DMem scrambling nonce.
          type: otp_ctrl_pkg::otbn_nonce_t
          randcount: 64
          randtype: data
          name_top: RndCnstOtbnOtbnNonce
          default: 0x8ba054399f71aa42
          randwidth: 64
        }
      ]
    }
    {
      name: keymgr_dpe
      type: keymgr_dpe
      base_addrs:
      {
        null:
        {
          hart: 0x41140000
        }
      }
      memory: {}
      param_list:
      [
        {
          name: RndCnstLfsrSeed
          desc: Compile-time random bits for initial LFSR seed
          type: keymgr_dpe_pkg::lfsr_seed_t
          randcount: 64
          randtype: data
          name_top: RndCnstKeymgrDpeLfsrSeed
          default: 0x2d9e391e965d86d2
          randwidth: 64
        }
        {
          name: RndCnstLfsrPerm
          desc: Compile-time random permutation for LFSR output
          type: keymgr_dpe_pkg::lfsr_perm_t
          randcount: 64
          randtype: perm
          name_top: RndCnstKeymgrDpeLfsrPerm
          default: 0xbd62530f948490cfa19f59718aa34f5509a0536fe8f5763b2118e97386ed75fb05d302ae081dce787cc603ceb266b68b
          randwidth: 384
        }
        {
          name: RndCnstRandPerm
          desc: Compile-time random permutation for entropy used in share overriding
          type: keymgr_dpe_pkg::rand_perm_t
          randcount: 32
          randtype: perm
          name_top: RndCnstKeymgrDpeRandPerm
          default: 0x96d48be5b6c30f1a849a1a4a6e405df4de05fe8e
          randwidth: 160
        }
        {
          name: RndCnstRevisionSeed
          desc: Compile-time random bits for revision seed
          type: keymgr_dpe_pkg::seed_t
          randcount: 256
          randtype: data
          name_top: RndCnstKeymgrDpeRevisionSeed
          default: 0xe6a176f8690524580f711f017190e3ed05c573c9aa17b2baf8c063e8eb49c269
          randwidth: 256
        }
        {
          name: RndCnstSoftOutputSeed
          desc: Compile-time random bits for software generation seed
          type: keymgr_dpe_pkg::seed_t
          randcount: 256
          randtype: data
          name_top: RndCnstKeymgrDpeSoftOutputSeed
          default: 0x574c9db581dc4f66c2c27ffc2b8538f539bff9a950aa7944b18fb6b76a1f5b19
          randwidth: 256
        }
        {
          name: RndCnstHardOutputSeed
          desc: Compile-time random bits for hardware generation seed
          type: keymgr_dpe_pkg::seed_t
          randcount: 256
          randtype: data
          name_top: RndCnstKeymgrDpeHardOutputSeed
          default: 0x8205a32959fdfb30be24ebca241ced0af4217e01a53f2be7fcbe75780dadec2
          randwidth: 256
        }
        {
          name: RndCnstAesSeed
          desc: Compile-time random bits for generation seed when aes destination selected
          type: keymgr_dpe_pkg::seed_t
          randcount: 256
          randtype: data
          name_top: RndCnstKeymgrDpeAesSeed
          default: 0xb1fa0110731127a1203a94fa13d41e2435278bb8c68210d73cdb0fb6651c2b1a
          randwidth: 256
        }
        {
          name: RndCnstKmacSeed
          desc: Compile-time random bits for generation seed when kmac destination selected
          type: keymgr_dpe_pkg::seed_t
          randcount: 256
          randtype: data
          name_top: RndCnstKeymgrDpeKmacSeed
          default: 0x6b5bf1f83c73fb08e172a7c85ee09eef847866fe33518ffbb881946db7319ec4
          randwidth: 256
        }
        {
          name: RndCnstOtbnSeed
          desc: Compile-time random bits for generation seed when otbn destination selected
          type: keymgr_dpe_pkg::seed_t
          randcount: 256
          randtype: data
          name_top: RndCnstKeymgrDpeOtbnSeed
          default: 0xfb2d8de353cf8ad74c66d60d2f5f466e8ed1afb0e2242c05ce59e25589d988f
          randwidth: 256
        }
        {
          name: RndCnstHmacSeed
          desc: Compile-time random bits for generation seed when hmac destination selected
          type: keymgr_dpe_pkg::seed_t
          randcount: 256
          randtype: data
          name_top: RndCnstKeymgrDpeHmacSeed
          default: 0x6a009a41c3ada4b6638d11c522f5567ac7cf280b9cd698b69ba2dde544d44b57
          randwidth: 256
        }
        {
          name: RndCnstNoneSeed
          desc: Compile-time random bits for generation seed when no destination selected
          type: keymgr_dpe_pkg::seed_t
          randcount: 256
          randtype: data
          name_top: RndCnstKeymgrDpeNoneSeed
          default: 0xb9f70dc71cebe05683e275945dd3db223c4ce7217b90b94e354e9ba1f613995e
          randwidth: 256
        }
      ]
    }
    {
      name: csrng
      type: csrng
      base_addrs:
      {
        null:
        {
          hart: 0x41150000
        }
      }
      memory: {}
      param_list:
      [
        {
          name: RndCnstCsKeymgrDivNonProduction
          desc: Compile-time random bits for csrng state group diversification value
          type: csrng_pkg::cs_keymgr_div_t
          randcount: 384
          randtype: data
          name_top: RndCnstCsrngCsKeymgrDivNonProduction
          default: 0x87db8dd9443dbc2fa7345f784b982902e3d2405388c4bdf5ebf9aff6d30a8fcd52677df9d787cf3807946824d2f97b69
          randwidth: 384
        }
        {
          name: RndCnstCsKeymgrDivProduction
          desc: Compile-time random bits for csrng state group diversification value
          type: csrng_pkg::cs_keymgr_div_t
          randcount: 384
          randtype: data
          name_top: RndCnstCsrngCsKeymgrDivProduction
          default: 0xcab42de4aadb2248723232922a7b25ab26360f6052daf7efe374061fbbe322c363cf8f00f756386d2b4ac4f7f372a7
          randwidth: 384
        }
      ]
    }
    {
      name: sram_ctrl_main
      type: sram_ctrl
      base_addrs:
      {
        regs:
        {
          hart: 0x411C0000
        }
        ram:
        {
          hart: 0x10000000
        }
      }
      memory:
      {
        ram:
        {
          label: ram_main
          swaccess: rw
          data_intg_passthru: "true"
          exec: True
          byte_write: True
          size: 0x20000
        }
      }
      param_list:
      [
        {
          name: RndCnstSramKey
          desc: Compile-time random reset value for SRAM scrambling key.
          type: otp_ctrl_pkg::sram_key_t
          randcount: 128
          randtype: data
          name_top: RndCnstSramCtrlMainSramKey
          default: 0x58430b4cac616998706f55ac8e64e9f7
          randwidth: 128
        }
        {
          name: RndCnstSramNonce
          desc: Compile-time random reset value for SRAM scrambling nonce.
          type: otp_ctrl_pkg::sram_nonce_t
          randcount: 128
          randtype: data
          name_top: RndCnstSramCtrlMainSramNonce
          default: 0x73ac82c002b16ed77bd24bb043ffb8cb
          randwidth: 128
        }
        {
          name: RndCnstLfsrSeed
          desc: Compile-time random bits for initial LFSR seed
          type: sram_ctrl_pkg::lfsr_seed_t
          randcount: 64
          randtype: data
          name_top: RndCnstSramCtrlMainLfsrSeed
          default: 0xad0b4fe59a4156db
          randwidth: 64
        }
        {
          name: RndCnstLfsrPerm
          desc: Compile-time random permutation for LFSR output
          type: sram_ctrl_pkg::lfsr_perm_t
          randcount: 64
          randtype: perm
          name_top: RndCnstSramCtrlMainLfsrPerm
          default: 0x4878f6542d10d79e8f2cae3353bf7eb9cc59461a4888131b243624de5c3c4ddfe75dfaea9af6ad7b214658036c384a20
          randwidth: 384
        }
      ]
    }
    {
      name: sram_ctrl_sec
      type: sram_ctrl
      base_addrs:
      {
        regs:
        {
          hart: 0x411D0000
        }
        ram:
        {
          hart: 0x10020000
        }
      }
      memory:
      {
        ram:
        {
          label: ram_secondary
          swaccess: rw
          data_intg_passthru: "true"
          exec: True
          byte_write: True
          size: 0x10000
        }
      }
      param_list:
      [
        {
          name: RndCnstSramKey
          desc: Compile-time random reset value for SRAM scrambling key.
          type: otp_ctrl_pkg::sram_key_t
          randcount: 128
          randtype: data
          name_top: RndCnstSramCtrlSecSramKey
          default: 0x11c4ae133235825a401bfa016cc4a93f
          randwidth: 128
        }
        {
          name: RndCnstSramNonce
          desc: Compile-time random reset value for SRAM scrambling nonce.
          type: otp_ctrl_pkg::sram_nonce_t
          randcount: 128
          randtype: data
          name_top: RndCnstSramCtrlSecSramNonce
          default: 0xb1ee33c032db4f6d29f259d4cdc771b0
          randwidth: 128
        }
        {
          name: RndCnstLfsrSeed
          desc: Compile-time random bits for initial LFSR seed
          type: sram_ctrl_pkg::lfsr_seed_t
          randcount: 64
          randtype: data
          name_top: RndCnstSramCtrlSecLfsrSeed
          default: 0xd1443241da610711
          randwidth: 64
        }
        {
          name: RndCnstLfsrPerm
          desc: Compile-time random permutation for LFSR output
          type: sram_ctrl_pkg::lfsr_perm_t
          randcount: 64
          randtype: perm
          name_top: RndCnstSramCtrlSecLfsrPerm
          default: 0xcfd53f1340cf2e48888764e9072558d5c263e77bd216c9515993ba5e8438ba01fcb5faca0269fe6c27aaec6c0c37169d
          randwidth: 384
        }
      ]
    }
    {
      name: rom_ctrl
      type: rom_ctrl
      base_addrs:
      {
        rom:
        {
          hart: 0x00040000
        }
        regs:
        {
          hart: 0x411e0000
        }
      }
      memory:
      {
        rom:
        {
          label: rom
          swaccess: ro
          data_intg_passthru: True
          exec: True
          byte_write: False
          size: 0x30000
        }
      }
      param_list:
      [
        {
          name: RndCnstScrNonce
          desc: Fixed nonce used for address / data scrambling
          type: bit [63:0]
          randcount: 64
          randtype: data
          name_top: RndCnstRomCtrlScrNonce
          default: 0x96fe3cf57804edb4
          randwidth: 64
        }
        {
          name: RndCnstScrKey
          desc: Randomised constant used as a scrambling key for ROM data
          type: bit [127:0]
          randcount: 128
          randtype: data
          name_top: RndCnstRomCtrlScrKey
          default: 0x1d6bd5fff4193f7e9e16595813a32883
          randwidth: 128
        }
      ]
    }
    {
      name: rv_core_ibex
      type: rv_core_ibex
      base_addrs:
      {
        cfg:
        {
          hart: 0x411F0000
        }
      }
      memory: {}
      param_list:
      [
        {
          name: RndCnstLfsrSeed
          desc: Default seed of the PRNG used for random instructions.
          type: ibex_pkg::lfsr_seed_t
          randcount: 32
          randtype: data
          name_top: RndCnstRvCoreIbexLfsrSeed
          default: 0x4b115639
          randwidth: 32
        }
        {
          name: RndCnstLfsrPerm
          desc: Permutation applied to the LFSR of the PRNG used for random instructions.
          type: ibex_pkg::lfsr_perm_t
          randcount: 32
          randtype: perm
          name_top: RndCnstRvCoreIbexLfsrPerm
          default: 0x58ce833e5bff6209b21a112b9b17cd4b838e2af4
          randwidth: 160
        }
        {
          name: RndCnstIbexKey
          desc: Default icache scrambling key
          type: logic [ibex_pkg::SCRAMBLE_KEY_W-1:0]
          randcount: 128
          randtype: data
          name_top: RndCnstRvCoreIbexIbexKey
          default: 0x17534bdcbc618a44dd79860bffdb12e2
          randwidth: 128
        }
        {
          name: RndCnstIbexNonce
          desc: Default icache scrambling nonce
          type: logic [ibex_pkg::SCRAMBLE_NONCE_W-1:0]
          randcount: 64
          randtype: data
          name_top: RndCnstRvCoreIbexIbexNonce
          default: 0x57b4a856b1b654e7
          randwidth: 64
        }
      ]
      template_type: rv_core_ibex
    }
    {
      name: sram_ctrl_meta
      type: sram_ctrl
      base_addrs:
      {
        regs:
        {
          hart: 0x411A0000
        }
        ram:
        {
          hart: 0x11000000
        }
      }
      memory:
      {
        ram:
        {
          label: ram_cheriot_meta
          swaccess: rw
          data_intg_passthru: "true"
          exec: false
          byte_write: False
          size: 0x9800
        }
      }
      param_list:
      [
        {
          name: RndCnstSramKey
          desc: Compile-time random reset value for SRAM scrambling key.
          type: otp_ctrl_pkg::sram_key_t
          randcount: 128
          randtype: data
          name_top: RndCnstSramCtrlMetaSramKey
          default: 0xda6dae072969978b9dfeb84fddd8d62b
          randwidth: 128
        }
        {
          name: RndCnstSramNonce
          desc: Compile-time random reset value for SRAM scrambling nonce.
          type: otp_ctrl_pkg::sram_nonce_t
          randcount: 128
          randtype: data
          name_top: RndCnstSramCtrlMetaSramNonce
          default: 0xb3f0be0f4e808303769110e8ddeab5a4
          randwidth: 128
        }
        {
          name: RndCnstLfsrSeed
          desc: Compile-time random bits for initial LFSR seed
          type: sram_ctrl_pkg::lfsr_seed_t
          randcount: 64
          randtype: data
          name_top: RndCnstSramCtrlMetaLfsrSeed
          default: 0xe64a4b8db8d8049
          randwidth: 64
        }
        {
          name: RndCnstLfsrPerm
          desc: Compile-time random permutation for LFSR output
          type: sram_ctrl_pkg::lfsr_perm_t
          randcount: 64
          randtype: perm
          name_top: RndCnstSramCtrlMetaLfsrPerm
          default: 0xc9418d9c541a10c75c5824b39b6babb01de5c4a8991e9b5787a8f80ef80eed17c9d552ead3f23ee7003c6def58a0f4e4
          randwidth: 384
        }
      ]
    }
  ]
}
