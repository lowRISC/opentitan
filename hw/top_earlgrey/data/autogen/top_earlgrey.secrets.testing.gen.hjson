// Copyright lowRISC contributors (OpenTitan project).
// Licensed under the Apache License, Version 2.0, see LICENSE for details.
// SPDX-License-Identifier: Apache-2.0
//
// ------------------- W A R N I N G: A U T O - G E N E R A T E D   C O D E !! -------------------//
// PLEASE DO NOT HAND-EDIT THIS FILE. IT HAS BEEN AUTO-GENERATED WITH THE FOLLOWING COMMAND:
// util/topgen.py -t hw/top_earlgrey/data/top_earlgrey.hjson
//                -o hw/top_earlgrey/
{
  seed:
  {
    topgen_seed:
    {
      seed_mode: testing
      value: 29644012399843606761155865046213904595566399179946856377972331600428548641958
    }
    otp_img_seed:
    {
      seed_mode: testing
      value: 52408960416235844780753299194502148156786072650816676092165912261205302331741
    }
    lc_ctrl_seed:
    {
      seed_mode: testing
      value: 40182201019264397688411770949626922549663256047001778394918990008320537410392
    }
  }
  module:
  [
    {
      name: otp_ctrl
      type: otp_ctrl
      base_addrs:
      {
        core:
        {
          hart: 0x40130000
        }
      }
      memory: {}
      param_list:
      [
        {
          name: RndCnstLfsrSeed
          desc: Compile-time random bits for initial LFSR seed
          type: otp_ctrl_top_specific_pkg::lfsr_seed_t
          randcount: 40
          randtype: data
          name_top: RndCnstOtpCtrlLfsrSeed
          default: 0x427b4599f8
          randwidth: 40
        }
        {
          name: RndCnstLfsrPerm
          desc: Compile-time random permutation for LFSR output
          type: otp_ctrl_top_specific_pkg::lfsr_perm_t
          randcount: 40
          randtype: perm
          name_top: RndCnstOtpCtrlLfsrPerm
          default: 0x85e1180905da15371b0d43c835654939266390180a9671c688c9807dd44b
          randwidth: 240
        }
        {
          name: RndCnstScrmblKeyInit
          desc: Compile-time random permutation for scrambling key/nonce register reset value
          type: otp_ctrl_top_specific_pkg::scrmbl_key_init_t
          randcount: 256
          randtype: data
          name_top: RndCnstOtpCtrlScrmblKeyInit
          default: 0x818aece8773ad6da66db3a3fe58ac30b5338893806975a2f0db4a2da26a43814
          randwidth: 256
        }
        {
          name: RndCnstScrmblKey0
          desc: Compile-time scrambling key
          type: otp_ctrl_top_specific_pkg::key_t
          randcount: 128
          randtype: extdata
          name_top: RndCnstOtpCtrlScrmblKey0
          default: 0xf9089cf2787c6c14b7d1a6c0618e831f
          randwidth: 128
        }
        {
          name: RndCnstScrmblKey1
          desc: Compile-time scrambling key
          type: otp_ctrl_top_specific_pkg::key_t
          randcount: 128
          randtype: extdata
          name_top: RndCnstOtpCtrlScrmblKey1
          default: 0xc8129e7a4149ba2831fe2e9fb3b2a1d2
          randwidth: 128
        }
        {
          name: RndCnstScrmblKey2
          desc: Compile-time scrambling key
          type: otp_ctrl_top_specific_pkg::key_t
          randcount: 128
          randtype: extdata
          name_top: RndCnstOtpCtrlScrmblKey2
          default: 0x5254f861ba80f82b303da30635aa3d3a
          randwidth: 128
        }
        {
          name: RndCnstDigestConst0
          desc: Compile-time digest const
          type: otp_ctrl_top_specific_pkg::digest_const_t
          randcount: 128
          randtype: extdata
          name_top: RndCnstOtpCtrlDigestConst0
          default: 0xd82dedcd5992c873952d50c51d21f7f8
          randwidth: 128
        }
        {
          name: RndCnstDigestConst1
          desc: Compile-time digest const
          type: otp_ctrl_top_specific_pkg::digest_const_t
          randcount: 128
          randtype: extdata
          name_top: RndCnstOtpCtrlDigestConst1
          default: 0xeec8b17cecd698405b3a0ca29bb023a1
          randwidth: 128
        }
        {
          name: RndCnstDigestConst2
          desc: Compile-time digest const
          type: otp_ctrl_top_specific_pkg::digest_const_t
          randcount: 128
          randtype: extdata
          name_top: RndCnstOtpCtrlDigestConst2
          default: 0x77f2691ca25411ffdb94d43c33bb7
          randwidth: 128
        }
        {
          name: RndCnstDigestConst3
          desc: Compile-time digest const
          type: otp_ctrl_top_specific_pkg::digest_const_t
          randcount: 128
          randtype: extdata
          name_top: RndCnstOtpCtrlDigestConst3
          default: 0xfd3e0171cf89fbb6926e44555b0747b
          randwidth: 128
        }
        {
          name: RndCnstDigestIV0
          desc: Compile-time digest initial vector
          type: otp_ctrl_top_specific_pkg::digest_iv_t
          randcount: 64
          randtype: extdata
          name_top: RndCnstOtpCtrlDigestIV0
          default: 0x87f0d5ee2b8b9db7
          randwidth: 64
        }
        {
          name: RndCnstDigestIV1
          desc: Compile-time digest initial vector
          type: otp_ctrl_top_specific_pkg::digest_iv_t
          randcount: 64
          randtype: extdata
          name_top: RndCnstOtpCtrlDigestIV1
          default: 0xf7b70f0cb345c05
          randwidth: 64
        }
        {
          name: RndCnstDigestIV2
          desc: Compile-time digest initial vector
          type: otp_ctrl_top_specific_pkg::digest_iv_t
          randcount: 64
          randtype: extdata
          name_top: RndCnstOtpCtrlDigestIV2
          default: 0x21bac589dfad65ac
          randwidth: 64
        }
        {
          name: RndCnstDigestIV3
          desc: Compile-time digest initial vector
          type: otp_ctrl_top_specific_pkg::digest_iv_t
          randcount: 64
          randtype: extdata
          name_top: RndCnstOtpCtrlDigestIV3
          default: 0xae8a6546f21bc8cf
          randwidth: 64
        }
        {
          name: RndCnstPartInvDefault
          desc: OTP invalid partition default for buffered partitions
          type: logic [16511:0]
          randcount: 16512
          randtype: extdata
          name_top: RndCnstOtpCtrlPartInvDefault
          default:
          [
            {
              size: 704
              items:
              [
                {
                  size: 320
                  inv_default: 186402203868873673160243174477532200584683723204874444823768914221879417048680339050270326481588
                }
                {
                  size: 384
                  inv_default: 36547239814968950675270266603718710860199702009457479176296663812534718147950124049968618911279337152360497595145434
                }
              ]
            }
            {
              size: 768
              items:
              [
                {
                  size: 64
                  inv_default: 0
                }
                {
                  size: 64
                  inv_default: 17692002389534325074
                }
                {
                  size: 256
                  inv_default: 97190113357435963470420612739456405550306030654118370004629633772295722868751
                }
                {
                  size: 256
                  inv_default: 25107113002565718362972229369406712307077327505567871892018373178413397358952
                }
                {
                  size: 128
                  inv_default: 67987365774749943300313112008098328447
                }
              ]
            }
            {
              size: 768
              items:
              [
                {
                  size: 64
                  inv_default: 0
                }
                {
                  size: 64
                  inv_default: 4056023092994342650
                }
                {
                  size: 128
                  inv_default: 114818820390911932356426594040990850415
                }
                {
                  size: 256
                  inv_default: 38285182093252413091650582675640097466814488494417681634384456313350941441436
                }
                {
                  size: 256
                  inv_default: 45553222205375505531056818163346296644806755634554894226675216589506912023402
                }
              ]
            }
            {
              size: 384
              items:
              [
                {
                  size: 64
                  inv_default: 0
                }
                {
                  size: 64
                  inv_default: 8467910270735405
                }
                {
                  size: 128
                  inv_default: 202583796664497922322878020928417080390
                }
                {
                  size: 128
                  inv_default: 250497149396770327952206041105615885168
                }
              ]
            }
            {
              size: 128
              items:
              [
                {
                  size: 64
                  inv_default: 16103824935462190277
                }
                {
                  comment: unallocated space
                  size: 40
                  inv_default: 0
                }
                {
                  size: 8
                  inv_default: 105
                }
                {
                  size: 8
                  inv_default: 105
                }
                {
                  size: 8
                  inv_default: 105
                }
              ]
            }
            {
              size: 576
              items:
              [
                {
                  size: 64
                  inv_default: 6236140243366831054
                }
                {
                  size: 256
                  inv_default: 10571946878513046603237907431809190521408891965256924791572121351254888273028
                }
                {
                  size: 256
                  inv_default: 55530846908657555531706223372618995525581232455492676800790901459534844803547
                }
              ]
            }
            {
              size: 320
              items:
              [
                {
                  size: 64
                  inv_default: 9901336721023614529
                }
                {
                  size: 32
                  inv_default: 0
                }
                {
                  size: 32
                  inv_default: 0
                }
                {
                  size: 32
                  inv_default: 0
                }
                {
                  size: 32
                  inv_default: 0
                }
                {
                  size: 32
                  inv_default: 0
                }
                {
                  size: 32
                  inv_default: 0
                }
                {
                  size: 32
                  inv_default: 0
                }
                {
                  size: 32
                  inv_default: 0
                }
              ]
            }
            {
              size: 3776
              items:
              [
                {
                  size: 64
                  inv_default: 11160556988759673749
                }
                {
                  size: 256
                  inv_default: 0
                }
                {
                  size: 32
                  inv_default: 0
                }
                {
                  size: 256
                  inv_default: 0
                }
                {
                  size: 32
                  inv_default: 0
                }
                {
                  size: 32
                  inv_default: 0
                }
                {
                  size: 256
                  inv_default: 0
                }
                {
                  size: 32
                  inv_default: 0
                }
                {
                  size: 32
                  inv_default: 0
                }
                {
                  size: 256
                  inv_default: 0
                }
                {
                  size: 32
                  inv_default: 0
                }
                {
                  size: 32
                  inv_default: 0
                }
                {
                  size: 256
                  inv_default: 0
                }
                {
                  size: 32
                  inv_default: 0
                }
                {
                  size: 512
                  inv_default: 0
                }
                {
                  size: 32
                  inv_default: 0
                }
                {
                  size: 512
                  inv_default: 0
                }
                {
                  size: 32
                  inv_default: 0
                }
                {
                  size: 512
                  inv_default: 0
                }
                {
                  size: 32
                  inv_default: 0
                }
                {
                  size: 512
                  inv_default: 0
                }
                {
                  size: 32
                  inv_default: 0
                }
              ]
            }
            {
              size: 5376
              items:
              [
                {
                  size: 64
                  inv_default: 17626243154800067267
                }
                {
                  comment: unallocated space
                  size: 32
                  inv_default: 0
                }
                {
                  size: 768
                  inv_default: 0
                }
                {
                  size: 32
                  inv_default: 0
                }
                {
                  size: 32
                  inv_default: 0
                }
                {
                  size: 32
                  inv_default: 0
                }
                {
                  size: 32
                  inv_default: 0
                }
                {
                  size: 32
                  inv_default: 0
                }
                {
                  size: 96
                  inv_default: 0
                }
                {
                  size: 32
                  inv_default: 0
                }
                {
                  size: 32
                  inv_default: 0
                }
                {
                  size: 32
                  inv_default: 0
                }
                {
                  size: 32
                  inv_default: 0
                }
                {
                  size: 32
                  inv_default: 0
                }
                {
                  size: 32
                  inv_default: 0
                }
                {
                  size: 32
                  inv_default: 0
                }
                {
                  size: 32
                  inv_default: 0
                }
                {
                  size: 32
                  inv_default: 0
                }
                {
                  size: 512
                  inv_default: 0
                }
                {
                  size: 128
                  inv_default: 0
                }
                {
                  size: 128
                  inv_default: 0
                }
                {
                  size: 512
                  inv_default: 0
                }
                {
                  size: 2560
                  inv_default: 0
                }
                {
                  size: 32
                  inv_default: 0
                }
                {
                  size: 32
                  inv_default: 0
                }
                {
                  size: 32
                  inv_default: 0
                }
                {
                  size: 32
                  inv_default: 0
                }
              ]
            }
            {
              size: 3200
              items:
              [
                {
                  size: 64
                  inv_default: 15171800517092997574
                }
                {
                  comment: unallocated space
                  size: 32
                  inv_default: 0
                }
                {
                  size: 256
                  inv_default: 0
                }
                {
                  size: 32
                  inv_default: 0
                }
                {
                  size: 32
                  inv_default: 0
                }
                {
                  size: 32
                  inv_default: 0
                }
                {
                  size: 32
                  inv_default: 0
                }
                {
                  size: 32
                  inv_default: 0
                }
                {
                  size: 32
                  inv_default: 0
                }
                {
                  size: 32
                  inv_default: 0
                }
                {
                  size: 32
                  inv_default: 0
                }
                {
                  size: 32
                  inv_default: 0
                }
                {
                  size: 32
                  inv_default: 0
                }
                {
                  size: 32
                  inv_default: 0
                }
                {
                  size: 32
                  inv_default: 0
                }
                {
                  size: 32
                  inv_default: 0
                }
                {
                  size: 32
                  inv_default: 0
                }
                {
                  size: 32
                  inv_default: 0
                }
                {
                  size: 32
                  inv_default: 0
                }
                {
                  size: 32
                  inv_default: 0
                }
                {
                  size: 32
                  inv_default: 0
                }
                {
                  size: 32
                  inv_default: 0
                }
                {
                  size: 32
                  inv_default: 0
                }
                {
                  size: 32
                  inv_default: 0
                }
                {
                  size: 32
                  inv_default: 0
                }
                {
                  size: 32
                  inv_default: 0
                }
                {
                  size: 32
                  inv_default: 0
                }
                {
                  size: 32
                  inv_default: 0
                }
                {
                  size: 32
                  inv_default: 0
                }
                {
                  size: 32
                  inv_default: 0
                }
                {
                  size: 32
                  inv_default: 0
                }
                {
                  size: 32
                  inv_default: 0
                }
                {
                  size: 32
                  inv_default: 0
                }
                {
                  size: 32
                  inv_default: 0
                }
                {
                  size: 32
                  inv_default: 0
                }
                {
                  size: 32
                  inv_default: 0
                }
                {
                  size: 32
                  inv_default: 0
                }
                {
                  size: 32
                  inv_default: 0
                }
                {
                  size: 1728
                  inv_default: 0
                }
              ]
            }
            {
              size: 512
              items:
              [
                {
                  size: 64
                  inv_default: 14559107168570208602
                }
                {
                  size: 448
                  inv_default: 0
                }
              ]
            }
          ]
          randwidth: 16512
        }
      ]
      template_type: otp_ctrl
      otp_mmap:
      {
        otp:
        {
          width: 2
          depth: 1032
          size: 2064
          addr_width: 11
          byte_addr_width: 12
        }
        scrambling:
        {
          key_size: 16
          iv_size: 8
          cnst_size: 16
          keys:
          [
            {
              name: Secret0Key
              value: 331022492591714447464586240374061564703
            }
            {
              name: Secret1Key
              value: 265942274807195661507108373182708621778
            }
            {
              name: Secret2Key
              value: 109437886370913622872069342019885612346
            }
          ]
          digests:
          [
            {
              name: CnstyDigest
              iv_value: 9795564408440331703
              cnst_value: 287351723648746892309770805605218514936
            }
            {
              name: NvmDataKey
              iv_value: 1115609512207997957
              cnst_value: 317398322252606832821360644140049638305
            }
            {
              name: NvmAddrKey
              iv_value: 2430472144873678252
              cnst_value: 38924999819288466149006682049690551
            }
            {
              name: SramDataKey
              iv_value: 12576976264769554639
              cnst_value: 21038539664889690717082771891904607355
            }
          ]
          num_keys: 3
          num_digests: 4
        }
        partitions:
        [
          {
            name: VENDOR_TEST
            variant: Unbuffered
            secret: false
            sw_digest: true
            hw_digest: false
            write_lock: Digest
            read_lock: CSR
            key_sel: NoKey
            integrity: false
            bkout_type: false
            skip_sw_header: true
            zeroizable: false
            items:
            [
              {
                name: SCRATCH
                size: 56
                isdigest: false
                iszer: false
                ismubi: false
                iskeymgr_creator: false
                iskeymgr_owner: false
                inv_default: 0
                offset: 0
              }
              {
                name: VENDOR_TEST_DIGEST
                size: 8
                offset: 56
                ismubi: false
                isdigest: true
                iszer: false
                inv_default: 14559107168570208602
                iskeymgr_creator: false
                iskeymgr_owner: false
              }
            ]
            desc:
              '''
              Vendor test partition.
              This is reserved for manufacturing smoke checks. The OTP wrapper
              control logic inside otp_macro is allowed to read/write to this
              region. ECC uncorrectable errors seen on the functional otp_macro
              interface will not lead to an alert for this partition.
              Instead, such errors will be reported as correctable ECC errors.
              '''
            absorb: false
            iskeymgr_creator: false
            iskeymgr_owner: false
            ignore_read_lock_in_rma: false
            size: 64
            offset: 0
          }
          {
            name: CREATOR_SW_CFG
            variant: Unbuffered
            absorb: true
            secret: false
            sw_digest: true
            hw_digest: false
            write_lock: Digest
            read_lock: CSR
            key_sel: NoKey
            integrity: true
            bkout_type: false
            zeroizable: false
            items:
            [
              {
                name: CREATOR_SW_CFG_AST_CFG
                size: 216
                desc:
                  '''
                  AST configuration data. These values get blindly copied to
                  the AST CSRs during ROM execution.
                  '''
                isdigest: false
                iszer: false
                ismubi: false
                iskeymgr_creator: false
                iskeymgr_owner: false
                inv_default: 0
                offset: 64
              }
              {
                name: CREATOR_SW_CFG_AST_INIT_EN
                size: 4
                desc:
                  '''
                  Controls whether or not the CREATOR_SW_CFG_AST_CFG values
                  get copied to the AST CSRs during ROM execution.
                  A value of kMultiBitBool4True enables copying; all other
                  values disable.
                  '''
                isdigest: false
                iszer: false
                ismubi: false
                iskeymgr_creator: false
                iskeymgr_owner: false
                inv_default: 0
                offset: 280
              }
              {
                name: CREATOR_SW_CFG_ROM_EXT_SKU
                size: 4
                desc: SKU identifier metadata. Unused by SiliconCreator software.
                isdigest: false
                iszer: false
                ismubi: false
                iskeymgr_creator: false
                iskeymgr_owner: false
                inv_default: 0
                offset: 284
              }
              {
                name: CREATOR_SW_CFG_SIGVERIFY_SPX_EN
                size: 4
                desc:
                  '''
                  Controls whether or not SPHINCS+ signature verification will
                  be executed when the ROM attempts to boot the ROM_EXT.
                  A value of kSigverifySpxDisabledOtp disables SPHINCS+
                  signature verification, while all other values enable it.
                  Note, SPHINCS+ signature verification is always disabled in
                  TEST_UNLOCKED* LC states.
                  '''
                isdigest: false
                iszer: false
                ismubi: false
                iskeymgr_creator: false
                iskeymgr_owner: false
                inv_default: 0
                offset: 288
              }
              {
                name: CREATOR_SW_CFG_NVM_DATA_DEFAULT_CFG
                size: 4
                desc:
                  '''
                  The default scrambling, ECC, and high endurance
                  configuration settings for NVM (flash or RRAM) data pages
                  set during ROM execution.
                  '''
                isdigest: false
                iszer: false
                ismubi: false
                iskeymgr_creator: false
                iskeymgr_owner: false
                inv_default: 0
                offset: 292
              }
              {
                name: CREATOR_SW_CFG_NVM_INFO_BOOT_DATA_CFG
                size: 4
                desc:
                  '''
                  The scrambling, ECC, and high endurance configuration
                  settings for the boot data NVM (flash or RRAM) info pages
                  set during ROM execution.
                  '''
                isdigest: false
                iszer: false
                ismubi: false
                iskeymgr_creator: false
                iskeymgr_owner: false
                inv_default: 0
                offset: 296
              }
              {
                name: CREATOR_SW_CFG_NVM_HW_INFO_CFG_OVERRIDE
                size: 4
                desc:
                  '''
                  Scrambling and ECC configuration overrides (set by the ROM)
                  for the Creator and OwnerSeed NVM (flash or RRAM) info
                  pages that are hardwired to the keygmr. By default,
                  scrambling and ECC on these info pages must be enabled in
                  order to successfully crank the keygmr (in the ROM_EXT).
                  However, values of kMultiBitBool4True for each subfield in
                  this field will disable this requirement. See the
                  HW_INFO_CFG_OVERRIDE flash_ctrl/rram_ctrl CSR for more
                  details.
                  '''
                isdigest: false
                iszer: false
                ismubi: false
                iskeymgr_creator: false
                iskeymgr_owner: false
                inv_default: 0
                offset: 300
              }
              {
                name: CREATOR_SW_CFG_RNG_EN
                size: 4
                desc:
                  '''
                  Whether or not to enable use of hardware generated entropy
                  (from the entropy complex via EDN) in the `rnd_uint32`
                  function. A value of kHardenedBoolTrue enables the use of
                  hardware generated entropy, while all other values disable.
                  '''
                isdigest: false
                iszer: false
                ismubi: false
                iskeymgr_creator: false
                iskeymgr_owner: false
                inv_default: 0
                offset: 304
              }
              {
                name: CREATOR_SW_CFG_JITTER_EN
                size: 4
                desc:
                  '''
                  Whether or not to enable clock jitter. A value of
                  kMultiBitBool4False disables, while all other values enable.
                  '''
                isdigest: false
                iszer: false
                ismubi: false
                iskeymgr_creator: false
                iskeymgr_owner: false
                inv_default: 0
                offset: 308
              }
              {
                name: CREATOR_SW_CFG_RET_RAM_RESET_MASK
                size: 4
                desc:
                  '''
                  Reset reason mask used to initialize (by overwriting with
                  random data) retention SRAM during ROM execution. A value of
                  0 only initializes retention SRAM on power-on-resets.See
                  rstmgr RESET_INFO CSR documentation for more details.
                  '''
                isdigest: false
                iszer: false
                ismubi: false
                iskeymgr_creator: false
                iskeymgr_owner: false
                inv_default: 0
                offset: 312
              }
              {
                name: CREATOR_SW_CFG_MANUF_STATE
                size: 4
                desc:
                  '''
                  Manufacturing state binding field. For use by
                  SiliconCreators or SiliconOwners to bind ROM_EXT images to a
                  specific device or set of devices.
                  '''
                isdigest: false
                iszer: false
                ismubi: false
                iskeymgr_creator: false
                iskeymgr_owner: false
                inv_default: 0
                offset: 316
              }
              {
                name: CREATOR_SW_CFG_ROM_EXEC_EN
                size: 4
                desc:
                  '''
                  Whether or not to enable execution of ROM. A value of 0
                  disables, while all other values enable. This enables
                  provisioning flows to attach JTAG connections and halt the
                  CPU before the device has been fully provisioned. All SKUs
                  should set this field to a non-zero value. Provisioning
                  flows shall take care to program this field at the
                  appropriate time during.
                  '''
                isdigest: false
                iszer: false
                ismubi: false
                iskeymgr_creator: false
                iskeymgr_owner: false
                inv_default: 0
                offset: 320
              }
              {
                name: CREATOR_SW_CFG_CPUCTRL
                size: 4
                desc:
                  '''
                  Value to write to the Ibex CPUCTRL CSR during ROM execution.
                  This field controls settings such as ICACHE enablement. See
                  Ibex documentation for more information.
                  '''
                isdigest: false
                iszer: false
                ismubi: false
                iskeymgr_creator: false
                iskeymgr_owner: false
                inv_default: 0
                offset: 324
              }
              {
                name: CREATOR_SW_CFG_MIN_SEC_VER_ROM_EXT
                size: 4
                desc:
                  '''
                  Value of the min_security_version_rom_ext field of the
                  default boot data.
                  '''
                isdigest: false
                iszer: false
                ismubi: false
                iskeymgr_creator: false
                iskeymgr_owner: false
                inv_default: 0
                offset: 328
              }
              {
                name: CREATOR_SW_CFG_MIN_SEC_VER_BL0
                size: 4
                desc:
                  '''
                  Value of the min_security_version_bl0 field of the
                  default boot data.
                  '''
                isdigest: false
                iszer: false
                ismubi: false
                iskeymgr_creator: false
                iskeymgr_owner: false
                inv_default: 0
                offset: 332
              }
              {
                name: CREATOR_SW_CFG_DEFAULT_BOOT_DATA_IN_PROD_EN
                size: 4
                desc:
                  '''
                  Whether or not to enable the default boot data in PROD and
                  PROD_END life cycle states. A value of kHardenedBoolTrue
                  enables, all other values disable. If left disabled,
                  provisioning flows are required to setup boot data pages
                  prior to enabling ROM execution. The default personalization
                  flow in `ft_personalize.c` configures these pages.
                  '''
                isdigest: false
                iszer: false
                ismubi: false
                iskeymgr_creator: false
                iskeymgr_owner: false
                inv_default: 0
                offset: 336
              }
              {
                name: CREATOR_SW_CFG_RMA_SPIN_EN
                size: 4
                desc:
                  '''
                  Whether or not to enable a busy-wait delay loop in the ROM,
                  when a specific SW strapping configuration is applied during
                  boot, to provide time to trigger an RMA lifecycle transition
                  over JTAG. A value of kHardenedBoolTrue enables, all other
                  values disable.
                  '''
                isdigest: false
                iszer: false
                ismubi: false
                iskeymgr_creator: false
                iskeymgr_owner: false
                inv_default: 0
                offset: 340
              }
              {
                name: CREATOR_SW_CFG_RMA_SPIN_CYCLES
                size: 4
                desc:
                  '''
                  The number of Ibex clock cycles to spin for when waiting for
                  an RMA transition. Used in combination with the
                  CREATOR_SW_CFG_RMA_SPIN_EN field.
                  '''
                isdigest: false
                iszer: false
                ismubi: false
                iskeymgr_creator: false
                iskeymgr_owner: false
                inv_default: 0
                offset: 344
              }
              {
                name: CREATOR_SW_CFG_RNG_REPCNT_THRESHOLDS
                size: 4
                desc:
                  '''
                  The repetition count health test thresholds to enable
                  entropy_src with during ROM execution.
                  This must be configured if CREATOR_SW_CFG_RNG_EN is true.
                  The LSBs contain the boot-time / bypass mode threshold
                  value.
                  The MSBs contain the value for the FIPS / CC compliant mode.
                  See entropy_src documentation for more details.
                  '''
                isdigest: false
                iszer: false
                ismubi: false
                iskeymgr_creator: false
                iskeymgr_owner: false
                inv_default: 0
                offset: 348
              }
              {
                name: CREATOR_SW_CFG_RNG_REPCNTS_THRESHOLDS
                size: 4
                desc:
                  '''
                  The repetition count symbol health test thresholds to enable
                  entropy_src with during ROM execution.
                  This must be configured if CREATOR_SW_CFG_RNG_EN is true.
                  The LSBs contain the boot-time / bypass mode threshold
                  value.
                  The MSBs contain the value for the FIPS / CC compliant mode.
                  See entropy_src documentation for more details.
                  '''
                isdigest: false
                iszer: false
                ismubi: false
                iskeymgr_creator: false
                iskeymgr_owner: false
                inv_default: 0
                offset: 352
              }
              {
                name: CREATOR_SW_CFG_RNG_ADAPTP_HI_THRESHOLDS
                size: 4
                desc:
                  '''
                  The adaptive proportion health test high thresholds to
                  enable entropy_src with during ROM execution.
                  This must be configured if CREATOR_SW_CFG_RNG_EN is true.
                  The LSBs contain the boot-time / bypass mode threshold
                  value.
                  The MSBs contain the value for the FIPS / CC compliant mode.
                  See entropy_src documentation for more details.
                  '''
                isdigest: false
                iszer: false
                ismubi: false
                iskeymgr_creator: false
                iskeymgr_owner: false
                inv_default: 0
                offset: 356
              }
              {
                name: CREATOR_SW_CFG_RNG_ADAPTP_LO_THRESHOLDS
                size: 4
                desc:
                  '''
                  The adaptive proportion health test low thresholds to enable
                  entropy_src with during ROM execution.
                  This must be configured if CREATOR_SW_CFG_RNG_EN is true.
                  The LSBs contain the boot-time / bypass mode threshold
                  value.
                  The MSBs contain the value for the FIPS / CC compliant mode.
                  See entropy_src documentation for more details.
                  '''
                isdigest: false
                iszer: false
                ismubi: false
                iskeymgr_creator: false
                iskeymgr_owner: false
                inv_default: 0
                offset: 360
              }
              {
                name: CREATOR_SW_CFG_RNG_ADAPTPS_THRESHOLDS
                size: 4
                desc:
                  '''
                  The adaptive proportion symbol health test thresholds to
                  enable entropy_src with during ROM execution.
                  This must be configured if CREATOR_SW_CFG_RNG_EN is true.
                  The LSBs contain the boot-time / bypass mode threshold
                  value.
                  The MSBs contain the value for the FIPS / CC compliant mode.
                  See entropy_src documentation for more details.
                  '''
                isdigest: false
                iszer: false
                ismubi: false
                iskeymgr_creator: false
                iskeymgr_owner: false
                inv_default: 0
                offset: 364
              }
              {
                name: CREATOR_SW_CFG_RNG_BUCKET_THRESHOLDS
                size: 4
                desc:
                  '''
                  The bucket health test thresholds to enable entropy_src with
                  during ROM execution.
                  This must be configured if CREATOR_SW_CFG_RNG_EN is true.
                  The LSBs contain the boot-time / bypass mode threshold
                  value.
                  The MSBs contain the value for the FIPS / CC compliant mode.
                  See entropy_src documentation for more details.
                  '''
                isdigest: false
                iszer: false
                ismubi: false
                iskeymgr_creator: false
                iskeymgr_owner: false
                inv_default: 0
                offset: 368
              }
              {
                name: CREATOR_SW_CFG_RNG_MARKOV_HI_THRESHOLDS
                size: 4
                desc:
                  '''
                  The Markov health test high thresholds to enable entropy_src
                  with during ROM execution.
                  This must be configured if CREATOR_SW_CFG_RNG_EN is true.
                  The LSBs contain the boot-time / bypass mode threshold
                  value.
                  The MSBs contain the value for the FIPS / CC compliant mode.
                  See entropy_src documentation for more details.
                  '''
                isdigest: false
                iszer: false
                ismubi: false
                iskeymgr_creator: false
                iskeymgr_owner: false
                inv_default: 0
                offset: 372
              }
              {
                name: CREATOR_SW_CFG_RNG_MARKOV_LO_THRESHOLDS
                size: 4
                desc:
                  '''
                  The Markov health test low thresholds to enable entropy_src
                  with during ROM execution.
                  This must be configured if CREATOR_SW_CFG_RNG_EN is true.
                  The LSBs contain the boot-time / bypass mode threshold
                  value.
                  The MSBs contain the value for the FIPS / CC compliant mode.
                  See entropy_src documentation for more details.
                  '''
                isdigest: false
                iszer: false
                ismubi: false
                iskeymgr_creator: false
                iskeymgr_owner: false
                inv_default: 0
                offset: 376
              }
              {
                name: CREATOR_SW_CFG_RNG_EXTHT_HI_THRESHOLDS
                size: 4
                desc:
                  '''
                  The external health test high thresholds to enable the
                  entropy_src with during ROM execution.
                  This must be configured if CREATOR_SW_CFG_RNG_EN is true.
                  The LSBs contain the boot-time / bypass mode threshold
                  value.
                  The MSBs contain the value for the FIPS / CC compliant mode.
                  See entropy_src documentation for more details.
                  '''
                isdigest: false
                iszer: false
                ismubi: false
                iskeymgr_creator: false
                iskeymgr_owner: false
                inv_default: 0
                offset: 380
              }
              {
                name: CREATOR_SW_CFG_RNG_EXTHT_LO_THRESHOLDS
                size: 4
                desc:
                  '''
                  The external health test low thresholds to enable the
                  entropy_src with during ROM execution.
                  This must be configured if CREATOR_SW_CFG_RNG_EN is true.
                  The LSBs contain the boot-time / bypass mode threshold
                  value.
                  The MSBs contain the value for the FIPS / CC compliant mode.
                  See entropy_src documentation for more details.
                  '''
                isdigest: false
                iszer: false
                ismubi: false
                iskeymgr_creator: false
                iskeymgr_owner: false
                inv_default: 0
                offset: 384
              }
              {
                name: CREATOR_SW_CFG_RNG_BOOT_ALERT_THRESHOLD
                size: 4
                desc:
                  '''
                  The alert threshold to configure the entropy_src with during
                  ROM execution in boot-time / bypass mode.
                  This must be configured if CREATOR_SW_CFG_RNG_EN is true.
                  See entropy_src documentation for more details.
                  '''
                isdigest: false
                iszer: false
                ismubi: false
                iskeymgr_creator: false
                iskeymgr_owner: false
                inv_default: 0
                offset: 388
              }
              {
                name: CREATOR_SW_CFG_RNG_FIPS_ALERT_THRESHOLD
                size: 4
                desc:
                  '''
                  The alert threshold to configure the entropy_src with during
                  ROM execution in FIPS / CC compliant mode.
                  This must be configured if CREATOR_SW_CFG_RNG_EN is true.
                  See entropy_src documentation for more details.
                  '''
                isdigest: false
                iszer: false
                ismubi: false
                iskeymgr_creator: false
                iskeymgr_owner: false
                inv_default: 0
                offset: 392
              }
              {
                name: CREATOR_SW_CFG_RNG_BOOT_CONFIG_DIGEST
                size: 4
                desc:
                  '''
                  A CRC32 digest of the entropy_src configuration above for
                  boot-time / bypass mode.
                  This must be configured if CREATOR_SW_CFG_RNG_EN is true.
                  See entropy_src documentation for more details.
                  '''
                isdigest: false
                iszer: false
                ismubi: false
                iskeymgr_creator: false
                iskeymgr_owner: false
                inv_default: 0
                offset: 396
              }
              {
                name: CREATOR_SW_CFG_RNG_FIPS_CONFIG_DIGEST
                size: 4
                desc:
                  '''
                  A CRC32 digest of the entropy_src configuration above for
                  FIPS / CC compliant mode.
                  This must be configured if CREATOR_SW_CFG_RNG_EN is true.
                  See entropy_src documentation for more details.
                  '''
                isdigest: false
                iszer: false
                ismubi: false
                iskeymgr_creator: false
                iskeymgr_owner: false
                inv_default: 0
                offset: 400
              }
              {
                name: CREATOR_SW_CFG_SRAM_KEY_RENEW_AND_INIT_EN
                size: 4
                desc:
                  '''
                  Whether or not the ROM should request SRAM to be rescrambled
                  with a new key on every boot. This includes renewing the
                  scrambling key and then initializing SRAM with pseudo-random
                  data. kHardenedBoolFalse disables, while all other values
                  enable.
                  '''
                isdigest: false
                iszer: false
                ismubi: false
                iskeymgr_creator: false
                iskeymgr_owner: false
                inv_default: 0
                offset: 404
              }
              {
                name: CREATOR_SW_CFG_IMMUTABLE_ROM_EXT_EN
                size: 4
                desc:
                  '''
                  Enablement of the ROM_EXT immutable code section.
                  A value of kHardenedBoolTrue enables the feature.
                  All other values disable it.
                  '''
                isdigest: false
                iszer: false
                ismubi: false
                iskeymgr_creator: false
                iskeymgr_owner: false
                inv_default: 0
                offset: 408
              }
              {
                name: CREATOR_SW_CFG_IMMUTABLE_ROM_EXT_START_OFFSET
                size: 4
                desc:
                  '''
                  Relative offset from the start of the ROM_EXT slot to
                  find the immutable code section at.
                  '''
                isdigest: false
                iszer: false
                ismubi: false
                iskeymgr_creator: false
                iskeymgr_owner: false
                inv_default: 0
                offset: 412
              }
              {
                name: CREATOR_SW_CFG_IMMUTABLE_ROM_EXT_LENGTH
                size: 4
                desc: Length (in bytes) of the immutable code section.
                isdigest: false
                iszer: false
                ismubi: false
                iskeymgr_creator: false
                iskeymgr_owner: false
                inv_default: 0
                offset: 416
              }
              {
                name: CREATOR_SW_CFG_IMMUTABLE_ROM_EXT_SHA256_HASH
                size: 32
                desc: SHA256 hash of the immutable ROM_EXT section.
                isdigest: false
                iszer: false
                ismubi: false
                iskeymgr_creator: false
                iskeymgr_owner: false
                inv_default: 0
                offset: 420
              }
              {
                name: CREATOR_SW_CFG_DIGEST
                size: 8
                offset: 456
                ismubi: false
                isdigest: true
                iszer: false
                inv_default: 15171800517092997574
                iskeymgr_creator: false
                iskeymgr_owner: false
              }
            ]
            desc:
              '''
              Software configuration partition.
              This is for device-specific calibration data, e.g, clock, LDO, RNG,
              and configuration settings set by the ROM.
              '''
            iskeymgr_creator: false
            iskeymgr_owner: false
            ignore_read_lock_in_rma: false
            size: 400
            offset: 64
          }
          {
            name: OWNER_SW_CFG
            variant: Unbuffered
            absorb: true
            secret: false
            sw_digest: true
            hw_digest: false
            write_lock: Digest
            read_lock: CSR
            key_sel: NoKey
            integrity: true
            bkout_type: false
            zeroizable: false
            items:
            [
              {
                name: OWNER_SW_CFG_ROM_ERROR_REPORTING
                size: 4
                desc:
                  '''
                  The shutdown error reporting verbosity used by the ROM.
                  Should be configured to one of several
                  `shutdown_error_redact_t` values. See
                  `sw/device/silicon_creator/lib/shutdown.h` for more details.
                  '''
                isdigest: false
                iszer: false
                ismubi: false
                iskeymgr_creator: false
                iskeymgr_owner: false
                inv_default: 0
                offset: 464
              }
              {
                name: OWNER_SW_CFG_ROM_BOOTSTRAP_DIS
                size: 4
                desc:
                  '''
                  Whether or not to disable ROM bootstrap mechanism. A value
                  of kHardenedBoolTrue disable bootstrap mechanism in the ROM,
                  while all other values enable it. Note, the provisioning
                  flow should take care when to program this field if it is
                  used by a SKU, as there is no way to get firmware into flash
                  in a PROD LC state if a valid ROM_EXT does not already exist
                  in flash once this value is configured to true.
                  '''
                isdigest: false
                iszer: false
                ismubi: false
                iskeymgr_creator: false
                iskeymgr_owner: false
                inv_default: 0
                offset: 468
              }
              {
                name: OWNER_SW_CFG_ROM_ALERT_CLASS_EN
                size: 4
                desc:
                  '''
                  A four byte packed field, where each byte controls whether
                  or not the ROM enables each alert class (A through D) of the
                  alert_handler. The byte-sized subfields are arranged from D
                  to A, MSB to LSB. Each byte should be set to an
                  `alert_enable_t` value accordingly. See the alert_handler
                  documentation for more details.
                  '''
                isdigest: false
                iszer: false
                ismubi: false
                iskeymgr_creator: false
                iskeymgr_owner: false
                inv_default: 0
                offset: 472
              }
              {
                name: OWNER_SW_CFG_ROM_ALERT_ESCALATION
                size: 4
                desc:
                  '''
                  A four byte packed field, where each byte controls the
                  escalation configuration for each alert class (A through D)
                  of the alert_handler configured by the ROM. The byte-sized
                  subfields are arranged from D to A, MSB to LSB. Each byte
                  should be set to an `alert_escalate_t` value accordingly.
                  See the alert_handler documentation for more details.
                  '''
                isdigest: false
                iszer: false
                ismubi: false
                iskeymgr_creator: false
                iskeymgr_owner: false
                inv_default: 0
                offset: 476
              }
              {
                name: OWNER_SW_CFG_ROM_ALERT_CLASSIFICATION
                size: 320
                desc:
                  '''
                  The alert classifications (A through D) for each alert
                  source of the alert_handler to be configured by the ROM. The
                  field consists of a contiguous 320-byte block, or 80 32-bit
                  words. The four bytes in each word encode the configuration
                  of a single alert source across four lifecycle states, in
                  order from LSB to MSB: PROD, PROD_END, DEV, and RMA. Each
                  byte should be set to an `alert_class_t` value accordingly.
                  The order of the 80 32-bit words, from LSB to MSB can be
                  found in the EARLGREY_ALERTS list in `rules/const.bzl`.
                  See the alert_handler documentation for more details.
                  '''
                isdigest: false
                iszer: false
                ismubi: false
                iskeymgr_creator: false
                iskeymgr_owner: false
                inv_default: 0
                offset: 480
              }
              {
                name: OWNER_SW_CFG_ROM_LOCAL_ALERT_CLASSIFICATION
                size: 64
                desc:
                  '''
                  Same as the `OWNER_SW_CFG_ROM_ALERT_CLASSIFICATION` field,
                  except these configuration correspond to the local alert
                  sources found in the `EARLGREY_LOC_ALERTS list in
                  `rules/const.bzl`.
                  '''
                isdigest: false
                iszer: false
                ismubi: false
                iskeymgr_creator: false
                iskeymgr_owner: false
                inv_default: 0
                offset: 800
              }
              {
                name: OWNER_SW_CFG_ROM_ALERT_ACCUM_THRESH
                size: 16
                desc:
                  '''
                  The alert accumulation threshold values for each alert class
                  (A through D) of the alert_handler to be configured by the
                  ROM. This field consists of four 32-bit words encoding the
                  accumulation thresholds for each alert class A through D
                  arranged LSW to MSW. See the alert_handler documentation for
                  more details.
                  '''
                isdigest: false
                iszer: false
                ismubi: false
                iskeymgr_creator: false
                iskeymgr_owner: false
                inv_default: 0
                offset: 864
              }
              {
                name: OWNER_SW_CFG_ROM_ALERT_TIMEOUT_CYCLES
                size: 16
                desc:
                  '''
                  Same as the `OWNER_SW_CFG_ROM_ALERT_ACCUM_THRESH` field,
                  except each value corresponds to the interrupt timeout
                  configuration of an alert class.
                  '''
                isdigest: false
                iszer: false
                ismubi: false
                iskeymgr_creator: false
                iskeymgr_owner: false
                inv_default: 0
                offset: 880
              }
              {
                name: OWNER_SW_CFG_ROM_ALERT_PHASE_CYCLES
                size: 64
                desc:
                  '''
                  The alert escalation phase durations, measured in clock
                  cycles, the ROM will configure the four alert phases for
                  each alert class of the alert_handler. This field consists
                  of a contiguous 64-byte block, or an array of four 128-bit
                  fields. Each 128-bit subfield encodes four 32-bit words that
                  contain the alert phase cycle count configurations for alert
                  escalation phases 0 to 3, from LSW to MSW. Each 128-bit
                  subfield is contains all configurations for a single alert
                  class, arranged from class A to D, from LS to MS. For
                  example, the cycle durations of each escalation phase in
                  this field should be configured as such, from LSB to MSB:
                  <classA,phase0>...<classA,phase3>...<classD,phase0>...
                  <classD,phase3>. See the alert_handler documentation for
                  more details.
                  '''
                isdigest: false
                iszer: false
                ismubi: false
                iskeymgr_creator: false
                iskeymgr_owner: false
                inv_default: 0
                offset: 896
              }
              {
                name: OWNER_SW_CFG_ROM_ALERT_DIGEST_PROD
                size: 4
                desc:
                  '''
                  The expected CRC32 digest over all of the alert_handler
                  configurations set up by the ROM for a device operating in
                  the PROD LC state. The ROM reads this field and checks it
                  against a digest it computes over the alert_handler
                  configuration it programmed. This field is expected to be
                  automatically computed by the `otp_alert_digest()` Bazel
                  rule. See the `alert_config_crc32()` function in the
                  SiliconCreator alert_handler driver for more details on what
                  configurations are included in this digest.
                  '''
                isdigest: false
                iszer: false
                ismubi: false
                iskeymgr_creator: false
                iskeymgr_owner: false
                inv_default: 0
                offset: 960
              }
              {
                name: OWNER_SW_CFG_ROM_ALERT_DIGEST_PROD_END
                size: 4
                desc:
                  '''
                  Same as the `OWNER_SW_CFG_ROM_ALERT_DIGEST_PROD` field,
                  except the expected digest is for chips operating in the
                  PROD_END LC state.
                  '''
                isdigest: false
                iszer: false
                ismubi: false
                iskeymgr_creator: false
                iskeymgr_owner: false
                inv_default: 0
                offset: 964
              }
              {
                name: OWNER_SW_CFG_ROM_ALERT_DIGEST_DEV
                size: 4
                desc:
                  '''
                  Same as the `OWNER_SW_CFG_ROM_ALERT_DIGEST_PROD` field,
                  except the expected digest is for chips operating in the
                  DEV LC state.
                  '''
                isdigest: false
                iszer: false
                ismubi: false
                iskeymgr_creator: false
                iskeymgr_owner: false
                inv_default: 0
                offset: 968
              }
              {
                name: OWNER_SW_CFG_ROM_ALERT_DIGEST_RMA
                size: 4
                desc:
                  '''
                  Same as the `OWNER_SW_CFG_ROM_ALERT_DIGEST_PROD` field,
                  except the expected digest is for chips operating in the
                  RMA LC state.
                  '''
                isdigest: false
                iszer: false
                ismubi: false
                iskeymgr_creator: false
                iskeymgr_owner: false
                inv_default: 0
                offset: 972
              }
              {
                name: OWNER_SW_CFG_ROM_WATCHDOG_BITE_THRESHOLD_CYCLES
                size: 4
                desc: Watchdog timer bite threshold (in cycles) configured by the ROM.
                isdigest: false
                iszer: false
                ismubi: false
                iskeymgr_creator: false
                iskeymgr_owner: false
                inv_default: 0
                offset: 976
              }
              {
                name: OWNER_SW_CFG_ROM_KEYMGR_OTP_MEAS_EN
                size: 4
                desc:
                  '''
                  Whether or not to configure the attestation SW binding CSRs
                  of the keymgr with the value in ROM_EXT manifest or the
                  measurement of the OTP CreatorSwCfg, OwnerSwCfg, and
                  secure boot key integrity digest. A value of
                  kHardenedBoolTrue uses the ROM computed OTP measurements,
                  while all other values trigger the use of the binding values
                  included in the ROM_EXT manifest.
                  '''
                isdigest: false
                iszer: false
                ismubi: false
                iskeymgr_creator: false
                iskeymgr_owner: false
                inv_default: 0
                offset: 980
              }
              {
                name: OWNER_SW_CFG_MANUF_STATE
                size: 4
                desc:
                  '''
                  Manufacturing state binding field. For use by
                  SiliconCreators or SiliconOwners to bind BL0 images to a
                  specific device or set of devices.
                  '''
                isdigest: false
                iszer: false
                ismubi: false
                iskeymgr_creator: false
                iskeymgr_owner: false
                inv_default: 0
                offset: 984
              }
              {
                name: OWNER_SW_CFG_ROM_RSTMGR_INFO_EN
                size: 4
                desc:
                  '''
                  A two byte packed word that indicates the expected rstmgr
                  alert and CPU info dump enable states, configured in the
                  rstmgr's ALERT_INFO_CTRL and CPU_INFO_CTRL CSRs respectively.
                  The expected format of this fields is
                  {0,0,kHardenedBool*,kHardenedBool*}, read MSB to LSB, where
                  the left most kHardenedBool* entry indicates the expected
                  enablement state of the ALERT_INFO_CTRL, and the right most
                  indicates the enablement state of the CPU_INFO_CTRL. Since
                  the ROM expects both to be disabled upon handing over
                  execution control to the ROM_EXT, this entire OTP field
                  **should be left unprovisioned, or set to all 0**.
                  '''
                isdigest: false
                iszer: false
                ismubi: false
                iskeymgr_creator: false
                iskeymgr_owner: false
                inv_default: 0
                offset: 988
              }
              {
                name: OWNER_SW_CFG_ROM_EXT_BOOTSTRAP_EN
                size: 4
                desc: Unused. Set to 0.
                isdigest: false
                iszer: false
                ismubi: false
                iskeymgr_creator: false
                iskeymgr_owner: false
                inv_default: 0
                offset: 992
              }
              {
                name: OWNER_SW_CFG_ROM_SENSOR_CTRL_ALERT_CFG
                size: 12
                desc:
                  '''
                  Alert configuration values for the sensor_ctrl block
                  that will be configured by the ROM. This field is 12 bytes
                  long, where each byte contains two 4-bit packed subfields,
                  encoding two four bit boolean values (kMultiBitBool4False or
                  kMultiBitBool4True), as follows (read MSB to LSB):
                  {fatality, enablement}. For example, the byte 0x69 would
                  encode the alert is: 1) recoverable, and 2) disabled.

                  Currently, there are only 11 alerts in sensor_ctrl to
                  configure, thus only the least significant bytes in this
                  field are used.
                  '''
                isdigest: false
                iszer: false
                ismubi: false
                iskeymgr_creator: false
                iskeymgr_owner: false
                inv_default: 0
                offset: 996
              }
              {
                name: OWNER_SW_CFG_ROM_SRAM_READBACK_EN
                size: 4
                desc:
                  '''
                  This field encodes the enablements of the readback security
                  features for the main and retention SRAMs to be configured
                  by the ROM. This field is four bytes, but the LSB contains
                  two 4-bit packed kMultiBitBool4* values that indicate the
                  enablement of the feature for the retention SRAM and
                  main SRAM, from MSB to LSB respectively. See the READBACK
                  CSR of the sram_ctrl for more details on this feature.
                  '''
                isdigest: false
                iszer: false
                ismubi: false
                iskeymgr_creator: false
                iskeymgr_owner: false
                inv_default: 0
                offset: 1008
              }
              {
                name: OWNER_SW_CFG_ROM_PRESERVE_RESET_REASON_EN
                size: 4
                desc:
                  '''
                  Whether or not the ROM should preserve the reset reasons CSR
                  state in the rstmgr, or clear it. A value of
                  kHardenedBoolTrue preserves the CSR, while other values
                  trigger the ROM to clear the CSR after copying the reason to
                  the retention SRAM.
                  '''
                isdigest: false
                iszer: false
                ismubi: false
                iskeymgr_creator: false
                iskeymgr_owner: false
                inv_default: 0
                offset: 1012
              }
              {
                name: OWNER_SW_CFG_ROM_RESET_REASON_CHECK_VALUE
                size: 4
                desc:
                  '''
                  Two packed 16-bit values that indicate whether the ROM
                  should perform a validation check on the the reset reasons
                  during boot. The validation check is a hardening mechanism
                  that checks the reset reasons for consistency at two
                  different points in time. Both packed values should be the
                  same. Values of kHardenedBoolFalse will instruct the ROM to
                  skip the reset reasons validation check, while all other
                  values will instruct the ROM to perform the check.
                  '''
                isdigest: false
                iszer: false
                ismubi: false
                iskeymgr_creator: false
                iskeymgr_owner: false
                inv_default: 0
                offset: 1016
              }
              {
                name: OWNER_SW_CFG_ROM_BANNER_EN
                size: 4
                desc:
                  '''
                  Whether or not the ROM should print a banner message to the
                  console UART during boot. A value of kHardenedBoolFalse
                  disables the message printing, while all other values enable
                  it.
                  '''
                isdigest: false
                iszer: false
                ismubi: false
                iskeymgr_creator: false
                iskeymgr_owner: false
                inv_default: 0
                offset: 1020
              }
              {
                name: OWNER_SW_CFG_ROM_NVM_ECC_EXC_HANDLER_EN
                size: 4
                desc:
                  '''
                  Whether or not the ROM should use the NVM (flash or RRAM)
                  ECC exception handler during execution. A value of
                  kHardenedBoolTrue allows the ROM to use the exception
                  handler that recovers gracefully and continues the boot
                  process if an NVM ECC error is encountered during
                  verification of a specific ROM_EXT slot. This enables the
                  ROM to attempt booting the next ROM_EXT slot if the first
                  slot attempted has been corrupted. All other values
                  trigger default ROM exception handling, which is all
                  exceptions trigger a chip shutdown and reset.
                  '''
                isdigest: false
                iszer: false
                ismubi: false
                iskeymgr_creator: false
                iskeymgr_owner: false
                inv_default: 0
                offset: 1024
              }
              {
                name: OWNER_SW_CFG_RESERVED
                size: 96
                desc:
                  '''
                  Unused bits in the OWNER_SW_CFG OTP partition. These can be
                  claimed by software as needed.
                  '''
                isdigest: false
                iszer: false
                ismubi: false
                iskeymgr_creator: false
                iskeymgr_owner: false
                inv_default: 0
                offset: 1028
              }
              {
                name: OWNER_SW_CFG_DIGEST
                size: 8
                offset: 1128
                ismubi: false
                isdigest: true
                iszer: false
                inv_default: 17626243154800067267
                iskeymgr_creator: false
                iskeymgr_owner: false
              }
            ]
            desc:
              '''
              Software configuration partition.
              This contains data that changes software behavior in the ROM, for
              example enabling defensive features in ROM or selecting failure
              modes if verification fails.
              '''
            iskeymgr_creator: false
            iskeymgr_owner: false
            ignore_read_lock_in_rma: false
            size: 672
            offset: 464
          }
          {
            name: ROT_CREATOR_AUTH_CODESIGN
            variant: Unbuffered
            absorb: false
            secret: false
            sw_digest: true
            hw_digest: false
            write_lock: Digest
            read_lock: CSR
            key_sel: NoKey
            integrity: true
            bkout_type: false
            zeroizable: false
            items:
            [
              {
                name: ROT_CREATOR_AUTH_CODESIGN_ECDSA_KEY_TYPE0
                size: 4
                isdigest: false
                iszer: false
                ismubi: false
                iskeymgr_creator: false
                iskeymgr_owner: false
                inv_default: 0
                offset: 1136
              }
              {
                name: ROT_CREATOR_AUTH_CODESIGN_ECDSA_KEY0
                size: 64
                isdigest: false
                iszer: false
                ismubi: false
                iskeymgr_creator: false
                iskeymgr_owner: false
                inv_default: 0
                offset: 1140
              }
              {
                name: ROT_CREATOR_AUTH_CODESIGN_ECDSA_KEY_TYPE1
                size: 4
                isdigest: false
                iszer: false
                ismubi: false
                iskeymgr_creator: false
                iskeymgr_owner: false
                inv_default: 0
                offset: 1204
              }
              {
                name: ROT_CREATOR_AUTH_CODESIGN_ECDSA_KEY1
                size: 64
                isdigest: false
                iszer: false
                ismubi: false
                iskeymgr_creator: false
                iskeymgr_owner: false
                inv_default: 0
                offset: 1208
              }
              {
                name: ROT_CREATOR_AUTH_CODESIGN_ECDSA_KEY_TYPE2
                size: 4
                isdigest: false
                iszer: false
                ismubi: false
                iskeymgr_creator: false
                iskeymgr_owner: false
                inv_default: 0
                offset: 1272
              }
              {
                name: ROT_CREATOR_AUTH_CODESIGN_ECDSA_KEY2
                size: 64
                isdigest: false
                iszer: false
                ismubi: false
                iskeymgr_creator: false
                iskeymgr_owner: false
                inv_default: 0
                offset: 1276
              }
              {
                name: ROT_CREATOR_AUTH_CODESIGN_ECDSA_KEY_TYPE3
                size: 4
                isdigest: false
                iszer: false
                ismubi: false
                iskeymgr_creator: false
                iskeymgr_owner: false
                inv_default: 0
                offset: 1340
              }
              {
                name: ROT_CREATOR_AUTH_CODESIGN_ECDSA_KEY3
                size: 64
                isdigest: false
                iszer: false
                ismubi: false
                iskeymgr_creator: false
                iskeymgr_owner: false
                inv_default: 0
                offset: 1344
              }
              {
                name: ROT_CREATOR_AUTH_CODESIGN_SPX_KEY_TYPE0
                size: 4
                isdigest: false
                iszer: false
                ismubi: false
                iskeymgr_creator: false
                iskeymgr_owner: false
                inv_default: 0
                offset: 1408
              }
              {
                name: ROT_CREATOR_AUTH_CODESIGN_SPX_KEY0
                size: 32
                isdigest: false
                iszer: false
                ismubi: false
                iskeymgr_creator: false
                iskeymgr_owner: false
                inv_default: 0
                offset: 1412
              }
              {
                name: ROT_CREATOR_AUTH_CODESIGN_SPX_KEY_CONFIG0
                size: 4
                isdigest: false
                iszer: false
                ismubi: false
                iskeymgr_creator: false
                iskeymgr_owner: false
                inv_default: 0
                offset: 1444
              }
              {
                name: ROT_CREATOR_AUTH_CODESIGN_SPX_KEY_TYPE1
                size: 4
                isdigest: false
                iszer: false
                ismubi: false
                iskeymgr_creator: false
                iskeymgr_owner: false
                inv_default: 0
                offset: 1448
              }
              {
                name: ROT_CREATOR_AUTH_CODESIGN_SPX_KEY1
                size: 32
                isdigest: false
                iszer: false
                ismubi: false
                iskeymgr_creator: false
                iskeymgr_owner: false
                inv_default: 0
                offset: 1452
              }
              {
                name: ROT_CREATOR_AUTH_CODESIGN_SPX_KEY_CONFIG1
                size: 4
                isdigest: false
                iszer: false
                ismubi: false
                iskeymgr_creator: false
                iskeymgr_owner: false
                inv_default: 0
                offset: 1484
              }
              {
                name: ROT_CREATOR_AUTH_CODESIGN_SPX_KEY_TYPE2
                size: 4
                isdigest: false
                iszer: false
                ismubi: false
                iskeymgr_creator: false
                iskeymgr_owner: false
                inv_default: 0
                offset: 1488
              }
              {
                name: ROT_CREATOR_AUTH_CODESIGN_SPX_KEY2
                size: 32
                isdigest: false
                iszer: false
                ismubi: false
                iskeymgr_creator: false
                iskeymgr_owner: false
                inv_default: 0
                offset: 1492
              }
              {
                name: ROT_CREATOR_AUTH_CODESIGN_SPX_KEY_CONFIG2
                size: 4
                isdigest: false
                iszer: false
                ismubi: false
                iskeymgr_creator: false
                iskeymgr_owner: false
                inv_default: 0
                offset: 1524
              }
              {
                name: ROT_CREATOR_AUTH_CODESIGN_SPX_KEY_TYPE3
                size: 4
                isdigest: false
                iszer: false
                ismubi: false
                iskeymgr_creator: false
                iskeymgr_owner: false
                inv_default: 0
                offset: 1528
              }
              {
                name: ROT_CREATOR_AUTH_CODESIGN_SPX_KEY3
                size: 32
                isdigest: false
                iszer: false
                ismubi: false
                iskeymgr_creator: false
                iskeymgr_owner: false
                inv_default: 0
                offset: 1532
              }
              {
                name: ROT_CREATOR_AUTH_CODESIGN_SPX_KEY_CONFIG3
                size: 4
                isdigest: false
                iszer: false
                ismubi: false
                iskeymgr_creator: false
                iskeymgr_owner: false
                inv_default: 0
                offset: 1564
              }
              {
                name: ROT_CREATOR_AUTH_CODESIGN_BLOCK_SHA2_256_HASH
                size: 32
                isdigest: false
                iszer: false
                ismubi: false
                iskeymgr_creator: false
                iskeymgr_owner: false
                inv_default: 0
                offset: 1568
              }
              {
                name: ROT_CREATOR_AUTH_CODESIGN_DIGEST
                size: 8
                offset: 1600
                ismubi: false
                isdigest: true
                iszer: false
                inv_default: 11160556988759673749
                iskeymgr_creator: false
                iskeymgr_owner: false
              }
            ]
            desc:
              '''
              This OTP partition is used to store four P-256 keys
              and four Sphincs+ keys. The partition requires 464
              bytes of software visible storage. The partition is
              locked at manufacturing time to protect against
              malicious write attempts.
              '''
            iskeymgr_creator: false
            iskeymgr_owner: false
            ignore_read_lock_in_rma: false
            size: 472
            offset: 1136
          }
          {
            name: ROT_CREATOR_AUTH_STATE
            variant: Unbuffered
            absorb: false
            secret: false
            sw_digest: true
            hw_digest: false
            write_lock: Digest
            read_lock: CSR
            key_sel: NoKey
            integrity: true
            bkout_type: false
            zeroizable: false
            items:
            [
              {
                name: ROT_CREATOR_AUTH_STATE_ECDSA_KEY0
                size: 4
                isdigest: false
                iszer: false
                ismubi: false
                iskeymgr_creator: false
                iskeymgr_owner: false
                inv_default: 0
                offset: 1608
              }
              {
                name: ROT_CREATOR_AUTH_STATE_ECDSA_KEY1
                size: 4
                isdigest: false
                iszer: false
                ismubi: false
                iskeymgr_creator: false
                iskeymgr_owner: false
                inv_default: 0
                offset: 1612
              }
              {
                name: ROT_CREATOR_AUTH_STATE_ECDSA_KEY2
                size: 4
                isdigest: false
                iszer: false
                ismubi: false
                iskeymgr_creator: false
                iskeymgr_owner: false
                inv_default: 0
                offset: 1616
              }
              {
                name: ROT_CREATOR_AUTH_STATE_ECDSA_KEY3
                size: 4
                isdigest: false
                iszer: false
                ismubi: false
                iskeymgr_creator: false
                iskeymgr_owner: false
                inv_default: 0
                offset: 1620
              }
              {
                name: ROT_CREATOR_AUTH_STATE_SPX_KEY0
                size: 4
                isdigest: false
                iszer: false
                ismubi: false
                iskeymgr_creator: false
                iskeymgr_owner: false
                inv_default: 0
                offset: 1624
              }
              {
                name: ROT_CREATOR_AUTH_STATE_SPX_KEY1
                size: 4
                isdigest: false
                iszer: false
                ismubi: false
                iskeymgr_creator: false
                iskeymgr_owner: false
                inv_default: 0
                offset: 1628
              }
              {
                name: ROT_CREATOR_AUTH_STATE_SPX_KEY2
                size: 4
                isdigest: false
                iszer: false
                ismubi: false
                iskeymgr_creator: false
                iskeymgr_owner: false
                inv_default: 0
                offset: 1632
              }
              {
                name: ROT_CREATOR_AUTH_STATE_SPX_KEY3
                size: 4
                isdigest: false
                iszer: false
                ismubi: false
                iskeymgr_creator: false
                iskeymgr_owner: false
                inv_default: 0
                offset: 1636
              }
              {
                name: ROT_CREATOR_AUTH_STATE_DIGEST
                size: 8
                offset: 1640
                ismubi: false
                isdigest: true
                iszer: false
                inv_default: 9901336721023614529
                iskeymgr_creator: false
                iskeymgr_owner: false
              }
            ]
            desc:
              '''
              This OTP partition is used to capture the state of
              each key slot. Each key can be in one of the
              following states: BLANK, ENABLED, DISABLED. The
              encoded values are such that transitions between
              BLANK -> ENABLED ->  DISABLED are possible without
              causing ECC errors (this is a mechanism similar to
              how we manage life cycle state transitions). The
              partition is left unlocked to allow STATE updates in
              the field. The ROM_EXT is required to lock access to
              the OTP Direct Access Interface to prevent DoS
              attacks from malicious code executing on Silicon
              Owner partitions. DAI write locking is available in
              EarlGrey.
              '''
            iskeymgr_creator: false
            iskeymgr_owner: false
            ignore_read_lock_in_rma: false
            size: 40
            offset: 1608
          }
          {
            name: HW_CFG0
            variant: Buffered
            secret: false
            sw_digest: false
            hw_digest: true
            write_lock: Digest
            read_lock: None
            key_sel: NoKey
            integrity: true
            bkout_type: true
            skip_sw_header: true
            zeroizable: false
            items:
            [
              {
                name: DEVICE_ID
                size: 32
                inv_default: 55530846908657555531706223372618995525581232455492676800790901459534844803547
                desc:
                  '''
                  Unique device identifier that is always exposed through the
                  lifecycle JTAG tap. See OpenTitan documentation on Device
                  Identifiers.
                  '''
                isdigest: false
                iszer: false
                ismubi: false
                iskeymgr_creator: false
                iskeymgr_owner: false
                offset: 1648
              }
              {
                name: MANUF_STATE
                size: 32
                inv_default: 10571946878513046603237907431809190521408891965256924791572121351254888273028
                desc:
                  '''
                  Field to capture manufacturing status. Currently unused. Set
                  to 0.
                  '''
                isdigest: false
                iszer: false
                ismubi: false
                iskeymgr_creator: false
                iskeymgr_owner: false
                offset: 1680
              }
              {
                name: HW_CFG0_DIGEST
                size: 8
                offset: 1712
                ismubi: false
                isdigest: true
                iszer: false
                inv_default: 6236140243366831054
                iskeymgr_creator: false
                iskeymgr_owner: false
              }
            ]
            desc:
              '''
              Hardware configuration 0 partition.
              This contains a device identifier and manufacturing state.
              '''
            absorb: false
            iskeymgr_creator: false
            iskeymgr_owner: false
            ignore_read_lock_in_rma: false
            size: 72
            offset: 1648
          }
          {
            name: HW_CFG1
            variant: Buffered
            secret: false
            sw_digest: false
            hw_digest: true
            write_lock: Digest
            read_lock: None
            key_sel: NoKey
            integrity: true
            bkout_type: true
            skip_sw_header: true
            zeroizable: false
            items:
            [
              {
                name: EN_SRAM_IFETCH
                size: 1
                ismubi: true
                inv_default: 105
                desc:
                  '''
                  Enablement of execute from SRAM switch in the sram_ctrl (see
                  EXEC CSR). A kMultiBitBool8True value enables, while all
                  other values disable.
                  '''
                isdigest: false
                iszer: false
                iskeymgr_creator: false
                iskeymgr_owner: false
                offset: 1720
              }
              {
                name: EN_CSRNG_SW_APP_READ
                size: 1
                ismubi: true
                inv_default: 105
                desc:
                  '''
                  Enablement of CSRNG software application interface. A
                  kMultiBitBool8True value enables, while all other values
                  disable. Enablement is required to extract output from
                  CSRNG via software.
                  '''
                isdigest: false
                iszer: false
                iskeymgr_creator: false
                iskeymgr_owner: false
                offset: 1721
              }
              {
                name: DIS_RV_DM_LATE_DEBUG
                size: 1
                ismubi: true
                inv_default: 105
                desc:
                  '''
                  Disablement of RV_DM late debug feature (see rv_dm
                  documentation). A kMultiBitBool8True disables the late debug
                  feature and renders the rv_dm fully ungated in DEV lifecycle
                  states. All other values gate rv_dm reachability based on
                  the value of LATE_DEBUG_ENABLE CSR in the rv_dm block.
                  '''
                isdigest: false
                iszer: false
                iskeymgr_creator: false
                iskeymgr_owner: false
                offset: 1722
              }
              {
                name: HW_CFG1_DIGEST
                size: 8
                offset: 1728
                ismubi: false
                isdigest: true
                iszer: false
                inv_default: 16103824935462190277
                iskeymgr_creator: false
                iskeymgr_owner: false
              }
            ]
            desc:
              '''
              Hardware configuration 1 partition.
              This contains several hardware feature switches.
              '''
            absorb: false
            iskeymgr_creator: false
            iskeymgr_owner: false
            ignore_read_lock_in_rma: false
            size: 16
            offset: 1720
          }
          {
            name: SECRET0
            variant: Buffered
            secret: true
            sw_digest: false
            hw_digest: true
            write_lock: Digest
            read_lock: Digest
            ignore_read_lock_in_rma: true
            key_sel: Secret0Key
            integrity: true
            bkout_type: false
            skip_sw_header: true
            zeroizable: true
            items:
            [
              {
                name: TEST_UNLOCK_TOKEN
                inv_default: 250497149396770327952206041105615885168
                size: 16
                isdigest: false
                iszer: false
                ismubi: false
                iskeymgr_creator: false
                iskeymgr_owner: false
                offset: 1736
              }
              {
                name: TEST_EXIT_TOKEN
                inv_default: 202583796664497922322878020928417080390
                size: 16
                isdigest: false
                iszer: false
                ismubi: false
                iskeymgr_creator: false
                iskeymgr_owner: false
                offset: 1752
              }
              {
                name: SECRET0_DIGEST
                size: 8
                offset: 1768
                ismubi: false
                isdigest: true
                iszer: false
                inv_default: 8467910270735405
                iskeymgr_creator: false
                iskeymgr_owner: false
              }
              {
                name: SECRET0_ZER
                size: 8
                offset: 1776
                ismubi: false
                isdigest: false
                iszer: true
                inv_default: 0
                iskeymgr_creator: false
                iskeymgr_owner: false
              }
            ]
            desc:
              '''
              Secret partition 0.
              This contains TEST lifecycle unlock tokens.
              '''
            absorb: false
            iskeymgr_creator: false
            iskeymgr_owner: false
            size: 48
            offset: 1736
          }
          {
            name: SECRET1
            variant: Buffered
            secret: true
            sw_digest: false
            hw_digest: true
            write_lock: Digest
            read_lock: Digest
            ignore_read_lock_in_rma: true
            key_sel: Secret1Key
            integrity: true
            bkout_type: false
            skip_sw_header: true
            zeroizable: true
            items:
            [
              {
                name: NVM_ADDR_KEY_SEED
                inv_default: 45553222205375505531056818163346296644806755634554894226675216589506912023402
                size: 32
                isdigest: false
                iszer: false
                ismubi: false
                iskeymgr_creator: false
                iskeymgr_owner: false
                offset: 1784
              }
              {
                name: NVM_DATA_KEY_SEED
                inv_default: 38285182093252413091650582675640097466814488494417681634384456313350941441436
                size: 32
                isdigest: false
                iszer: false
                ismubi: false
                iskeymgr_creator: false
                iskeymgr_owner: false
                offset: 1816
              }
              {
                name: SRAM_DATA_KEY_SEED
                inv_default: 114818820390911932356426594040990850415
                size: 16
                isdigest: false
                iszer: false
                ismubi: false
                iskeymgr_creator: false
                iskeymgr_owner: false
                offset: 1848
              }
              {
                name: SECRET1_DIGEST
                size: 8
                offset: 1864
                ismubi: false
                isdigest: true
                iszer: false
                inv_default: 4056023092994342650
                iskeymgr_creator: false
                iskeymgr_owner: false
              }
              {
                name: SECRET1_ZER
                size: 8
                offset: 1872
                ismubi: false
                isdigest: false
                iszer: true
                inv_default: 0
                iskeymgr_creator: false
                iskeymgr_owner: false
              }
            ]
            desc:
              '''
              Secret partition 1.
              This contains SRAM and NVM scrambling keys.
              '''
            absorb: false
            iskeymgr_creator: false
            iskeymgr_owner: false
            size: 96
            offset: 1784
          }
          {
            name: SECRET2
            variant: Buffered
            secret: true
            sw_digest: false
            hw_digest: true
            write_lock: Digest
            read_lock: Digest
            ignore_read_lock_in_rma: true
            key_sel: Secret2Key
            integrity: true
            bkout_type: false
            skip_sw_header: true
            zeroizable: true
            items:
            [
              {
                name: RMA_TOKEN
                inv_default: 67987365774749943300313112008098328447
                size: 16
                isdigest: false
                iszer: false
                ismubi: false
                iskeymgr_creator: false
                iskeymgr_owner: false
                offset: 1880
              }
              {
                name: CREATOR_ROOT_KEY_SHARE0
                inv_default: 25107113002565718362972229369406712307077327505567871892018373178413397358952
                size: 32
                iskeymgr_creator: true
                isdigest: false
                iszer: false
                ismubi: false
                iskeymgr_owner: false
                offset: 1896
              }
              {
                name: CREATOR_ROOT_KEY_SHARE1
                inv_default: 97190113357435963470420612739456405550306030654118370004629633772295722868751
                size: 32
                iskeymgr_creator: true
                isdigest: false
                iszer: false
                ismubi: false
                iskeymgr_owner: false
                offset: 1928
              }
              {
                name: SECRET2_DIGEST
                size: 8
                offset: 1960
                ismubi: false
                isdigest: true
                iszer: false
                inv_default: 17692002389534325074
                iskeymgr_creator: false
                iskeymgr_owner: false
              }
              {
                name: SECRET2_ZER
                size: 8
                offset: 1968
                ismubi: false
                isdigest: false
                iszer: true
                inv_default: 0
                iskeymgr_creator: false
                iskeymgr_owner: false
              }
            ]
            desc:
              '''
              Secret partition 2.
              This contains RMA unlock token, creator root key, and creator seed.
              '''
            absorb: false
            iskeymgr_creator: true
            iskeymgr_owner: false
            size: 96
            offset: 1880
          }
          {
            name: LIFE_CYCLE
            variant: LifeCycle
            secret: false
            sw_digest: false
            hw_digest: false
            write_lock: None
            read_lock: None
            key_sel: NoKey
            integrity: true
            bkout_type: false
            skip_sw_header: true
            zeroizable: false
            items:
            [
              {
                name: LC_TRANSITION_CNT
                inv_default: 36547239814968950675270266603718710860199702009457479176296663812534718147950124049968618911279337152360497595145434
                size: 48
                isdigest: false
                iszer: false
                ismubi: false
                iskeymgr_creator: false
                iskeymgr_owner: false
                offset: 1976
              }
              {
                name: LC_STATE
                inv_default: 186402203868873673160243174477532200584683723204874444823768914221879417048680339050270326481588
                size: 40
                isdigest: false
                iszer: false
                ismubi: false
                iskeymgr_creator: false
                iskeymgr_owner: false
                offset: 2024
              }
            ]
            desc:
              '''
              Lifecycle partition.
              This contains lifecycle transition count and state. This partition
              cannot be locked since the life cycle state needs to advance to RMA
              in-field. Note that while this partition is not marked secret, it
              is not readable nor writeable via the DAI. Only the LC controller
              can access this partition, and even via the LC controller it is not
              possible to read the raw manufacturing life cycle state in encoded
              form, since that encoding is considered a netlist secret. The LC
              controller only exposes a decoded version of this state.
              '''
            absorb: false
            iskeymgr_creator: false
            iskeymgr_owner: false
            ignore_read_lock_in_rma: false
            size: 88
            offset: 1976
          }
        ]
      }
    }
    {
      name: lc_ctrl
      type: lc_ctrl
      base_addrs:
      {
        regs:
        {
          hart: 0x40140000
        }
      }
      memory: {}
      param_list:
      [
        {
          name: RndCnstLcKeymgrDivInvalid
          desc: Diversification value used for all invalid life cycle states.
          type: lc_ctrl_pkg::lc_keymgr_div_t
          randcount: 128
          randtype: data
          name_top: RndCnstLcCtrlLcKeymgrDivInvalid
          default: 0x8c14809e0a20f7f979bf692eca005096
          randwidth: 128
        }
        {
          name: RndCnstLcKeymgrDivTestUnlocked
          desc: Diversification value used for the TEST_UNLOCKED* life cycle states.
          type: lc_ctrl_pkg::lc_keymgr_div_t
          randcount: 128
          randtype: data
          name_top: RndCnstLcCtrlLcKeymgrDivTestUnlocked
          default: 0x81fe8ffdfe0c771754005214d3f0cc6
          randwidth: 128
        }
        {
          name: RndCnstLcKeymgrDivDev
          desc: Diversification value used for the DEV life cycle state.
          type: lc_ctrl_pkg::lc_keymgr_div_t
          randcount: 128
          randtype: data
          name_top: RndCnstLcCtrlLcKeymgrDivDev
          default: 0xb7aa378530c10dd72477c47aa0eb970f
          randwidth: 128
        }
        {
          name: RndCnstLcKeymgrDivProduction
          desc: Diversification value used for the PROD/PROD_END life cycle states.
          type: lc_ctrl_pkg::lc_keymgr_div_t
          randcount: 128
          randtype: data
          name_top: RndCnstLcCtrlLcKeymgrDivProduction
          default: 0x1443777aa1f10cfc4c0b23f1629b563d
          randwidth: 128
        }
        {
          name: RndCnstLcKeymgrDivRma
          desc: Diversification value used for the RMA life cycle state.
          type: lc_ctrl_pkg::lc_keymgr_div_t
          randcount: 128
          randtype: data
          name_top: RndCnstLcCtrlLcKeymgrDivRma
          default: 0x9a0284e7a0a8b72be56f680bfe2096b4
          randwidth: 128
        }
        {
          name: RndCnstInvalidTokens
          desc: Compile-time random bits used for invalid tokens in the token mux
          type: lc_ctrl_pkg::lc_token_mux_t
          randcount: 1024
          randtype: data
          name_top: RndCnstLcCtrlInvalidTokens
          default: 0x9fedb97cb88f8f255a4ada4fa320aa882689b418f126854b3b30204762f66abe7ba9a5a08e2368f0015c5dd01d224476f99e7b20f7881a36653ab70b9e0717c91cfceca84287601dd59ea67b4d275e1e94f7f23e7864ed285faf0c4e421bee50ce196aec3a5018111ae4e618a30d896ab6c4af99e53988ee06d5bf24e8a3dcda
          randwidth: 1024
        }
      ]
    }
    {
      name: alert_handler
      type: alert_handler
      base_addrs:
      {
        null:
        {
          hart: 0x40150000
        }
      }
      memory: {}
      param_list:
      [
        {
          name: RndCnstLfsrSeed
          desc: Compile-time random bits for initial LFSR seed
          type: alert_handler_pkg::lfsr_seed_t
          randcount: 32
          randtype: data
          name_top: RndCnstAlertHandlerLfsrSeed
          default: 0xe583223a
          randwidth: 32
        }
        {
          name: RndCnstLfsrPerm
          desc: Compile-time random permutation for LFSR output
          type: alert_handler_pkg::lfsr_perm_t
          randcount: 32
          randtype: perm
          name_top: RndCnstAlertHandlerLfsrPerm
          default: 0xbe0fdd204f2838adb4795c8919d5d6833f40f8c9
          randwidth: 160
        }
      ]
      template_type: alert_handler
    }
    {
      name: sram_ctrl_ret
      type: sram_ctrl
      base_addrs:
      {
        regs:
        {
          hart: 0x40500000
        }
        ram:
        {
          hart: 0x40600000
        }
      }
      memory:
      {
        ram:
        {
          label: ram_ret_aon
          swaccess: rw
          data_intg_passthru: "true"
          exec: True
          byte_write: True
          size: 0x1000
        }
      }
      param_list:
      [
        {
          name: RndCnstSramKey
          desc: Compile-time random reset value for SRAM scrambling key.
          type: otp_ctrl_pkg::sram_key_t
          randcount: 128
          randtype: data
          name_top: RndCnstSramCtrlRetSramKey
          default: 0xcba642cf8b7d74a696f14d83bc9cbb67
          randwidth: 128
        }
        {
          name: RndCnstSramNonce
          desc: Compile-time random reset value for SRAM scrambling nonce.
          type: otp_ctrl_pkg::sram_nonce_t
          randcount: 128
          randtype: data
          name_top: RndCnstSramCtrlRetSramNonce
          default: 0x393ecfb1e7d2f69338ab42ad967d0d56
          randwidth: 128
        }
        {
          name: RndCnstLfsrSeed
          desc: Compile-time random bits for initial LFSR seed
          type: sram_ctrl_pkg::lfsr_seed_t
          randcount: 64
          randtype: data
          name_top: RndCnstSramCtrlRetLfsrSeed
          default: 0x91083a37dcc78cc1
          randwidth: 64
        }
        {
          name: RndCnstLfsrPerm
          desc: Compile-time random permutation for LFSR output
          type: sram_ctrl_pkg::lfsr_perm_t
          randcount: 64
          randtype: perm
          name_top: RndCnstSramCtrlRetLfsrPerm
          default: 0xf0170b18292edfad69b17478abf3ad9d4cd31c5da55a860f6557e642210a6be8efef1372270e5e3120c801d86bf606f4
          randwidth: 384
        }
      ]
    }
    {
      name: rram_ctrl
      type: rram_ctrl
      base_addrs:
      {
        core:
        {
          hart: 0x41010000
        }
        host:
        {
          hart: 0x30000000
        }
      }
      memory:
      {
        host:
        {
          label: rram
          swaccess: ro
          data_intg_passthru: "true"
          exec: True
          byte_write: False
          size: 0x200000
        }
      }
      param_list:
      [
        {
          name: RndCnstAddrKey
          desc: Compile-time random bits for default address key
          type: rram_ctrl_pkg::rram_key_t
          randcount: 128
          randtype: data
          name_top: RndCnstRramCtrlAddrKey
          default: 0xeec389087d1cb943ea5a3e4b4ca72f85
          randwidth: 128
        }
        {
          name: RndCnstDataKey
          desc: Compile-time random bits for default data key
          type: rram_ctrl_pkg::rram_key_t
          randcount: 128
          randtype: data
          name_top: RndCnstRramCtrlDataKey
          default: 0x58b34114ee9203a94044e6fc7ca539f
          randwidth: 128
        }
        {
          name: RndCnstAllSeeds
          desc: Compile-time random bits for default seeds
          type: rram_ctrl_pkg::all_seeds_t
          randcount: 512
          randtype: data
          name_top: RndCnstRramCtrlAllSeeds
          default: 0x552cb801e72bfa7c14b730ec4cc6e0d963f8d3b02804c41ef937f6bd4609f1919a2b937e8ea7db17f31adcebea4a3d8f4d3f97da771ff9a7651a7a2980962aa3
          randwidth: 512
        }
        {
          name: RndCnstLfsrSeed
          desc: Compile-time random bits for initial LFSR seed
          type: rram_ctrl_pkg::lfsr_seed_t
          randcount: 64
          randtype: data
          name_top: RndCnstRramCtrlLfsrSeed
          default: 0xf903bdb8130f3873
          randwidth: 64
        }
        {
          name: RndCnstLfsrPerm
          desc: Compile-time random permutation for LFSR output
          type: rram_ctrl_pkg::lfsr_perm_t
          randcount: 64
          randtype: perm
          name_top: RndCnstRramCtrlLfsrPerm
          default: 0x42572c0c589f68cc5992098f741e39ff52f75d16edef6cc4f2fa5503ea9350d9e3847d0a230bbdcab18e7ba0a8598252
          randwidth: 384
        }
      ]
    }
    {
      name: aes
      type: aes
      base_addrs:
      {
        null:
        {
          hart: 0x41100000
        }
      }
      memory: {}
      param_list:
      [
        {
          name: RndCnstClearingLfsrSeed
          desc: Default seed of the PRNG used for register clearing.
          type: aes_pkg::clearing_lfsr_seed_t
          randcount: 64
          randtype: data
          name_top: RndCnstAesClearingLfsrSeed
          default: 0xc766ff863c5ec901
          randwidth: 64
        }
        {
          name: RndCnstClearingLfsrPerm
          desc: Permutation applied to the LFSR of the PRNG used for clearing.
          type: aes_pkg::clearing_lfsr_perm_t
          randcount: 64
          randtype: perm
          name_top: RndCnstAesClearingLfsrPerm
          default: 0x6ddaa45fb82e470cb6128cd02dfbe66869403a90e251378124220afe1f379d95bee7dd7a3d834772d331b2b4b45458f8
          randwidth: 384
        }
        {
          name: RndCnstClearingSharePerm
          desc: Permutation applied to the clearing PRNG output for clearing the second share of registers.
          type: aes_pkg::clearing_lfsr_perm_t
          randcount: 64
          randtype: perm
          name_top: RndCnstAesClearingSharePerm
          default: 0x67cd278a4a08b1fb8396fd7b616dcdc0728ecb8766100e94af369547d86da71fea3e0f928cc2f60855dc7936c9181439
          randwidth: 384
        }
        {
          name: RndCnstMaskingLfsrSeed
          desc: Default seed of the PRNG used for masking.
          type: aes_pkg::masking_lfsr_seed_t
          randcount: 288
          randtype: data
          name_top: RndCnstAesMaskingLfsrSeed
          default: 0x6a988825e405ffeeadcb17a19cc2f68935ae809e2713b9250e9b07c9a1b14586bdcd973e
          randwidth: 288
        }
        {
          name: RndCnstMaskingLfsrPerm
          desc: Permutation applied to the output of the PRNG used for masking.
          type: aes_pkg::masking_lfsr_perm_t
          randcount: 160
          randtype: perm
          name_top: RndCnstAesMaskingLfsrPerm
          default: 0x753a6d8f8899787a913f5a9d6f0a9f8606246b978d3089222f80345637420240849e98836836543b7767191760723c211a480e7058419a2c1451311b7b38459b766257057d0b595295495c3326744b923e61290135791e0703947e46505d5e558b094712961d5b392e28104c6e85114427188e2a7f2573000c3d82201c668a69168c530f637c4d4a1f15812d65640d87136c6a234e049c3293904f2b085f7143
          randwidth: 1280
        }
      ]
    }
    {
      name: kmac
      type: kmac
      base_addrs:
      {
        null:
        {
          hart: 0x41120000
        }
      }
      memory: {}
      param_list:
      [
        {
          name: RndCnstLfsrSeed
          desc: Compile-time random data for PRNG default seed
          type: kmac_pkg::lfsr_seed_t
          randcount: 288
          randtype: data
          name_top: RndCnstKmacLfsrSeed
          default: 0x30afe945464cb314bfb5bdfd34794f0585ee98370c4e3b72e289c9263fca514818dcb3c7
          randwidth: 288
        }
        {
          name: RndCnstLfsrPerm
          desc: Compile-time random permutation for PRNG output
          type: kmac_pkg::lfsr_perm_t
          randcount: 800
          randtype: perm
          name_top: RndCnstKmacLfsrPerm
          default: 0xa6d121b109200bd5209468cb0648779a6da0f2143902295313c6a704a5fc64e5f3e044592f99bd632ff094518f3410637ce3aa24cb1ca5710b96bf085e9f03383b38ab61696f9f639c4924ae4327714c282e37dafab7aaa5398375da681a55356b217a29270fe99a720d4c929c345d2366812a4a1fe35d445351756af38d24a3656d997190fe42305d659c9028eb16b53f9b8e02f8439f8038886ebc6477c9e2190d40b8633b6e56f8c4650e8488da5895e52de37ac1fa05ef1082ca623ab440a9d1521183e7a088344a695f11015c02382a46ed5691d25fe0713dcf6890c1bc0f4942457e1a66cf11c85db4e1004e5062c110991da59b2a0db6a1ef61801c6b00d4370c62ab55ef0461cad7748401ea54c9d54aca167e014d8a4a70db2d89297a3d618fc258785f8103d675159031424399cb119886301990d8485285782c3933c892a1ea5dee6b18c5a75c59e1d905da7822d0611372468f5d9b313add35a8831cd8740812c81e860d28251e5018e2d09e28b0e14e46ba96e53e49106dbc1c85bf20e3dae12356830dcd7a6357e15d55139ac071bfaa7808476d1494f0371f17d541ee601ce25c55ba4f05e1968ec4c9fe8d150698567a9a9f1b009a94ddbb5d7559a2a81513bba94af8dc12c99858ac5a9b58c71f32d8c0f5fbb04616bb1096c67bd25686ecc971edb81b01f9e1c51ba4f85cc5542162e7914f4695d87053396a13486919eea0abe68545c992f035b17340a33c007d55e3230a6456eabc145b89af59e4f750c150940b8e1c3585829022470acb6dc8a9b452565a9b26624561c6eecd74caf009451d08b4597098dbf004ef1b4e97919c06a8627706146bc949793fd5c260335cafda78c83ec0c71a2c1e88c2aee8778936e2ba4230b596932a82da8cfa4619d8deb74411147ebf7d22d6c6d48ae2fa5c20396595050049aef46a0404a8c20a27801d1b4a3051c188fe58386ec56079b724426de70adca4bd6bbae954171b8a068065384b2775c531b2241b3ebb406905827c1158d4ec836f24f73220a3a12c621e2a6f083e1105076075b9b659e77dffc5e3e645e03a83862519a993a88c4d429f7374306ad0fab248bdd9aa08fd54ea9481983292d7cead06d0794680b585f686ca1280ec055642dc72546523c734d621c2a73164877b2c431b0f0a4752e827b3930622d805831752f2896e4985900beb37d4cd6571dbb69f7e5cb981faa26173cd2380cf28f0ae79a4e616a2399da60699023024b927a14b51accca121d189fd39cb70866b3e70db1504abac39d87b974093b28ab7d9743a718329251af810000a86b8794eec707f8361fc59346a2e27222e9b0de5f1690a0bba6b1e3ac491aa4d018d3a2eb44f51c6aa0ab0abd556ff2f1bd08cb82ce191c2fb0109fa903a
          randwidth: 8000
        }
        {
          name: RndCnstBufferLfsrSeed
          desc: Compile-time random data for PRNG buffer default seed
          type: kmac_pkg::buffer_lfsr_seed_t
          randcount: 800
          randtype: data
          name_top: RndCnstKmacBufferLfsrSeed
          default: 0x631439b43907c31e40dae7cc914e3f18d067045f6a5d559ef83e274644e5b104af0e4658a0909da3852cf35e3dc04ae39de052be5bd663299a01b5126e1652cb6c5bbb31aab2d39c6eb6778350a558733edb9b0a911752cfe9524a0f0c65603a8f661db6
          randwidth: 800
        }
        {
          name: RndCnstMsgPerm
          desc: Compile-time random permutation for LFSR Message output
          type: kmac_pkg::msg_perm_t
          randcount: 64
          randtype: perm
          name_top: RndCnstKmacMsgPerm
          default: 0x92de845eccea2632fec9be590d4e1240fb95741d0082fc4617678888230a6b5f16ddf47fa4df673a6730a21625ed3ac7
          randwidth: 384
        }
      ]
    }
    {
      name: otbn
      type: otbn
      base_addrs:
      {
        null:
        {
          hart: 0x41130000
        }
      }
      memory: {}
      param_list:
      [
        {
          name: RndCnstUrndPrngSeed
          desc: Default seed of the PRNG used for URND.
          type: otbn_pkg::urnd_prng_seed_t
          randcount: 288
          randtype: data
          name_top: RndCnstOtbnUrndPrngSeed
          default: 0x85b92efd07b7adc5cfecc25210176bb4737347a2eaeeddc5518e2e1dbfa516e8a695b863
          randwidth: 288
        }
        {
          name: RndCnstUrndPerm
          desc: Compile-time random permutation applied to the primary URND output, directly after the PRNG and before it is distributed to the rest of the design.
          type: otbn_pkg::urnd_perm_t
          randcount: 389
          randtype: perm
          name_top: RndCnstOtbnUrndPerm
          default: 0x14d8ba0e422b073803e2322cc8d42290221561881ad15411aa3a0393e3b2bc05168a842a236593a6254613b0d94cb2a828a24601d0ac17462129a4d146c517f1c0a59492db1828c086095e084295a54349af98516000ff7d20a5f5a53260ca34501ac5e6c70b71dcb7bc0a424d63a8fc6e91332110e4c4a33a4c8c319a16c7aab3684b622dcba50f06bbf4fd474741cfe9a7c42e263929242f8992e2887ccf1de0da100b78782ec887512329fbbc229881b341a5555b70ccf8fc431a43a789fa90eed9a586c634554b1c5893032c0138033cd65b01a41657448541d27b1eaf3d23f6a84c30b4ea395c58ac044b30f64ebd442696972b1a52b304101b0247f55ec27153dd9e219429115a961d54d76ac698cab25f8148da857bf5383479608b6096b14490c47300c6ca6705cbde784f1509aeaaeafccd93368c3554b7fa7c1517439d0e1709d9dd7084bd09b35bc4173df6b68058c44c815a4a84a09b36834dc56b65061f7b239f51f8191082612c5f25ea0edb44df08f6038f5bee6451524b52b1b7578fbaebd6ce9c30bbd3c9205d62731d6105a62eb2e92dd8e3b90d41938b9bc8bcb57249ee043b20f1e6e2078ba346fa0016db79
          randwidth: 3501
        }
        {
          name: RndCnstBnMacUrndPerm
          desc: Compile-time random permutation for URND permutation in BN MAC.
          type: otbn_pkg::bn_mac_urnd_perm_t
          randcount: 256
          randtype: perm
          name_top: RndCnstOtbnBnMacUrndPerm
          default: 0xc6bdd193aa591d761547f6dd56a5165c60cca0c4edc8e38d1a35a914832e3d049b530d43adee9290fa9db8d777fe0c106d69abe2e0afa68b9fb22c3e6b715ac1fb0f7ad2ce5546ff6af225c723f1cd480b190178dcec18d57b133b276e2fea660080b70533c2a72282d8d3b9c51ff409869af7e445fd99d65e652642968a817989208e5721e894b18775c08fba2aac317c39497d671c2430f59c584e744a3fe54b9efc5da24f1b6fe96ca351915b418436b3efb0a137cba4851238f3c3f808077e03b5e16168cfd070f90e977f2b17f04498bcdb1132bb4db4883c2d63deb64c6450eb40285202d9df0a95733a5434ca0672a8da1e62aec9be298ce6bf5fe7d4
          randwidth: 2048
        }
        {
          name: RndCnstMaiUrndPerm
          desc: Compile-time random permutation for URND permutation in MAI.
          type: otbn_pkg::mai_urnd_perm_t
          randcount: 389
          randtype: perm
          name_top: RndCnstOtbnMaiUrndPerm
          default: 0xcb78582549ba306658b0235b03e0b2f58c8a6382228c30a50145310925462f52151c757eb4013fc8e17035ce00ae80a0a7477ab23d8c4c21975384d215ca276ac03e4cad552599783834d2d76601f9b2ee24551f04c8c7c13840dd662b59049183868a522a90462d4ae3c8f0223a561588b7780c5c04bccc4ed199315e4b340d604b30f68365d4f43339adf2b1dcb65e0e03a385687442c5b144621ee52d22d4dd0a4854da5742dbeb6cc8165aaa2a97067159f6e00c43994893380650f70a30c81527e4f5f428842ca2a705b5f92d179c9fe374e9dc9dc40a3f5d09722511aa9350bf940226819c15d16e7e8d8255f041ca80911f254c4f38a33ef143579beb4376f419ed6b8fb147af555d35fc39029c5af3e2a4fe3d682253e6d0c718d4db5e3ac4aaae439df1d6b714962ca5b423944b5952878469206d91b41db689d3c7a1a251aceeaed5d26f11906d80c9b3b9e3507a9a649f4760c92a3419ad8a601c4d3b184b350b4e048191cca7083298bd209f3cba5da5f0603ef74a3e886c21308612eb48b8c368486ada761680535d97ac753b34583a049707897a6480d68d5c1b9731068b73073c88c7054be9740f04008b37e6615
          randwidth: 3501
        }
        {
          name: RndCnstOtbnKey
          desc: Compile-time random reset value for IMem/DMem scrambling key.
          type: otp_ctrl_pkg::otbn_key_t
          randcount: 128
          randtype: data
          name_top: RndCnstOtbnOtbnKey
          default: 0x7ed5fb238388402f1024267e80168cd7
          randwidth: 128
        }
        {
          name: RndCnstOtbnNonce
          desc: Compile-time random reset value for IMem/DMem scrambling nonce.
          type: otp_ctrl_pkg::otbn_nonce_t
          randcount: 64
          randtype: data
          name_top: RndCnstOtbnOtbnNonce
          default: 0xd429f6f9a6ffd99f
          randwidth: 64
        }
      ]
    }
    {
      name: keymgr_dpe
      type: keymgr_dpe
      base_addrs:
      {
        null:
        {
          hart: 0x41140000
        }
      }
      memory: {}
      param_list:
      [
        {
          name: RndCnstLfsrSeed
          desc: Compile-time random bits for initial LFSR seed
          type: keymgr_dpe_pkg::lfsr_seed_t
          randcount: 64
          randtype: data
          name_top: RndCnstKeymgrDpeLfsrSeed
          default: 0x84e0903c916b5070
          randwidth: 64
        }
        {
          name: RndCnstLfsrPerm
          desc: Compile-time random permutation for LFSR output
          type: keymgr_dpe_pkg::lfsr_perm_t
          randcount: 64
          randtype: perm
          name_top: RndCnstKeymgrDpeLfsrPerm
          default: 0x72ecf5b7dbde63a7e53a401af3b3eb0e9dca990fd6a0c8939c10b87748f0a9485b2f9671f87d8d1882445c5460c92b15
          randwidth: 384
        }
        {
          name: RndCnstRandPerm
          desc: Compile-time random permutation for entropy used in share overriding
          type: keymgr_dpe_pkg::rand_perm_t
          randcount: 32
          randtype: perm
          name_top: RndCnstKeymgrDpeRandPerm
          default: 0x5c8aaca517f18eea46c166843fd5a4076788736f
          randwidth: 160
        }
        {
          name: RndCnstRevisionSeed
          desc: Compile-time random bits for revision seed
          type: keymgr_dpe_pkg::seed_t
          randcount: 256
          randtype: data
          name_top: RndCnstKeymgrDpeRevisionSeed
          default: 0x518d44f0e1829b14b8f03026bf6df0116af77d3aa25c37b1ddc04f6bee51cf42
          randwidth: 256
        }
        {
          name: RndCnstSoftOutputSeed
          desc: Compile-time random bits for software generation seed
          type: keymgr_dpe_pkg::seed_t
          randcount: 256
          randtype: data
          name_top: RndCnstKeymgrDpeSoftOutputSeed
          default: 0xb870eeb9465d10414897ad3924658ce5bb0a6eafbba5acd035dd7700fcf1d48
          randwidth: 256
        }
        {
          name: RndCnstHardOutputSeed
          desc: Compile-time random bits for hardware generation seed
          type: keymgr_dpe_pkg::seed_t
          randcount: 256
          randtype: data
          name_top: RndCnstKeymgrDpeHardOutputSeed
          default: 0xebd0513af0c164b52e884f90f2e62d13a5968de632180ff3215b26235f17e733
          randwidth: 256
        }
        {
          name: RndCnstAesSeed
          desc: Compile-time random bits for generation seed when aes destination selected
          type: keymgr_dpe_pkg::seed_t
          randcount: 256
          randtype: data
          name_top: RndCnstKeymgrDpeAesSeed
          default: 0x71b938ccc209b5126629c48e1ab45ad46b270c168892472f5072ee3ca90b34eb
          randwidth: 256
        }
        {
          name: RndCnstKmacSeed
          desc: Compile-time random bits for generation seed when kmac destination selected
          type: keymgr_dpe_pkg::seed_t
          randcount: 256
          randtype: data
          name_top: RndCnstKeymgrDpeKmacSeed
          default: 0x329e9a276322cc738b91addaa137e6f637a69a201dca49d744a1cb7017026d90
          randwidth: 256
        }
        {
          name: RndCnstOtbnSeed
          desc: Compile-time random bits for generation seed when otbn destination selected
          type: keymgr_dpe_pkg::seed_t
          randcount: 256
          randtype: data
          name_top: RndCnstKeymgrDpeOtbnSeed
          default: 0xdc96907f05bafd751e56126b50ad5c68db4ea7c03669d35c1fbb82fdbdd0bc15
          randwidth: 256
        }
        {
          name: RndCnstHmacSeed
          desc: Compile-time random bits for generation seed when hmac destination selected
          type: keymgr_dpe_pkg::seed_t
          randcount: 256
          randtype: data
          name_top: RndCnstKeymgrDpeHmacSeed
          default: 0xb52baa0c5057cc2328956934a178ab4ae3a7537eee6264a3c067f0ae8787028b
          randwidth: 256
        }
        {
          name: RndCnstNoneSeed
          desc: Compile-time random bits for generation seed when no destination selected
          type: keymgr_dpe_pkg::seed_t
          randcount: 256
          randtype: data
          name_top: RndCnstKeymgrDpeNoneSeed
          default: 0xcc21e3fd65ccf384275c13422a2d18fb3da8de1f07e850b7f1bcdb08cc744a0f
          randwidth: 256
        }
      ]
    }
    {
      name: csrng
      type: csrng
      base_addrs:
      {
        null:
        {
          hart: 0x41150000
        }
      }
      memory: {}
      param_list:
      [
        {
          name: RndCnstCsKeymgrDivNonProduction
          desc: Compile-time random bits for csrng state group diversification value
          type: csrng_pkg::cs_keymgr_div_t
          randcount: 384
          randtype: data
          name_top: RndCnstCsrngCsKeymgrDivNonProduction
          default: 0x36a428fc3cc2481317d643025d14cbace9276534c3afd9bb620030b26306197da9b6f314d782ff5cae517b83bbecd428
          randwidth: 384
        }
        {
          name: RndCnstCsKeymgrDivProduction
          desc: Compile-time random bits for csrng state group diversification value
          type: csrng_pkg::cs_keymgr_div_t
          randcount: 384
          randtype: data
          name_top: RndCnstCsrngCsKeymgrDivProduction
          default: 0xd182cc4761ba188dd84c87100d52e6ce500195f4031a37c1770073400f05c664f9698168489337293ee24e425434b908
          randwidth: 384
        }
      ]
    }
    {
      name: sram_ctrl_main
      type: sram_ctrl
      base_addrs:
      {
        regs:
        {
          hart: 0x411C0000
        }
        ram:
        {
          hart: 0x10000000
        }
      }
      memory:
      {
        ram:
        {
          label: ram_main
          swaccess: rw
          data_intg_passthru: "true"
          exec: True
          byte_write: True
          size: 0x20000
        }
      }
      param_list:
      [
        {
          name: RndCnstSramKey
          desc: Compile-time random reset value for SRAM scrambling key.
          type: otp_ctrl_pkg::sram_key_t
          randcount: 128
          randtype: data
          name_top: RndCnstSramCtrlMainSramKey
          default: 0xad83ed89e532e2c3b270409598650110
          randwidth: 128
        }
        {
          name: RndCnstSramNonce
          desc: Compile-time random reset value for SRAM scrambling nonce.
          type: otp_ctrl_pkg::sram_nonce_t
          randcount: 128
          randtype: data
          name_top: RndCnstSramCtrlMainSramNonce
          default: 0x9446f3a0a9af793bd3a550e2c0dee27b
          randwidth: 128
        }
        {
          name: RndCnstLfsrSeed
          desc: Compile-time random bits for initial LFSR seed
          type: sram_ctrl_pkg::lfsr_seed_t
          randcount: 64
          randtype: data
          name_top: RndCnstSramCtrlMainLfsrSeed
          default: 0x296ce2bbf63b835a
          randwidth: 64
        }
        {
          name: RndCnstLfsrPerm
          desc: Compile-time random permutation for LFSR output
          type: sram_ctrl_pkg::lfsr_perm_t
          randcount: 64
          randtype: perm
          name_top: RndCnstSramCtrlMainLfsrPerm
          default: 0xd9b1a6efea7914ebed2c28fd25ac6c1eeeb4aa0756553f224753f8ca100d95420390aaf0ddc07f41e60464c9df4a85f3
          randwidth: 384
        }
      ]
    }
    {
      name: sram_ctrl_sec
      type: sram_ctrl
      base_addrs:
      {
        regs:
        {
          hart: 0x411D0000
        }
        ram:
        {
          hart: 0x10020000
        }
      }
      memory:
      {
        ram:
        {
          label: ram_secondary
          swaccess: rw
          data_intg_passthru: "true"
          exec: True
          byte_write: True
          size: 0x10000
        }
      }
      param_list:
      [
        {
          name: RndCnstSramKey
          desc: Compile-time random reset value for SRAM scrambling key.
          type: otp_ctrl_pkg::sram_key_t
          randcount: 128
          randtype: data
          name_top: RndCnstSramCtrlSecSramKey
          default: 0x188f580860b8d170b5b9a247b228dfd2
          randwidth: 128
        }
        {
          name: RndCnstSramNonce
          desc: Compile-time random reset value for SRAM scrambling nonce.
          type: otp_ctrl_pkg::sram_nonce_t
          randcount: 128
          randtype: data
          name_top: RndCnstSramCtrlSecSramNonce
          default: 0x32fe160377476658c8814a96e3cec90a
          randwidth: 128
        }
        {
          name: RndCnstLfsrSeed
          desc: Compile-time random bits for initial LFSR seed
          type: sram_ctrl_pkg::lfsr_seed_t
          randcount: 64
          randtype: data
          name_top: RndCnstSramCtrlSecLfsrSeed
          default: 0xbed0540e2b91ca1f
          randwidth: 64
        }
        {
          name: RndCnstLfsrPerm
          desc: Compile-time random permutation for LFSR output
          type: sram_ctrl_pkg::lfsr_perm_t
          randcount: 64
          randtype: perm
          name_top: RndCnstSramCtrlSecLfsrPerm
          default: 0x293527b5744f0f58dded87844ae6640bf22c15f96fcb6ad637a7103b8fb0cf9831f26abd6dadc18498951c03341a8a4b
          randwidth: 384
        }
      ]
    }
    {
      name: rom_ctrl
      type: rom_ctrl
      base_addrs:
      {
        rom:
        {
          hart: 0x00040000
        }
        regs:
        {
          hart: 0x411e0000
        }
      }
      memory:
      {
        rom:
        {
          label: rom
          swaccess: ro
          data_intg_passthru: True
          exec: True
          byte_write: False
          size: 0x30000
        }
      }
      param_list:
      [
        {
          name: RndCnstScrNonce
          desc: Fixed nonce used for address / data scrambling
          type: bit [63:0]
          randcount: 64
          randtype: data
          name_top: RndCnstRomCtrlScrNonce
          default: 0x3a577a4ecbbdf696
          randwidth: 64
        }
        {
          name: RndCnstScrKey
          desc: Randomised constant used as a scrambling key for ROM data
          type: bit [127:0]
          randcount: 128
          randtype: data
          name_top: RndCnstRomCtrlScrKey
          default: 0xfd2cd89c4a353c1d17c58a766cc797c8
          randwidth: 128
        }
      ]
    }
    {
      name: rv_core_ibex
      type: rv_core_ibex
      base_addrs:
      {
        cfg:
        {
          hart: 0x411F0000
        }
      }
      memory: {}
      param_list:
      [
        {
          name: RndCnstLfsrSeed
          desc: Default seed of the PRNG used for random instructions.
          type: ibex_pkg::lfsr_seed_t
          randcount: 32
          randtype: data
          name_top: RndCnstRvCoreIbexLfsrSeed
          default: 0xd086d3d
          randwidth: 32
        }
        {
          name: RndCnstLfsrPerm
          desc: Permutation applied to the LFSR of the PRNG used for random instructions.
          type: ibex_pkg::lfsr_perm_t
          randcount: 32
          randtype: perm
          name_top: RndCnstRvCoreIbexLfsrPerm
          default: 0x2c03c1d888aa7479e6ff9376259a2ca281e7bb1d
          randwidth: 160
        }
        {
          name: RndCnstIbexKey
          desc: Default icache scrambling key
          type: logic [ibex_pkg::SCRAMBLE_KEY_W-1:0]
          randcount: 128
          randtype: data
          name_top: RndCnstRvCoreIbexIbexKey
          default: 0xcf6a5979b019877c59a30ef573130b1c
          randwidth: 128
        }
        {
          name: RndCnstIbexNonce
          desc: Default icache scrambling nonce
          type: logic [ibex_pkg::SCRAMBLE_NONCE_W-1:0]
          randcount: 64
          randtype: data
          name_top: RndCnstRvCoreIbexIbexNonce
          default: 0x47b66509a3f24365
          randwidth: 64
        }
      ]
      template_type: rv_core_ibex
    }
    {
      name: sram_ctrl_meta
      type: sram_ctrl
      base_addrs:
      {
        regs:
        {
          hart: 0x411A0000
        }
        ram:
        {
          hart: 0x11000000
        }
      }
      memory:
      {
        ram:
        {
          label: ram_cheriot_meta
          swaccess: rw
          data_intg_passthru: "true"
          exec: false
          byte_write: False
          size: 0x9800
        }
      }
      param_list:
      [
        {
          name: RndCnstSramKey
          desc: Compile-time random reset value for SRAM scrambling key.
          type: otp_ctrl_pkg::sram_key_t
          randcount: 128
          randtype: data
          name_top: RndCnstSramCtrlMetaSramKey
          default: 0x4fec4bf9f323c075f3bdee69bb70285e
          randwidth: 128
        }
        {
          name: RndCnstSramNonce
          desc: Compile-time random reset value for SRAM scrambling nonce.
          type: otp_ctrl_pkg::sram_nonce_t
          randcount: 128
          randtype: data
          name_top: RndCnstSramCtrlMetaSramNonce
          default: 0x21ee604dab43391d1df4e9bf68f8ea94
          randwidth: 128
        }
        {
          name: RndCnstLfsrSeed
          desc: Compile-time random bits for initial LFSR seed
          type: sram_ctrl_pkg::lfsr_seed_t
          randcount: 64
          randtype: data
          name_top: RndCnstSramCtrlMetaLfsrSeed
          default: 0x9edbb1acee62e2b4
          randwidth: 64
        }
        {
          name: RndCnstLfsrPerm
          desc: Compile-time random permutation for LFSR output
          type: sram_ctrl_pkg::lfsr_perm_t
          randcount: 64
          randtype: perm
          name_top: RndCnstSramCtrlMetaLfsrPerm
          default: 0x8506eff16fa93524c7eb3d19e14c06db174b3ccf7b8de0b7a17a8eb4a93298971a443fe59f57e022c040b988ab115e45
          randwidth: 384
        }
      ]
    }
  ]
}
