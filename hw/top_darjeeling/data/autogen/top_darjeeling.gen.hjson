// Copyright lowRISC contributors (OpenTitan project).
// Licensed under the Apache License, Version 2.0, see LICENSE for details.
// SPDX-License-Identifier: Apache-2.0
//
// ------------------- W A R N I N G: A U T O - G E N E R A T E D   C O D E !! -------------------//
// PLEASE DO NOT HAND-EDIT THIS FILE. IT HAS BEEN AUTO-GENERATED WITH THE FOLLOWING COMMAND:
//
// util/topgen.py -t hw/top_darjeeling/data/top_darjeeling.hjson \
//                -o hw/top_darjeeling/ \
//                --rnd_cnst_seed 1017106219537032642877583828875051302543807092889754935647094601236425074047
{
  name: darjeeling
  type: top
  rnd_cnst_seed: 1017106219537032642877583828875051302543807092889754935647094601236425074047
  datawidth: "32"
  racl_config: racl/racl.hjson
  power:
  {
    domains:
    [
      Aon
      "0"
    ]
    default: "0"
    wait_for_external_reset: true
    halt_ibex_via_rom_ctrl: true
  }
  unmanaged_clocks: {}
  clocks:
  {
    hier_paths:
    {
      top: clkmgr_aon_clocks.
      ext: ""
      lpg: clkmgr_aon_cg_en.
    }
    srcs:
    [
      {
        name: main
        aon: no
        freq: "1000000000"
        ref: false
      }
      {
        name: io
        aon: no
        freq: "1000000000"
        ref: false
      }
      {
        name: aon
        aon: yes
        freq: "62500000"
        ref: true
      }
    ]
    derived_srcs:
    [
      {
        name: io_div2
        aon: no
        freq: "500000000"
        ref: false
        div: "2"
        src: io
      }
      {
        name: io_div4
        aon: no
        freq: "250000000"
        ref: false
        div: "4"
        src: io
      }
    ]
    groups:
    [
      {
        name: ast
        src: ext
        sw_cg: no
        unique: no
        clocks:
        {
          clk_main_i: main
          clk_io_i: io
          clk_aon_i: aon
        }
      }
      {
        name: powerup
        src: top
        sw_cg: no
        unique: no
        clocks:
        {
          clk_io_div4_powerup: io_div4
          clk_aon_powerup: aon
          clk_main_powerup: main
          clk_io_powerup: io
          clk_io_div2_powerup: io_div2
        }
      }
      {
        name: trans
        src: top
        sw_cg: hint
        unique: yes
        clocks:
        {
          clk_main_aes: main
          clk_main_hmac: main
          clk_main_kmac: main
          clk_main_otbn: main
        }
      }
      {
        name: infra
        src: top
        sw_cg: no
        unique: no
        clocks:
        {
          clk_io_div4_infra: io_div4
          clk_main_infra: main
          clk_aon_infra: aon
        }
      }
      {
        name: secure
        src: top
        sw_cg: no
        unique: no
        clocks:
        {
          clk_io_div4_secure: io_div4
          clk_main_secure: main
        }
      }
      {
        name: peri
        src: top
        sw_cg: yes
        unique: no
        clocks:
        {
          clk_io_div4_peri: io_div4
          clk_io_div2_peri: io_div2
          clk_aon_peri: aon
        }
      }
      {
        name: timers
        src: top
        sw_cg: no
        unique: no
        clocks:
        {
          clk_io_div4_timers: io_div4
          clk_aon_timers: aon
        }
      }
    ]
  }
  resets:
  {
    hier_paths:
    {
      top: rstmgr_aon_resets.
      ext: ""
      lpg: rstmgr_aon_rst_en.
    }
    nodes:
    [
      {
        name: por_aon
        gen: false
        type: top
        domains:
        [
          "0"
          Aon
        ]
        shadowed: false
        sw: false
        path: rstmgr_aon_resets.rst_por_aon_n
        clock: aon
      }
      {
        name: lc_src
        gen: false
        type: int
        domains: []
        shadowed: false
        sw: false
        path: ""
        clock: io_div4
      }
      {
        name: sys_src
        gen: false
        type: int
        domains: []
        shadowed: false
        sw: false
        path: ""
        clock: io_div4
      }
      {
        name: por
        gen: true
        type: top
        domains:
        [
          Aon
        ]
        shadowed: false
        sw: false
        path: rstmgr_aon_resets.rst_por_n
        parent: por_aon
        clock: main
      }
      {
        name: por_io
        gen: true
        type: top
        domains:
        [
          Aon
        ]
        shadowed: false
        sw: false
        path: rstmgr_aon_resets.rst_por_io_n
        parent: por_aon
        clock: io
      }
      {
        name: por_io_div2
        gen: true
        type: top
        domains:
        [
          Aon
        ]
        shadowed: false
        sw: false
        path: rstmgr_aon_resets.rst_por_io_div2_n
        parent: por_aon
        clock: io_div2
      }
      {
        name: por_io_div4
        gen: true
        type: top
        domains:
        [
          Aon
        ]
        shadowed: false
        sw: false
        path: rstmgr_aon_resets.rst_por_io_div4_n
        parent: por_aon
        clock: io_div4
      }
      {
        name: lc
        gen: true
        type: top
        domains:
        [
          "0"
          Aon
        ]
        shadowed: true
        sw: false
        path: rstmgr_aon_resets.rst_lc_n
        parent: lc_src
        clock: main
      }
      {
        name: lc_aon
        gen: true
        type: top
        domains:
        [
          Aon
        ]
        shadowed: false
        sw: false
        path: rstmgr_aon_resets.rst_lc_aon_n
        parent: lc_src
        clock: aon
      }
      {
        name: lc_io
        gen: true
        type: top
        domains:
        [
          Aon
        ]
        shadowed: false
        sw: false
        path: rstmgr_aon_resets.rst_lc_io_n
        parent: lc_src
        clock: io
      }
      {
        name: lc_io_div2
        gen: true
        type: top
        domains:
        [
          Aon
        ]
        shadowed: false
        sw: false
        path: rstmgr_aon_resets.rst_lc_io_div2_n
        parent: lc_src
        clock: io_div2
      }
      {
        name: lc_io_div4
        gen: true
        type: top
        domains:
        [
          "0"
          Aon
        ]
        shadowed: true
        sw: false
        path: rstmgr_aon_resets.rst_lc_io_div4_n
        parent: lc_src
        clock: io_div4
      }
      {
        name: sys
        gen: true
        type: top
        domains:
        [
          "0"
        ]
        shadowed: false
        sw: false
        path: rstmgr_aon_resets.rst_sys_n
        parent: sys_src
        clock: main
      }
      {
        name: sys_io_div4
        gen: true
        type: top
        domains:
        [
          Aon
        ]
        shadowed: false
        sw: false
        path: rstmgr_aon_resets.rst_sys_io_div4_n
        parent: sys_src
        clock: io_div4
      }
      {
        name: spi_device
        gen: true
        type: top
        domains:
        [
          "0"
        ]
        shadowed: false
        sw: true
        path: rstmgr_aon_resets.rst_spi_device_n
        parent: lc_src
        clock: io_div4
      }
      {
        name: spi_host0
        gen: true
        type: top
        domains:
        [
          "0"
        ]
        shadowed: false
        sw: true
        path: rstmgr_aon_resets.rst_spi_host0_n
        parent: lc_src
        clock: io_div4
      }
      {
        name: i2c0
        gen: true
        type: top
        domains:
        [
          "0"
        ]
        shadowed: false
        sw: true
        path: rstmgr_aon_resets.rst_i2c0_n
        parent: lc_src
        clock: io_div4
      }
    ]
  }
  reset_requests:
  {
    int:
    [
      {
        name: MainPwr
        desc: main power glitch reset request
        module: pwrmgr_aon
      }
      {
        name: Esc
        desc: escalation reset request
        module: alert_handler
      }
    ]
    debug:
    [
      {
        name: Ndm
        desc: non-debug-module reset request
        module: rv_dm
      }
    ]
    peripheral:
    [
      {
        name: aon_timer_rst_req
        width: "1"
        module: aon_timer_aon
        desc: Watchdog reset request.
      }
      {
        name: rst_req_external
        width: "1"
        module: soc_proxy
        desc: External reset request
      }
    ]
  }
  num_cores: "1"
  addr_spaces:
  [
    {
      name: hart
      desc: The main address space, shared between the CPU and DM
      subspaces:
      [
        {
          name: mmio
          desc:
            '''
            MMIO region excludes any memory that is separate from the module configuration
            space, i.e. ROM, main SRAM, and mbx SRAM are excluded but retention SRAM or
            spi_device are included.
            '''
          nodes:
          [
            uart0
            gpio
            spi_device
            i2c0
            rv_timer
            otp_ctrl
            lc_ctrl.regs
            alert_handler
            spi_host0
            pwrmgr_aon
            rstmgr_aon
            clkmgr_aon
            pinmux_aon
            aon_timer_aon
            ast
            soc_proxy.core
            soc_dbg_ctrl.core
            sram_ctrl_ret_aon
            rv_plic
            aes
            hmac
            otbn
            keymgr_dpe
            csrng
            edn0
            edn1
            sram_ctrl_main.regs
            sram_ctrl_mbox.regs
            rom_ctrl0.regs
            rom_ctrl1.regs
            dma
            mbx0.core
            mbx1.core
            mbx2.core
            mbx3.core
            mbx4.core
            mbx5.core
            mbx6.core
            mbx_jtag.core
            mbx_pcie0.core
            mbx_pcie1.core
            rv_core_ibex
          ]
        }
      ]
    }
    {
      name: soc_mbx
      desc: SoC address space for mailbox access
    }
    {
      name: soc_dbg
      desc: SoC address space for debug module interfaces
    }
  ]
  module:
  [
    {
      name: uart0
      type: uart
      clock_srcs:
      {
        clk_i: io_div4
      }
      clock_group: peri
      reset_connections:
      {
        rst_ni:
        {
          name: lc_io_div4
          domain: "0"
        }
      }
      clock_connections:
      {
        clk_i: clkmgr_aon_clocks.clk_io_div4_peri
      }
      param_decl: {}
      param_list: []
      inter_signal_list:
      [
        {
          name: lsio_trigger
          desc:
            '''
            Self-clearing status trigger for the DMA.
            Set when RX or TX FIFOs are past their configured watermarks matching watermark interrupt behaviour.
            '''
          struct: logic
          type: uni
          act: req
          width: 1
          inst_name: uart0
          default: ""
          package: ""
          end_idx: -1
          top_type: broadcast
          top_signame: uart0_lsio_trigger
          index: -1
        }
        {
          name: racl_policies
          desc:
            '''
            Incoming RACL policy vector from a racl_ctrl instance.
            The policy selection vector (parameter) selects the policy for each register.
            '''
          struct: racl_policy_vec
          package: top_racl_pkg
          type: uni
          act: rcv
          width: 1
          inst_name: uart0
          index: -1
        }
        {
          name: racl_error
          desc: RACL error log information of this module.
          struct: racl_error_log
          package: top_racl_pkg
          type: uni
          act: req
          width: 1
          inst_name: uart0
          index: -1
        }
        {
          name: tl
          struct: tl
          package: tlul_pkg
          type: req_rsp
          act: rsp
          width: 1
          inst_name: uart0
          default: ""
          end_idx: -1
          top_signame: uart0_tl
          index: -1
        }
      ]
      base_addrs:
      {
        null:
        {
          hart: 0x30010000
        }
      }
      generate_dif: true
      domain:
      [
        "0"
      ]
    }
    {
      name: gpio
      type: gpio
      template_type: gpio
      clock_srcs:
      {
        clk_i: io_div4
      }
      clock_group: peri
      reset_connections:
      {
        rst_ni:
        {
          name: lc_io_div4
          domain: "0"
        }
      }
      param_decl:
      {
        GpioAsHwStrapsEn: "1"
        GpioAsyncOn: "1"
      }
      ipgen_param:
      {
        num_inp_period_counters: 8
      }
      attr: ipgen
      clock_connections:
      {
        clk_i: clkmgr_aon_clocks.clk_io_div4_peri
      }
      memory: {}
      param_list:
      [
        {
          name: GpioAsyncOn
          desc: Instantiates 2-flop synchronizers on all GPIO inputs if set to 1.
          type: bit
          default: "1"
          local: "false"
          expose: "true"
          name_top: GpioGpioAsyncOn
        }
        {
          name: GpioAsHwStrapsEn
          desc: Enable HW straps sampling logic for GPIO inputs at initial cold boot
          type: bit
          default: "1"
          local: "false"
          expose: "true"
          name_top: GpioGpioAsHwStrapsEn
        }
      ]
      inter_signal_list:
      [
        {
          name: strap_en
          desc:
            '''
            The strap enable signal tells gpio to take a snapshot of the input pins.
            The behaviour of this signal after that event will have no effect.
            '''
          struct: logic
          type: uni
          act: rcv
          width: 1
          default: 1'b0
          inst_name: gpio
          package: ""
          top_signame: pwrmgr_aon_strap
          index: -1
        }
        {
          name: sampled_straps
          desc: This vector contains the sampled strap values.
          struct: gpio_straps
          package: gpio_pkg
          type: uni
          act: req
          width: 1
          default: "'0"
          inst_name: gpio
          index: -1
        }
        {
          name: racl_policies
          desc:
            '''
            Incoming RACL policy vector from a racl_ctrl instance.
            The policy selection vector (parameter) selects the policy for each register.
            '''
          struct: racl_policy_vec
          package: top_racl_pkg
          type: uni
          act: rcv
          width: 1
          inst_name: gpio
          index: -1
        }
        {
          name: racl_error
          desc: RACL error log information of this module.
          struct: racl_error_log
          package: top_racl_pkg
          type: uni
          act: req
          width: 1
          inst_name: gpio
          index: -1
        }
        {
          name: tl
          struct: tl
          package: tlul_pkg
          type: req_rsp
          act: rsp
          width: 1
          inst_name: gpio
          default: ""
          end_idx: -1
          top_signame: gpio_tl
          index: -1
        }
      ]
      base_addrs:
      {
        null:
        {
          hart: 0x30000000
        }
      }
      generate_dif: true
      domain:
      [
        "0"
      ]
    }
    {
      name: spi_device
      type: spi_device
      clock_srcs:
      {
        clk_i: io_div4
        scan_clk_i: io_div2
      }
      clock_group: peri
      reset_connections:
      {
        rst_ni:
        {
          name: spi_device
          domain: "0"
        }
      }
      param_decl:
      {
        SramType: spi_device_pkg::SramType1r1w
      }
      clock_connections:
      {
        clk_i: clkmgr_aon_clocks.clk_io_div4_peri
        scan_clk_i: clkmgr_aon_clocks.clk_io_div2_peri
      }
      memory: {}
      param_list:
      [
        {
          name: SramType
          desc: Sram Entries. Word size is 32bit width.
          type: spi_device_pkg::sram_type_e
          default: spi_device_pkg::SramType1r1w
          local: "false"
          expose: "true"
          name_top: SpiDeviceSramType
        }
      ]
      inter_signal_list:
      [
        {
          name: ram_cfg_sys2spi
          struct: ram_2p_cfg
          package: prim_ram_2p_pkg
          type: uni
          act: rcv
          width: 1
          inst_name: spi_device
          default: ""
          external: true
          top_signame: spi_device_ram_2p_cfg_sys2spi
          conn_type: false
          index: -1
        }
        {
          name: ram_cfg_rsp_sys2spi
          struct: ram_2p_cfg_rsp
          package: prim_ram_2p_pkg
          type: uni
          act: req
          width: 1
          inst_name: spi_device
          default: ""
          external: true
          top_signame: spi_device_ram_2p_cfg_rsp_sys2spi
          conn_type: false
          index: -1
        }
        {
          name: ram_cfg_spi2sys
          struct: ram_2p_cfg
          package: prim_ram_2p_pkg
          type: uni
          act: rcv
          width: 1
          inst_name: spi_device
          default: ""
          external: true
          top_signame: spi_device_ram_2p_cfg_spi2sys
          conn_type: false
          index: -1
        }
        {
          name: ram_cfg_rsp_spi2sys
          struct: ram_2p_cfg_rsp
          package: prim_ram_2p_pkg
          type: uni
          act: req
          width: 1
          inst_name: spi_device
          default: ""
          external: true
          top_signame: spi_device_ram_2p_cfg_rsp_spi2sys
          conn_type: false
          index: -1
        }
        {
          name: passthrough
          struct: passthrough
          package: spi_device_pkg
          type: req_rsp
          act: req
          width: 1
          inst_name: spi_device
          default: ""
          end_idx: -1
          top_signame: spi_device_passthrough
          index: -1
        }
        {
          name: mbist_en
          struct: logic
          type: uni
          act: rcv
          width: 1
          inst_name: spi_device
          index: -1
        }
        {
          name: sck_monitor
          struct: logic
          type: uni
          act: req
          width: 1
          inst_name: spi_device
          default: ""
          package: ""
          external: true
          top_signame: sck_monitor
          conn_type: false
          index: -1
        }
        {
          name: racl_policies
          desc:
            '''
            Incoming RACL policy vector from a racl_ctrl instance.
            The policy selection vector (parameter) selects the policy for each register.
            '''
          struct: racl_policy_vec
          package: top_racl_pkg
          type: uni
          act: rcv
          width: 1
          inst_name: spi_device
          index: -1
        }
        {
          name: racl_error
          desc: RACL error log information of this module.
          struct: racl_error_log
          package: top_racl_pkg
          type: uni
          act: req
          width: 1
          inst_name: spi_device
          index: -1
        }
        {
          name: tl
          struct: tl
          package: tlul_pkg
          type: req_rsp
          act: rsp
          width: 1
          inst_name: spi_device
          default: ""
          end_idx: -1
          top_signame: spi_device_tl
          index: -1
        }
      ]
      base_addrs:
      {
        null:
        {
          hart: 0x30310000
        }
      }
      generate_dif: true
      domain:
      [
        "0"
      ]
    }
    {
      name: i2c0
      type: i2c
      clock_srcs:
      {
        clk_i: io_div4
      }
      clock_group: peri
      reset_connections:
      {
        rst_ni:
        {
          name: i2c0
          domain: "0"
        }
      }
      clock_connections:
      {
        clk_i: clkmgr_aon_clocks.clk_io_div4_peri
      }
      param_decl: {}
      memory: {}
      param_list:
      [
        {
          name: InputDelayCycles
          desc:
            '''
            Maximum number of cycles of propagation delay between a change on the cio_scl_en_o or cio_sda_en_o pins and sensing the new values on the corresponding input pins, not including the rise/fall times.
            For the purposes of this calculation, an input delay of 0 cycles means an output pin changing at the beginning of clock edge N will be sampled and observed on the input pins at clock edge N+1.
            '''
          type: int
          default: "0"
          local: "false"
          expose: "true"
          name_top: I2c0InputDelayCycles
        }
      ]
      inter_signal_list:
      [
        {
          name: ram_cfg
          struct: ram_1p_cfg
          package: prim_ram_1p_pkg
          type: uni
          act: rcv
          width: 1
          inst_name: i2c0
          default: ""
          external: true
          top_signame: i2c_ram_1p_cfg
          conn_type: false
          index: -1
        }
        {
          name: ram_cfg_rsp
          struct: ram_1p_cfg_rsp
          package: prim_ram_1p_pkg
          type: uni
          act: req
          width: 1
          inst_name: i2c0
          default: ""
          external: true
          top_signame: i2c_ram_1p_cfg_rsp
          conn_type: false
          index: -1
        }
        {
          name: lsio_trigger
          desc:
            '''
            Self-clearing status trigger for the DMA.
            Set when RX TX FIFO is past their configured watermark matching watermark interrupt behaviour.
            '''
          struct: logic
          type: uni
          act: req
          width: 1
          inst_name: i2c0
          default: ""
          package: ""
          end_idx: -1
          top_type: broadcast
          top_signame: i2c0_lsio_trigger
          index: -1
        }
        {
          name: racl_policies
          desc:
            '''
            Incoming RACL policy vector from a racl_ctrl instance.
            The policy selection vector (parameter) selects the policy for each register.
            '''
          struct: racl_policy_vec
          package: top_racl_pkg
          type: uni
          act: rcv
          width: 1
          inst_name: i2c0
          index: -1
        }
        {
          name: racl_error
          desc: RACL error log information of this module.
          struct: racl_error_log
          package: top_racl_pkg
          type: uni
          act: req
          width: 1
          inst_name: i2c0
          index: -1
        }
        {
          name: tl
          struct: tl
          package: tlul_pkg
          type: req_rsp
          act: rsp
          width: 1
          inst_name: i2c0
          default: ""
          end_idx: -1
          top_signame: i2c0_tl
          index: -1
        }
      ]
      base_addrs:
      {
        null:
        {
          hart: 0x30080000
        }
      }
      generate_dif: true
      domain:
      [
        "0"
      ]
    }
    {
      name: rv_timer
      type: rv_timer
      clock_srcs:
      {
        clk_i: io_div4
      }
      clock_group: timers
      reset_connections:
      {
        rst_ni:
        {
          name: lc_io_div4
          domain: "0"
        }
      }
      clock_connections:
      {
        clk_i: clkmgr_aon_clocks.clk_io_div4_timers
      }
      param_decl: {}
      param_list: []
      inter_signal_list:
      [
        {
          name: racl_policies
          desc:
            '''
            Incoming RACL policy vector from a racl_ctrl instance.
            The policy selection vector (parameter) selects the policy for each register.
            '''
          struct: racl_policy_vec
          package: top_racl_pkg
          type: uni
          act: rcv
          width: 1
          inst_name: rv_timer
          index: -1
        }
        {
          name: racl_error
          desc: RACL error log information of this module.
          struct: racl_error_log
          package: top_racl_pkg
          type: uni
          act: req
          width: 1
          inst_name: rv_timer
          index: -1
        }
        {
          name: tl
          struct: tl
          package: tlul_pkg
          type: req_rsp
          act: rsp
          width: 1
          inst_name: rv_timer
          default: ""
          end_idx: -1
          top_signame: rv_timer_tl
          index: -1
        }
      ]
      base_addrs:
      {
        null:
        {
          hart: 0x30100000
        }
      }
      generate_dif: true
      domain:
      [
        "0"
      ]
    }
    {
      name: otp_ctrl
      type: otp_ctrl
      template_type: otp_ctrl
      clock_srcs:
      {
        clk_i: io_div4
        clk_edn_i: main
      }
      clock_group: secure
      reset_connections:
      {
        rst_ni:
        {
          name: lc_io_div4
          domain: "0"
        }
        rst_edn_ni:
        {
          name: lc
          domain: "0"
        }
      }
      base_addrs:
      {
        core:
        {
          hart: 0x30130000
        }
      }
      attr: ipgen
      clock_connections:
      {
        clk_i: clkmgr_aon_clocks.clk_io_div4_secure
        clk_edn_i: clkmgr_aon_clocks.clk_main_secure
      }
      param_decl: {}
      memory: {}
      param_list:
      [
        {
          name: RndCnstLfsrSeed
          desc: Compile-time random bits for initial LFSR seed
          type: otp_ctrl_top_specific_pkg::lfsr_seed_t
          randcount: 40
          randtype: data
          name_top: RndCnstOtpCtrlLfsrSeed
          default: 0x4b9fbde86f
          randwidth: 40
        }
        {
          name: RndCnstLfsrPerm
          desc: Compile-time random permutation for LFSR output
          type: otp_ctrl_top_specific_pkg::lfsr_perm_t
          randcount: 40
          randtype: perm
          name_top: RndCnstOtpCtrlLfsrPerm
          default: 0x6736539341470210f61f55284b59a44a0c81dd91b0062628d79a014c799
          randwidth: 240
        }
        {
          name: RndCnstScrmblKeyInit
          desc: Compile-time random permutation for scrambling key/nonce register reset value
          type: otp_ctrl_top_specific_pkg::scrmbl_key_init_t
          randcount: 256
          randtype: data
          name_top: RndCnstOtpCtrlScrmblKeyInit
          default: 0xe8f2f8be62fe9d2d4204b2f54be875ae480277680cba442baa3acb9c2a3f40a5
          randwidth: 256
        }
      ]
      inter_signal_list:
      [
        {
          name: edn
          desc: Entropy request to the entropy distribution network for LFSR reseeding and ephemeral key derivation.
          struct: edn
          package: edn_pkg
          type: req_rsp
          act: req
          width: 1
          inst_name: otp_ctrl
          default: ""
          top_signame: edn0_edn
          index: 1
        }
        {
          name: pwr_otp
          desc: Initialization request/acknowledge from/to power manager.
          struct: pwr_otp
          package: pwrmgr_pkg
          type: req_rsp
          act: rsp
          width: 1
          default: "'0"
          inst_name: otp_ctrl
          top_signame: pwrmgr_aon_pwr_otp
          index: -1
        }
        {
          name: lc_otp_program
          desc: Life cycle state transition interface.
          struct: lc_otp_program
          package: otp_ctrl_pkg
          type: req_rsp
          act: rsp
          width: 1
          default: "'0"
          inst_name: otp_ctrl
          top_signame: lc_ctrl_lc_otp_program
          index: -1
        }
        {
          name: otp_lc_data
          desc:
            '''
            Life cycle state output holding the current life cycle state,
            the value of the transition counter and the tokens needed for life cycle transitions.
            '''
          struct: otp_lc_data
          package: otp_ctrl_pkg
          type: uni
          act: req
          width: 1
          default: "'0"
          inst_name: otp_ctrl
          end_idx: -1
          top_type: broadcast
          top_signame: otp_ctrl_otp_lc_data
          index: -1
        }
        {
          name: lc_escalate_en
          desc:
            '''
            Life cycle escalation enable coming from life cycle controller.
            This signal moves all FSMs within OTP into the error state.
            '''
          struct: lc_tx
          package: lc_ctrl_pkg
          type: uni
          act: rcv
          width: 1
          default: lc_ctrl_pkg::Off
          inst_name: otp_ctrl
          top_signame: lc_ctrl_lc_escalate_en
          index: -1
        }
        {
          name: lc_creator_seed_sw_rw_en
          desc:
            '''
            Provision enable qualifier coming from life cycle controller.
            This signal enables SW read / write access to the RMA_TOKEN and CREATOR_ROOT_KEY_SHARE0 and CREATOR_ROOT_KEY_SHARE1.
            '''
          struct: lc_tx
          package: lc_ctrl_pkg
          type: uni
          act: rcv
          width: 1
          default: lc_ctrl_pkg::Off
          inst_name: otp_ctrl
          top_signame: lc_ctrl_lc_creator_seed_sw_rw_en
          index: -1
        }
        {
          name: lc_owner_seed_sw_rw_en
          desc:
            '''
            Provision enable qualifier coming from life cycle controller.
            This signal enables SW read / write access to the OWNER_SEED.
            '''
          struct: lc_tx
          package: lc_ctrl_pkg
          type: uni
          act: rcv
          width: 1
          default: lc_ctrl_pkg::Off
          inst_name: otp_ctrl
          top_signame: lc_ctrl_lc_owner_seed_sw_rw_en
          index: -1
        }
        {
          name: lc_seed_hw_rd_en
          desc:
            '''
            Seed read enable coming from life cycle controller.
            This signal enables HW read access to the CREATOR_ROOT_KEY_SHARE0 and CREATOR_ROOT_KEY_SHARE1.
            '''
          struct: lc_tx
          package: lc_ctrl_pkg
          type: uni
          act: rcv
          width: 1
          default: lc_ctrl_pkg::Off
          inst_name: otp_ctrl
          top_signame: lc_ctrl_lc_seed_hw_rd_en
          index: -1
        }
        {
          name: lc_check_byp_en
          desc:
            '''
            Life cycle partition check bypass signal.
            This signal causes the life cycle partition to bypass consistency checks during life cycle state transitions in order to prevent spurious consistency check failures.
            '''
          struct: lc_tx
          package: lc_ctrl_pkg
          type: uni
          act: rcv
          width: 1
          default: lc_ctrl_pkg::Off
          inst_name: otp_ctrl
          top_signame: lc_ctrl_lc_check_byp_en
          index: -1
        }
        {
          name: otp_keymgr_key
          desc: Key output to the key manager holding CREATOR_ROOT_KEY_SHARE0 and CREATOR_ROOT_KEY_SHARE1.
          struct: otp_keymgr_key
          package: otp_ctrl_pkg
          type: uni
          act: req
          width: 1
          default: "'0"
          inst_name: otp_ctrl
          end_idx: -1
          top_type: broadcast
          top_signame: otp_ctrl_otp_keymgr_key
          index: -1
        }
        {
          name: sram_otp_key
          desc: Array with key derivation interfaces for SRAM scrambling devices.
          struct: sram_otp_key
          package: otp_ctrl_pkg
          type: req_rsp
          act: rsp
          width: 4
          default: "'0"
          inst_name: otp_ctrl
          end_idx: -1
          top_type: one-to-N
          top_signame: otp_ctrl_sram_otp_key
          index: -1
        }
        {
          name: otbn_otp_key
          desc: Key derivation interface for OTBN scrambling devices.
          struct: otbn_otp_key
          package: otp_ctrl_pkg
          type: req_rsp
          act: rsp
          width: 1
          default: "'0"
          inst_name: otp_ctrl
          end_idx: -1
          top_signame: otp_ctrl_otbn_otp_key
          index: -1
        }
        {
          name: otp_broadcast
          desc: Output of the HW partitions with breakout data types.
          struct: otp_broadcast
          package: otp_ctrl_part_pkg
          type: uni
          act: req
          width: 1
          default: "'0"
          inst_name: otp_ctrl
          top_signame: otp_ctrl_otp_broadcast
          index: -1
        }
        {
          name: otp_macro
          desc: Data interface for the OTP macro.
          struct: otp_ctrl_macro
          package: otp_ctrl_macro_pkg
          type: req_rsp
          act: req
          width: 1
          default: "'0"
          inst_name: otp_ctrl
          end_idx: -1
          top_signame: otp_ctrl_otp_macro
          index: -1
        }
        {
          name: core_tl
          struct: tl
          package: tlul_pkg
          type: req_rsp
          act: rsp
          width: 1
          inst_name: otp_ctrl
          default: ""
          end_idx: -1
          top_signame: otp_ctrl_core_tl
          index: -1
        }
      ]
      generate_dif: true
      domain:
      [
        "0"
      ]
    }
    {
      name: otp_macro
      type: otp_macro
      clock_srcs:
      {
        clk_i: io_div4
      }
      clock_group: secure
      reset_connections:
      {
        rst_ni:
        {
          name: lc_io_div4
          domain: "0"
        }
      }
      param_decl:
      {
        Width: otp_ctrl_macro_pkg::OtpWidth
        Depth: otp_ctrl_macro_pkg::OtpDepth
        SizeWidth: otp_ctrl_macro_pkg::OtpSizeWidth
        VendorTestOffset: otp_ctrl_reg_pkg::VendorTestOffset
        VendorTestSize: otp_ctrl_reg_pkg::VendorTestSize
      }
      clock_connections:
      {
        clk_i: clkmgr_aon_clocks.clk_io_div4_secure
      }
      memory: {}
      param_list:
      [
        {
          name: Width
          desc: Size of storage words in bits
          type: int
          default: otp_ctrl_macro_pkg::OtpWidth
          local: "false"
          expose: "false"
          name_top: OtpMacroWidth
        }
        {
          name: Depth
          desc: Number of words
          type: int
          default: otp_ctrl_macro_pkg::OtpDepth
          local: "false"
          expose: "false"
          name_top: OtpMacroDepth
        }
        {
          name: SizeWidth
          desc: Number of words transferred per access
          type: int
          default: otp_ctrl_macro_pkg::OtpSizeWidth
          local: "false"
          expose: "false"
          name_top: OtpMacroSizeWidth
        }
        {
          name: MemInitFile
          desc: ""
          type: ""
          default: '''""'''
          local: "false"
          expose: "true"
          name_top: OtpMacroMemInitFile
        }
        {
          name: VendorTestOffset
          desc: ""
          type: int
          default: otp_ctrl_reg_pkg::VendorTestOffset
          local: "false"
          expose: "false"
          name_top: OtpMacroVendorTestOffset
        }
        {
          name: VendorTestSize
          desc: ""
          type: int
          default: otp_ctrl_reg_pkg::VendorTestSize
          local: "false"
          expose: "false"
          name_top: OtpMacroVendorTestSize
        }
      ]
      inter_signal_list:
      [
        {
          name: obs_ctrl
          desc: AST observability control signals.
          struct: ast_obs_ctrl
          package: ast_pkg
          type: uni
          act: rcv
          width: 1
          inst_name: otp_macro
          default: ""
          top_signame: ast_obs_ctrl
          index: -1
        }
        {
          name: otp_obs
          desc: AST observability bus.
          struct: logic
          type: uni
          act: req
          width: 8
          inst_name: otp_macro
          default: ""
          package: ""
          external: true
          top_signame: otp_obs
          conn_type: false
          index: -1
        }
        {
          name: pwr_seq
          desc: Power sequencing signals to AST (VDD domain).
          struct: pwr_seq
          package: otp_macro_pkg
          type: uni
          act: req
          width: 1
          default: "'0"
          inst_name: otp_macro
          external: true
          top_signame: otp_macro_pwr_seq
          conn_type: false
          index: -1
        }
        {
          name: pwr_seq_h
          desc: Power sequencing signals coming from AST (VCC domain).
          struct: pwr_seq
          package: otp_macro_pkg
          type: uni
          act: rcv
          width: 1
          default: "'0"
          inst_name: otp_macro
          external: true
          top_signame: otp_macro_pwr_seq_h
          conn_type: false
          index: -1
        }
        {
          name: ext_voltage_h
          struct: ""
          type: io
          act: none
          width: 1
          default: "'0"
          inst_name: otp_macro
          package: ""
          external: true
          top_signame: otp_ext_voltage_h
          conn_type: false
          index: -1
        }
        {
          name: lc_dft_en
          desc:
            '''
            Test enable qualifier coming from life cycle controller.
            This signals enables the TL-UL access port.
            '''
          struct: lc_tx
          package: lc_ctrl_pkg
          type: uni
          act: rcv
          width: 1
          default: lc_ctrl_pkg::Off
          inst_name: otp_macro
          top_signame: lc_ctrl_lc_dft_en
          index: -1
        }
        {
          name: test
          desc: Vendor test control signals from/to the life cycle TAP.
          struct: otp_test
          package: otp_macro_pkg
          type: req_rsp
          act: rsp
          width: 1
          default: "'0"
          inst_name: otp_macro
          top_signame: lc_ctrl_lc_otp_vendor_test
          index: -1
        }
        {
          name: otp
          desc: Data interface for the OTP macro.
          struct: otp_ctrl_macro
          package: otp_ctrl_macro_pkg
          type: req_rsp
          act: rsp
          width: 1
          default: "'0"
          inst_name: otp_macro
          top_signame: otp_ctrl_otp_macro
          index: -1
        }
        {
          name: cfg
          struct: otp_cfg
          package: otp_macro_pkg
          type: uni
          act: rcv
          width: 1
          default: "'0"
          inst_name: otp_macro
          external: true
          top_signame: otp_cfg
          conn_type: false
          index: -1
        }
        {
          name: cfg_rsp
          struct: otp_cfg_rsp
          package: otp_macro_pkg
          type: uni
          act: req
          width: 1
          default: "'0"
          inst_name: otp_macro
          external: true
          top_signame: otp_cfg_rsp
          conn_type: false
          index: -1
        }
        {
          name: tl
          struct: tl
          package: tlul_pkg
          type: req_rsp
          act: rsp
          width: 1
          inst_name: otp_macro
          default: ""
          end_idx: -1
          top_signame: otp_macro_tl
          index: -1
        }
      ]
      base_addrs:
      {
        null:
        {
          hart: 0x30140000
        }
      }
      generate_dif: true
      domain:
      [
        "0"
      ]
    }
    {
      name: lc_ctrl
      type: lc_ctrl
      clock_srcs:
      {
        clk_i: io_div4
        clk_kmac_i: main
      }
      clock_group: secure
      reset_connections:
      {
        rst_ni:
        {
          name: lc_io_div4
          domain: "0"
        }
        rst_kmac_ni:
        {
          name: lc
          domain: "0"
        }
      }
      base_addrs:
      {
        regs:
        {
          hart: 0x30150000
        }
        dmi:
        {
          soc_dbg: 0x3000
        }
      }
      param_decl:
      {
        SecVolatileRawUnlockEn: top_pkg::SecVolatileRawUnlockEn
        SiliconCreatorId: 16'h 4002
        ProductId: 16'h 4000
        RevisionId: 8'h 01
        UseDmiInterface: "1"
        NumRmaAckSigs: "1"
        EscNumSeverities: AlertHandlerEscNumSeverities
        EscPingCountWidth: AlertHandlerEscPingCountWidth
      }
      clock_connections:
      {
        clk_i: clkmgr_aon_clocks.clk_io_div4_secure
        clk_kmac_i: clkmgr_aon_clocks.clk_main_secure
      }
      memory: {}
      param_list:
      [
        {
          name: SecVolatileRawUnlockEn
          desc:
            '''
            Disable (0) or enable (1) volatile RAW UNLOCK capability.
            If enabled, it is possible to perform a volatile RAW -> TEST_UNLOCKED0 transition
            without programming the OTP. This is a useful fallback mode in case the OTP is
            not working correctly.

            IMPORTANT NOTE: This should only be used in test chips. The parameter must be set
            to 0 in production tapeouts since this weakens the security posture of the RAW
            UNLOCK mechanism.
            '''
          type: bit
          default: top_pkg::SecVolatileRawUnlockEn
          local: "false"
          expose: "true"
          name_top: SecLcCtrlVolatileRawUnlockEn
        }
        {
          name: UseDmiInterface
          desc: When 1, a TLUL-based DMI interface is used. When 0, a JTAG TAP is used.
          type: bit
          default: "1"
          local: "false"
          expose: "true"
          name_top: LcCtrlUseDmiInterface
        }
        {
          name: RndCnstLcKeymgrDivInvalid
          desc: Diversification value used for all invalid life cycle states.
          type: lc_ctrl_pkg::lc_keymgr_div_t
          randcount: 128
          randtype: data
          name_top: RndCnstLcCtrlLcKeymgrDivInvalid
          default: 0xe816a506c2ab1f4a2f01cbe908a34c2a
          randwidth: 128
        }
        {
          name: RndCnstLcKeymgrDivTestUnlocked
          desc: Diversification value used for the TEST_UNLOCKED* life cycle states.
          type: lc_ctrl_pkg::lc_keymgr_div_t
          randcount: 128
          randtype: data
          name_top: RndCnstLcCtrlLcKeymgrDivTestUnlocked
          default: 0x20fecda9a5fceba680bbb8e9c0f3699c
          randwidth: 128
        }
        {
          name: RndCnstLcKeymgrDivDev
          desc: Diversification value used for the DEV life cycle state.
          type: lc_ctrl_pkg::lc_keymgr_div_t
          randcount: 128
          randtype: data
          name_top: RndCnstLcCtrlLcKeymgrDivDev
          default: 0xd9803542888fa690c16dd41b3d1fa05f
          randwidth: 128
        }
        {
          name: RndCnstLcKeymgrDivProduction
          desc: Diversification value used for the PROD/PROD_END life cycle states.
          type: lc_ctrl_pkg::lc_keymgr_div_t
          randcount: 128
          randtype: data
          name_top: RndCnstLcCtrlLcKeymgrDivProduction
          default: 0x7ecc83245ccc8577daafb97c26a70119
          randwidth: 128
        }
        {
          name: RndCnstLcKeymgrDivRma
          desc: Diversification value used for the RMA life cycle state.
          type: lc_ctrl_pkg::lc_keymgr_div_t
          randcount: 128
          randtype: data
          name_top: RndCnstLcCtrlLcKeymgrDivRma
          default: 0x88481250c2c82deb519d69c7051aab9f
          randwidth: 128
        }
        {
          name: RndCnstInvalidTokens
          desc: Compile-time random bits used for invalid tokens in the token mux
          type: lc_ctrl_pkg::lc_token_mux_t
          randcount: 1024
          randtype: data
          name_top: RndCnstLcCtrlInvalidTokens
          default: 0xc45a1658fa9063ce216c0b412615d73f476529a96a1a8aca4b0bdcbe6b240c31095162e41bf99b2bc41e9edbb4685f7eb27eb3b35f352752e34f64ce978305bfc3481a2162ea2792b7508f1eab067af954dda5491439a9dde6320801fdcf25a4fba528399117069e77c887f53dda6fb4ef8758b99027b6aa7468bc0bd8d70368
          randwidth: 1024
        }
        {
          name: SiliconCreatorId
          desc: Chip generation number.
          type: logic [15:0]
          default: 16'h 4002
          local: "false"
          expose: "true"
          name_top: LcCtrlSiliconCreatorId
        }
        {
          name: ProductId
          desc: Chip revision number.
          type: logic [15:0]
          default: 16'h 4000
          local: "false"
          expose: "true"
          name_top: LcCtrlProductId
        }
        {
          name: RevisionId
          desc: Chip revision number.
          type: logic [7:0]
          default: 8'h 01
          local: "false"
          expose: "true"
          name_top: LcCtrlRevisionId
        }
        {
          name: IdcodeValue
          desc: JTAG ID code.
          type: logic [31:0]
          default: 32'h00000001
          local: "false"
          expose: "true"
          name_top: LcCtrlIdcodeValue
        }
        {
          name: NumRmaAckSigs
          desc: Number of Flash RMA wiping response signals
          type: int
          default: "1"
          local: "true"
          expose: "true"
          name_top: LcCtrlNumRmaAckSigs
        }
        {
          name: EscNumSeverities
          desc: Number of escalation severities
          type: int
          default: AlertHandlerEscNumSeverities
          local: "false"
          expose: "false"
          name_top: LcCtrlEscNumSeverities
        }
        {
          name: EscPingCountWidth
          desc: Width of ping count for the escalation receiver
          type: int
          default: AlertHandlerEscPingCountWidth
          local: "false"
          expose: "false"
          name_top: LcCtrlEscPingCountWidth
        }
      ]
      inter_signal_list:
      [
        {
          name: jtag
          struct: jtag
          package: jtag_pkg
          type: req_rsp
          act: rsp
          width: 1
          inst_name: lc_ctrl
          index: -1
        }
        {
          name: esc_scrap_state0_tx
          struct: esc_tx
          package: prim_esc_pkg
          type: uni
          act: rcv
          width: 1
          inst_name: lc_ctrl
          default: ""
          top_signame: alert_handler_esc_tx
          index: 1
        }
        {
          name: esc_scrap_state0_rx
          struct: esc_rx
          package: prim_esc_pkg
          type: uni
          act: req
          width: 1
          inst_name: lc_ctrl
          default: ""
          top_signame: alert_handler_esc_rx
          index: 1
        }
        {
          name: esc_scrap_state1_tx
          struct: esc_tx
          package: prim_esc_pkg
          type: uni
          act: rcv
          width: 1
          inst_name: lc_ctrl
          default: ""
          top_signame: alert_handler_esc_tx
          index: 2
        }
        {
          name: esc_scrap_state1_rx
          struct: esc_rx
          package: prim_esc_pkg
          type: uni
          act: req
          width: 1
          inst_name: lc_ctrl
          default: ""
          top_signame: alert_handler_esc_rx
          index: 2
        }
        {
          name: pwr_lc
          struct: pwr_lc
          package: lc_ctrl_pkg
          type: req_rsp
          act: rsp
          width: 1
          inst_name: lc_ctrl
          default: ""
          top_signame: pwrmgr_aon_pwr_lc
          index: -1
        }
        {
          name: lc_otp_vendor_test
          struct: otp_test
          package: otp_macro_pkg
          type: req_rsp
          act: req
          width: 1
          default: "'0"
          inst_name: lc_ctrl
          end_idx: -1
          top_signame: lc_ctrl_lc_otp_vendor_test
          index: -1
        }
        {
          name: otp_lc_data
          struct: otp_lc_data
          package: otp_ctrl_pkg
          type: uni
          act: rcv
          width: 1
          default: otp_ctrl_pkg::OTP_LC_DATA_DEFAULT
          inst_name: lc_ctrl
          top_signame: otp_ctrl_otp_lc_data
          index: -1
        }
        {
          name: lc_otp_program
          struct: lc_otp_program
          package: otp_ctrl_pkg
          type: req_rsp
          act: req
          width: 1
          default: "'0"
          inst_name: lc_ctrl
          end_idx: -1
          top_signame: lc_ctrl_lc_otp_program
          index: -1
        }
        {
          name: kmac_data
          struct: app
          package: kmac_pkg
          type: req_rsp
          act: req
          width: 1
          default: "'0"
          inst_name: lc_ctrl
          top_signame: kmac_app
          index: 1
        }
        {
          name: lc_raw_test_rma
          struct: lc_tx
          package: lc_ctrl_pkg
          type: uni
          act: req
          width: 1
          default: lc_ctrl_pkg::Off
          inst_name: lc_ctrl
          end_idx: -1
          top_type: broadcast
          top_signame: lc_ctrl_lc_raw_test_rma
          index: -1
        }
        {
          name: lc_dft_en
          struct: lc_tx
          package: lc_ctrl_pkg
          type: uni
          act: req
          width: 1
          default: lc_ctrl_pkg::Off
          inst_name: lc_ctrl
          end_idx: -1
          top_type: broadcast
          top_signame: lc_ctrl_lc_dft_en
          index: -1
        }
        {
          name: lc_nvm_debug_en
          struct: lc_tx
          package: lc_ctrl_pkg
          type: uni
          act: req
          width: 1
          default: lc_ctrl_pkg::Off
          inst_name: lc_ctrl
          index: -1
        }
        {
          name: lc_hw_debug_en
          struct: lc_tx
          package: lc_ctrl_pkg
          type: uni
          act: req
          width: 1
          default: lc_ctrl_pkg::Off
          inst_name: lc_ctrl
          end_idx: -1
          top_type: broadcast
          top_signame: lc_ctrl_lc_hw_debug_en
          index: -1
        }
        {
          name: lc_cpu_en
          struct: lc_tx
          package: lc_ctrl_pkg
          type: uni
          act: req
          width: 1
          default: lc_ctrl_pkg::Off
          inst_name: lc_ctrl
          end_idx: -1
          top_type: broadcast
          top_signame: lc_ctrl_lc_cpu_en
          index: -1
        }
        {
          name: lc_keymgr_en
          struct: lc_tx
          package: lc_ctrl_pkg
          type: uni
          act: req
          width: 1
          default: lc_ctrl_pkg::Off
          inst_name: lc_ctrl
          end_idx: -1
          top_type: broadcast
          top_signame: lc_ctrl_lc_keymgr_en
          index: -1
        }
        {
          name: lc_escalate_en
          struct: lc_tx
          package: lc_ctrl_pkg
          type: uni
          act: req
          width: 1
          default: lc_ctrl_pkg::Off
          inst_name: lc_ctrl
          end_idx: -1
          top_type: broadcast
          top_signame: lc_ctrl_lc_escalate_en
          index: -1
        }
        {
          name: lc_clk_byp_req
          struct: lc_tx
          package: lc_ctrl_pkg
          type: uni
          act: req
          width: 1
          default: lc_ctrl_pkg::Off
          inst_name: lc_ctrl
          end_idx: -1
          top_type: broadcast
          top_signame: lc_ctrl_lc_clk_byp_req
          index: -1
        }
        {
          name: lc_clk_byp_ack
          struct: lc_tx
          package: lc_ctrl_pkg
          type: uni
          act: rcv
          width: 1
          default: lc_ctrl_pkg::Off
          inst_name: lc_ctrl
          end_idx: -1
          top_type: broadcast
          top_signame: lc_ctrl_lc_clk_byp_ack
          index: -1
        }
        {
          name: lc_flash_rma_req
          struct: lc_tx
          package: lc_ctrl_pkg
          type: uni
          act: req
          width: 1
          default: lc_ctrl_pkg::Off
          inst_name: lc_ctrl
          end_idx: -1
          top_type: broadcast
          top_signame: lc_ctrl_lc_flash_rma_req
          index: -1
        }
        {
          name: lc_flash_rma_ack
          struct: lc_tx
          package: lc_ctrl_pkg
          type: uni
          act: rcv
          width: 2
          default: lc_ctrl_pkg::On
          inst_name: lc_ctrl
          top_signame: otbn_lc_rma_ack
          index: -1
        }
        {
          name: lc_flash_rma_seed
          struct: lc_flash_rma_seed
          package: lc_ctrl_pkg
          type: uni
          act: req
          width: 1
          default: "'0"
          inst_name: lc_ctrl
          index: -1
        }
        {
          name: lc_check_byp_en
          struct: lc_tx
          package: lc_ctrl_pkg
          type: uni
          act: req
          width: 1
          default: lc_ctrl_pkg::Off
          inst_name: lc_ctrl
          end_idx: -1
          top_type: broadcast
          top_signame: lc_ctrl_lc_check_byp_en
          index: -1
        }
        {
          name: lc_creator_seed_sw_rw_en
          struct: lc_tx
          package: lc_ctrl_pkg
          type: uni
          act: req
          width: 1
          default: lc_ctrl_pkg::Off
          inst_name: lc_ctrl
          end_idx: -1
          top_type: broadcast
          top_signame: lc_ctrl_lc_creator_seed_sw_rw_en
          index: -1
        }
        {
          name: lc_owner_seed_sw_rw_en
          struct: lc_tx
          package: lc_ctrl_pkg
          type: uni
          act: req
          width: 1
          default: lc_ctrl_pkg::Off
          inst_name: lc_ctrl
          end_idx: -1
          top_type: broadcast
          top_signame: lc_ctrl_lc_owner_seed_sw_rw_en
          index: -1
        }
        {
          name: lc_iso_part_sw_rd_en
          struct: lc_tx
          package: lc_ctrl_pkg
          type: uni
          act: req
          width: 1
          default: lc_ctrl_pkg::Off
          inst_name: lc_ctrl
          index: -1
        }
        {
          name: lc_iso_part_sw_wr_en
          struct: lc_tx
          package: lc_ctrl_pkg
          type: uni
          act: req
          width: 1
          default: lc_ctrl_pkg::Off
          inst_name: lc_ctrl
          index: -1
        }
        {
          name: lc_seed_hw_rd_en
          struct: lc_tx
          package: lc_ctrl_pkg
          type: uni
          act: req
          width: 1
          default: lc_ctrl_pkg::Off
          inst_name: lc_ctrl
          end_idx: -1
          top_type: broadcast
          top_signame: lc_ctrl_lc_seed_hw_rd_en
          index: -1
        }
        {
          name: lc_keymgr_div
          struct: lc_keymgr_div
          package: lc_ctrl_pkg
          type: uni
          act: req
          width: 1
          default: "'0"
          inst_name: lc_ctrl
          end_idx: -1
          top_type: broadcast
          top_signame: lc_ctrl_lc_keymgr_div
          index: -1
        }
        {
          name: otp_device_id
          struct: otp_device_id
          package: otp_ctrl_pkg
          type: uni
          act: rcv
          width: 1
          default: "'0"
          inst_name: lc_ctrl
          top_signame: lc_ctrl_otp_device_id
          index: -1
        }
        {
          name: otp_manuf_state
          struct: otp_manuf_state
          package: otp_ctrl_pkg
          type: uni
          act: rcv
          width: 1
          default: "'0"
          inst_name: lc_ctrl
          top_signame: lc_ctrl_otp_manuf_state
          index: -1
        }
        {
          name: hw_rev
          struct: lc_hw_rev
          package: lc_ctrl_pkg
          type: uni
          act: req
          width: 1
          default: "'0"
          inst_name: lc_ctrl
          index: -1
        }
        {
          name: strap_en_override
          desc:
            '''
            This signal transitions from 0 -> 1 by the lc_ctrl manager after volatile RAW_UNLOCK in order to re-sample the HW straps.
            The signal stays at 1 until reset.
            Note that this is only used in test chips when SecVolatileRawUnlockEn = 1.
            Otherwise this signal is tied off to 0.
            '''
          struct: logic
          type: uni
          act: req
          width: 1
          default: 1'b0
          inst_name: lc_ctrl
          package: ""
          end_idx: -1
          top_type: broadcast
          top_signame: lc_ctrl_strap_en_override
          index: -1
        }
        {
          name: regs_tl
          struct: tl
          package: tlul_pkg
          type: req_rsp
          act: rsp
          width: 1
          inst_name: lc_ctrl
          default: ""
          end_idx: -1
          top_signame: lc_ctrl_regs_tl
          index: -1
        }
        {
          name: dmi_tl
          struct: tl
          package: tlul_pkg
          type: req_rsp
          act: rsp
          width: 1
          inst_name: lc_ctrl
          default: ""
          end_idx: -1
          top_signame: lc_ctrl_dmi_tl
          index: -1
        }
      ]
      generate_dif: true
      domain:
      [
        "0"
      ]
    }
    {
      name: alert_handler
      type: alert_handler
      template_type: alert_handler
      clock_srcs:
      {
        clk_i: io_div4
        clk_edn_i: main
      }
      clock_group: secure
      reset_connections:
      {
        rst_ni:
        {
          name: lc_io_div4
          domain: "0"
        }
        rst_edn_ni:
        {
          name: lc
          domain: "0"
        }
      }
      param_decl:
      {
        EscNumSeverities: "4"
        EscPingCountWidth: "16"
      }
      attr: ipgen
      clock_connections:
      {
        clk_i: clkmgr_aon_clocks.clk_io_div4_secure
        clk_edn_i: clkmgr_aon_clocks.clk_main_secure
      }
      memory: {}
      param_list:
      [
        {
          name: RndCnstLfsrSeed
          desc: Compile-time random bits for initial LFSR seed
          type: alert_handler_pkg::lfsr_seed_t
          randcount: 32
          randtype: data
          name_top: RndCnstAlertHandlerLfsrSeed
          default: 0xe7cfb11a
          randwidth: 32
        }
        {
          name: RndCnstLfsrPerm
          desc: Compile-time random permutation for LFSR output
          type: alert_handler_pkg::lfsr_perm_t
          randcount: 32
          randtype: perm
          name_top: RndCnstAlertHandlerLfsrPerm
          default: 0x7c7f66878056334b97a7d3869812a696d1e12d93
          randwidth: 160
        }
        {
          name: EscNumSeverities
          desc: Number of escalation severities as regular parameter
          type: int
          default: "4"
          local: "false"
          expose: "true"
          name_top: AlertHandlerEscNumSeverities
        }
        {
          name: EscPingCountWidth
          desc: Width of ping counter as regular parameter
          type: int
          default: "16"
          local: "false"
          expose: "true"
          name_top: AlertHandlerEscPingCountWidth
        }
      ]
      inter_signal_list:
      [
        {
          name: crashdump
          struct: alert_crashdump
          package: alert_handler_pkg
          type: uni
          act: req
          width: 1
          inst_name: alert_handler
          default: ""
          end_idx: -1
          top_type: broadcast
          top_signame: alert_handler_crashdump
          index: -1
        }
        {
          name: edn
          struct: edn
          package: edn_pkg
          type: req_rsp
          act: req
          width: 1
          inst_name: alert_handler
          default: ""
          top_signame: edn0_edn
          index: 4
        }
        {
          name: esc_rx
          struct: esc_rx
          package: prim_esc_pkg
          type: uni
          act: rcv
          width: 4
          inst_name: alert_handler
          default: ""
          end_idx: -1
          top_type: one-to-N
          top_signame: alert_handler_esc_rx
          index: -1
        }
        {
          name: esc_tx
          struct: esc_tx
          package: prim_esc_pkg
          type: uni
          act: req
          width: 4
          inst_name: alert_handler
          default: ""
          end_idx: -1
          top_type: one-to-N
          top_signame: alert_handler_esc_tx
          index: -1
        }
        {
          name: tl
          struct: tl
          package: tlul_pkg
          type: req_rsp
          act: rsp
          width: 1
          inst_name: alert_handler
          default: ""
          end_idx: -1
          top_signame: alert_handler_tl
          index: -1
        }
      ]
      base_addrs:
      {
        null:
        {
          hart: 0x30160000
        }
      }
      generate_dif: true
      domain:
      [
        "0"
      ]
    }
    {
      name: spi_host0
      type: spi_host
      clock_srcs:
      {
        clk_i: io_div4
      }
      clock_group: peri
      reset_connections:
      {
        rst_ni:
        {
          name: spi_host0
          domain: "0"
        }
      }
      clock_connections:
      {
        clk_i: clkmgr_aon_clocks.clk_io_div4_peri
      }
      param_decl: {}
      memory: {}
      param_list:
      [
        {
          name: NumCS
          desc: The number of active-low chip select (cs_n) lines to create.
          type: int
          default: "1"
          local: "true"
          expose: "true"
          name_top: SpiHost0NumCS
        }
      ]
      inter_signal_list:
      [
        {
          name: passthrough
          struct: passthrough
          package: spi_device_pkg
          type: req_rsp
          act: rsp
          width: 1
          inst_name: spi_host0
          default: ""
          top_signame: spi_device_passthrough
          index: -1
        }
        {
          name: lsio_trigger
          desc:
            '''
            Self-clearing status trigger for the DMA.
            Set when RX or TX FIFOs are past their configured watermarks matching watermark interrupt behaviour.
            '''
          struct: logic
          type: uni
          act: req
          width: 1
          inst_name: spi_host0
          default: ""
          package: ""
          end_idx: -1
          top_type: broadcast
          top_signame: spi_host0_lsio_trigger
          index: -1
        }
        {
          name: racl_policies
          desc:
            '''
            Incoming RACL policy vector from a racl_ctrl instance.
            The policy selection vector (parameter) selects the policy for each register.
            '''
          struct: racl_policy_vec
          package: top_racl_pkg
          type: uni
          act: rcv
          width: 1
          inst_name: spi_host0
          index: -1
        }
        {
          name: racl_error
          desc: RACL error log information of this module.
          struct: racl_error_log
          package: top_racl_pkg
          type: uni
          act: req
          width: 1
          inst_name: spi_host0
          index: -1
        }
        {
          name: tl
          struct: tl
          package: tlul_pkg
          type: req_rsp
          act: rsp
          width: 1
          inst_name: spi_host0
          default: ""
          end_idx: -1
          top_signame: spi_host0_tl
          index: -1
        }
      ]
      base_addrs:
      {
        null:
        {
          hart: 0x30300000
        }
      }
      generate_dif: true
      domain:
      [
        "0"
      ]
    }
    {
      name: pwrmgr_aon
      type: pwrmgr
      template_type: pwrmgr
      clock_group: powerup
      clock_srcs:
      {
        clk_i: io_div4
        clk_slow_i: aon
        clk_lc_i: io_div4
        clk_esc_i:
        {
          clock: io_div4
          group: secure
        }
      }
      reset_connections:
      {
        rst_ni:
        {
          name: por_io_div4
          domain: Aon
        }
        rst_main_ni:
        {
          name: por_aon
          domain: "0"
        }
        rst_lc_ni:
        {
          name: lc_io_div4
          domain: Aon
        }
        rst_esc_ni:
        {
          name: lc_io_div4
          domain: Aon
        }
        rst_slow_ni:
        {
          name: por_aon
          domain: Aon
        }
      }
      domain:
      [
        Aon
        "0"
      ]
      param_decl:
      {
        EscNumSeverities: AlertHandlerEscNumSeverities
        EscPingCountWidth: AlertHandlerEscPingCountWidth
      }
      attr: ipgen
      clock_connections:
      {
        clk_i: clkmgr_aon_clocks.clk_io_div4_powerup
        clk_slow_i: clkmgr_aon_clocks.clk_aon_powerup
        clk_lc_i: clkmgr_aon_clocks.clk_io_div4_powerup
        clk_esc_i: clkmgr_aon_clocks.clk_io_div4_secure
      }
      memory: {}
      param_list:
      [
        {
          name: EscNumSeverities
          desc: Number of escalation severities
          type: int
          default: AlertHandlerEscNumSeverities
          local: "false"
          expose: "false"
          name_top: PwrmgrAonEscNumSeverities
        }
        {
          name: EscPingCountWidth
          desc: Width of ping count for the escalation receiver
          type: int
          default: AlertHandlerEscPingCountWidth
          local: "false"
          expose: "false"
          name_top: PwrmgrAonEscPingCountWidth
        }
      ]
      inter_signal_list:
      [
        {
          name: boot_status
          struct: pwr_boot_status
          package: pwrmgr_pkg
          type: uni
          act: req
          width: 1
          inst_name: pwrmgr_aon
          default: ""
          end_idx: -1
          top_type: broadcast
          top_signame: pwrmgr_aon_boot_status
          index: -1
          external: true
          conn_type: true
        }
        {
          name: pwr_ast
          struct: pwr_ast
          package: pwrmgr_pkg
          type: req_rsp
          act: req
          width: 1
          inst_name: pwrmgr_aon
          default: ""
          external: true
          top_signame: pwrmgr_ast
          conn_type: false
          index: -1
        }
        {
          name: pwr_rst
          struct: pwr_rst
          package: pwrmgr_pkg
          type: req_rsp
          act: req
          width: 1
          inst_name: pwrmgr_aon
          default: ""
          end_idx: -1
          top_signame: pwrmgr_aon_pwr_rst
          index: -1
        }
        {
          name: pwr_clk
          struct: pwr_clk
          package: pwrmgr_pkg
          type: req_rsp
          act: req
          width: 1
          inst_name: pwrmgr_aon
          default: ""
          end_idx: -1
          top_signame: pwrmgr_aon_pwr_clk
          index: -1
        }
        {
          name: pwr_otp
          struct: pwr_otp
          package: pwrmgr_pkg
          type: req_rsp
          act: req
          width: 1
          inst_name: pwrmgr_aon
          default: ""
          end_idx: -1
          top_signame: pwrmgr_aon_pwr_otp
          index: -1
        }
        {
          name: pwr_lc
          struct: pwr_lc
          package: lc_ctrl_pkg
          type: req_rsp
          act: req
          width: 1
          inst_name: pwrmgr_aon
          default: ""
          end_idx: -1
          top_signame: pwrmgr_aon_pwr_lc
          index: -1
        }
        {
          name: pwr_flash
          struct: pwr_flash
          package: pwrmgr_pkg
          type: uni
          act: rcv
          width: 1
          inst_name: pwrmgr_aon
          index: -1
        }
        {
          name: esc_rst_tx
          struct: esc_tx
          package: prim_esc_pkg
          type: uni
          act: rcv
          width: 1
          inst_name: pwrmgr_aon
          default: ""
          top_signame: alert_handler_esc_tx
          index: 3
        }
        {
          name: esc_rst_rx
          struct: esc_rx
          package: prim_esc_pkg
          type: uni
          act: req
          width: 1
          inst_name: pwrmgr_aon
          default: ""
          top_signame: alert_handler_esc_rx
          index: 3
        }
        {
          name: pwr_cpu
          struct: cpu_pwrmgr
          package: rv_core_ibex_pkg
          type: uni
          act: rcv
          width: 1
          inst_name: pwrmgr_aon
          default: ""
          top_signame: rv_core_ibex_pwrmgr
          index: -1
        }
        {
          name: wakeups
          struct: logic
          type: uni
          act: rcv
          width: 4
          inst_name: pwrmgr_aon
          default: ""
          package: ""
          end_idx: -1
          top_type: one-to-N
          top_signame: pwrmgr_aon_wakeups
          index: -1
        }
        {
          name: rstreqs
          struct: logic
          type: uni
          act: rcv
          width: 2
          inst_name: pwrmgr_aon
          default: ""
          package: ""
          end_idx: -1
          top_type: one-to-N
          top_signame: pwrmgr_aon_rstreqs
          index: -1
        }
        {
          name: ndmreset_req
          struct: logic
          type: uni
          act: rcv
          width: 1
          inst_name: pwrmgr_aon
          default: ""
          package: ""
          top_signame: rv_dm_ndmreset_req
          index: -1
        }
        {
          name: strap
          struct: logic
          type: uni
          act: req
          width: 1
          inst_name: pwrmgr_aon
          default: ""
          package: ""
          end_idx: -1
          top_type: broadcast
          top_signame: pwrmgr_aon_strap
          index: -1
        }
        {
          name: low_power
          struct: logic
          type: uni
          act: req
          width: 1
          inst_name: pwrmgr_aon
          default: ""
          package: ""
          end_idx: -1
          top_type: broadcast
          top_signame: pwrmgr_aon_low_power
          index: -1
        }
        {
          name: rom_ctrl
          struct: pwrmgr_data
          package: rom_ctrl_pkg
          type: uni
          act: rcv
          width: 3
          default: rom_ctrl_pkg::PWRMGR_DATA_DEFAULT
          inst_name: pwrmgr_aon
          end_idx: -1
          top_type: one-to-N
          top_signame: pwrmgr_aon_rom_ctrl
          index: -1
        }
        {
          name: fetch_en
          struct: lc_tx
          package: lc_ctrl_pkg
          type: uni
          act: req
          width: 1
          inst_name: pwrmgr_aon
          default: ""
          end_idx: -1
          top_type: broadcast
          top_signame: pwrmgr_aon_fetch_en
          index: -1
        }
        {
          name: lc_dft_en
          struct: lc_tx
          package: lc_ctrl_pkg
          type: uni
          act: rcv
          width: 1
          inst_name: pwrmgr_aon
          default: ""
          top_signame: lc_ctrl_lc_dft_en
          index: -1
        }
        {
          name: lc_hw_debug_en
          struct: lc_tx
          package: lc_ctrl_pkg
          type: uni
          act: rcv
          width: 1
          inst_name: pwrmgr_aon
          default: ""
          top_signame: lc_ctrl_lc_hw_debug_en
          index: -1
        }
        {
          name: sw_rst_req
          struct: mubi4
          package: prim_mubi_pkg
          type: uni
          act: rcv
          width: 1
          inst_name: pwrmgr_aon
          default: ""
          top_signame: rstmgr_aon_sw_rst_req
          index: -1
        }
        {
          name: tl
          struct: tl
          package: tlul_pkg
          type: req_rsp
          act: rsp
          width: 1
          inst_name: pwrmgr_aon
          default: ""
          end_idx: -1
          top_signame: pwrmgr_aon_tl
          index: -1
        }
      ]
      base_addrs:
      {
        null:
        {
          hart: 0x30400000
        }
      }
      generate_dif: true
    }
    {
      name: rstmgr_aon
      type: rstmgr
      template_type: rstmgr
      clock_srcs:
      {
        clk_i:
        {
          clock: io_div4
          group: powerup
        }
        clk_por_i: io_div4
        clk_aon_i: aon
        clk_main_i: main
        clk_io_i: io
        clk_io_div2_i: io_div2
        clk_io_div4_i: io_div4
      }
      clock_group: powerup
      reset_connections:
      {
        rst_ni:
        {
          name: lc_io_div4
          domain: Aon
        }
        rst_por_ni:
        {
          name: por_io_div4
          domain: Aon
        }
      }
      domain:
      [
        Aon
        "0"
      ]
      attr: ipgen
      clock_connections:
      {
        clk_i: clkmgr_aon_clocks.clk_io_div4_powerup
        clk_por_i: clkmgr_aon_clocks.clk_io_div4_powerup
        clk_aon_i: clkmgr_aon_clocks.clk_aon_powerup
        clk_main_i: clkmgr_aon_clocks.clk_main_powerup
        clk_io_i: clkmgr_aon_clocks.clk_io_powerup
        clk_io_div2_i: clkmgr_aon_clocks.clk_io_div2_powerup
        clk_io_div4_i: clkmgr_aon_clocks.clk_io_div4_powerup
      }
      param_decl: {}
      memory: {}
      param_list:
      [
        {
          name: SecCheck
          desc:
            '''
            When 1, enable rstmgr reset consistency checks.
            When 0, there are no consistency checks.
            '''
          type: bit
          default: 1'b1
          local: "false"
          expose: "true"
          name_top: SecRstmgrAonCheck
        }
        {
          name: SecMaxSyncDelay
          desc: The maximum synchronization delay for parent / child reset checks.
          type: int
          default: "2"
          local: "false"
          expose: "true"
          name_top: SecRstmgrAonMaxSyncDelay
        }
      ]
      inter_signal_list:
      [
        {
          name: por_n
          desc:
            '''
            Root power on reset signals from ast.
            There is one root reset signal for each core power domain.
            '''
          struct: logic
          type: uni
          act: rcv
          width: 2
          inst_name: rstmgr_aon
          default: ""
          package: ""
          external: true
          top_signame: por_n
          conn_type: false
          index: -1
        }
        {
          name: pwr
          desc:
            '''
            Reset request signals from power manager.
            Power manager can request for specific domains of the lc/sys reset tree to assert.
            '''
          struct: pwr_rst
          type: req_rsp
          act: rsp
          width: 1
          inst_name: rstmgr_aon
          default: ""
          package: pwrmgr_pkg
          top_signame: pwrmgr_aon_pwr_rst
          index: -1
        }
        {
          name: resets
          desc: Leaf resets fed to the system.
          struct: rstmgr_out
          package: rstmgr_pkg
          type: uni
          act: req
          width: 1
          inst_name: rstmgr_aon
          default: ""
          top_signame: rstmgr_aon_resets
          index: -1
        }
        {
          name: rst_en
          desc: Low-power-group outputs used by alert handler.
          struct: rstmgr_rst_en
          package: rstmgr_pkg
          type: uni
          act: req
          width: 1
          inst_name: rstmgr_aon
          default: ""
          top_signame: rstmgr_aon_rst_en
          index: -1
        }
        {
          name: alert_dump
          desc: Alert handler crash dump information.
          struct: alert_crashdump
          package: alert_handler_pkg
          type: uni
          act: rcv
          width: 1
          inst_name: rstmgr_aon
          default: ""
          top_signame: alert_handler_crashdump
          index: -1
        }
        {
          name: cpu_dump
          desc: Main processing element crash dump information.
          struct: cpu_crash_dump
          package: rv_core_ibex_pkg
          type: uni
          act: rcv
          width: 1
          inst_name: rstmgr_aon
          default: ""
          top_signame: rv_core_ibex_crash_dump
          index: -1
        }
        {
          name: sw_rst_req
          desc: Software requested system reset to pwrmgr.
          struct: mubi4
          package: prim_mubi_pkg
          type: uni
          act: req
          width: 1
          inst_name: rstmgr_aon
          default: ""
          end_idx: -1
          top_type: broadcast
          top_signame: rstmgr_aon_sw_rst_req
          index: -1
        }
        {
          name: tl
          struct: tl
          package: tlul_pkg
          type: req_rsp
          act: rsp
          width: 1
          inst_name: rstmgr_aon
          default: ""
          end_idx: -1
          top_signame: rstmgr_aon_tl
          index: -1
        }
      ]
      base_addrs:
      {
        null:
        {
          hart: 0x30410000
        }
      }
      generate_dif: true
    }
    {
      name: clkmgr_aon
      type: clkmgr
      template_type: clkmgr
      clock_srcs:
      {
        clk_i: io_div4
        clk_main_i:
        {
          group: ast
          clock: main
        }
        clk_io_i:
        {
          group: ast
          clock: io
        }
        clk_aon_i:
        {
          group: ast
          clock: aon
        }
      }
      clock_group: powerup
      reset_connections:
      {
        rst_ni:
        {
          name: lc_io_div4
          domain: Aon
        }
        rst_aon_ni:
        {
          name: lc_aon
          domain: Aon
        }
        rst_io_ni:
        {
          name: lc_io
          domain: Aon
        }
        rst_io_div2_ni:
        {
          name: lc_io_div2
          domain: Aon
        }
        rst_io_div4_ni:
        {
          name: lc_io_div4
          domain: Aon
        }
        rst_main_ni:
        {
          name: lc
          domain: Aon
        }
        rst_root_ni:
        {
          name: por_io_div4
          domain: Aon
        }
        rst_root_io_ni:
        {
          name: por_io
          domain: Aon
        }
        rst_root_io_div2_ni:
        {
          name: por_io_div2
          domain: Aon
        }
        rst_root_io_div4_ni:
        {
          name: por_io_div4
          domain: Aon
        }
        rst_root_main_ni:
        {
          name: por
          domain: Aon
        }
      }
      domain:
      [
        Aon
      ]
      attr: ipgen
      clock_connections:
      {
        clk_i: clkmgr_aon_clocks.clk_io_div4_powerup
        clk_main_i: clk_main_i
        clk_io_i: clk_io_i
        clk_aon_i: clk_aon_i
      }
      param_decl: {}
      param_list: []
      inter_signal_list:
      [
        {
          name: clocks
          struct: clkmgr_out
          package: clkmgr_pkg
          type: uni
          act: req
          width: 1
          inst_name: clkmgr_aon
          default: ""
          top_signame: clkmgr_aon_clocks
          index: -1
        }
        {
          name: cg_en
          struct: clkmgr_cg_en
          package: clkmgr_pkg
          type: uni
          act: req
          width: 1
          inst_name: clkmgr_aon
          default: ""
          top_signame: clkmgr_aon_cg_en
          index: -1
        }
        {
          name: lc_hw_debug_en
          struct: lc_tx
          package: lc_ctrl_pkg
          type: uni
          act: rcv
          width: 1
          inst_name: clkmgr_aon
          default: ""
          top_signame: lc_ctrl_lc_hw_debug_en
          index: -1
        }
        {
          name: io_clk_byp_req
          struct: mubi4
          package: prim_mubi_pkg
          type: uni
          act: req
          width: 1
          inst_name: clkmgr_aon
          default: ""
          external: true
          top_signame: io_clk_byp_req
          conn_type: false
          index: -1
        }
        {
          name: io_clk_byp_ack
          struct: mubi4
          package: prim_mubi_pkg
          type: uni
          act: rcv
          width: 1
          inst_name: clkmgr_aon
          default: ""
          external: true
          top_signame: io_clk_byp_ack
          conn_type: false
          index: -1
        }
        {
          name: all_clk_byp_req
          struct: mubi4
          package: prim_mubi_pkg
          type: uni
          act: req
          width: 1
          inst_name: clkmgr_aon
          default: ""
          external: true
          top_signame: all_clk_byp_req
          conn_type: false
          index: -1
        }
        {
          name: all_clk_byp_ack
          struct: mubi4
          package: prim_mubi_pkg
          type: uni
          act: rcv
          width: 1
          inst_name: clkmgr_aon
          default: ""
          external: true
          top_signame: all_clk_byp_ack
          conn_type: false
          index: -1
        }
        {
          name: hi_speed_sel
          struct: mubi4
          package: prim_mubi_pkg
          type: uni
          act: req
          width: 1
          inst_name: clkmgr_aon
          default: ""
          external: true
          top_signame: hi_speed_sel
          conn_type: false
          index: -1
        }
        {
          name: div_step_down_req
          struct: mubi4
          package: prim_mubi_pkg
          type: uni
          act: rcv
          width: 1
          inst_name: clkmgr_aon
          default: ""
          external: true
          top_signame: div_step_down_req
          conn_type: false
          index: -1
        }
        {
          name: lc_clk_byp_req
          struct: lc_tx
          package: lc_ctrl_pkg
          type: uni
          act: rcv
          width: 1
          inst_name: clkmgr_aon
          default: ""
          top_signame: lc_ctrl_lc_clk_byp_req
          index: -1
        }
        {
          name: lc_clk_byp_ack
          struct: lc_tx
          package: lc_ctrl_pkg
          type: uni
          act: req
          width: 1
          inst_name: clkmgr_aon
          default: ""
          top_signame: lc_ctrl_lc_clk_byp_ack
          index: -1
        }
        {
          name: jitter_en
          struct: mubi4
          package: prim_mubi_pkg
          type: uni
          act: req
          width: 1
          inst_name: clkmgr_aon
          default: ""
          external: true
          top_signame: clk_main_jitter_en
          conn_type: false
          index: -1
        }
        {
          name: pwr
          struct: pwr_clk
          type: req_rsp
          act: rsp
          width: 1
          inst_name: clkmgr_aon
          default: ""
          package: pwrmgr_pkg
          top_signame: pwrmgr_aon_pwr_clk
          index: -1
        }
        {
          name: idle
          struct: mubi4
          package: prim_mubi_pkg
          type: uni
          act: rcv
          width: 4
          inst_name: clkmgr_aon
          default: ""
          end_idx: -1
          top_type: one-to-N
          top_signame: clkmgr_aon_idle
          index: -1
        }
        {
          name: calib_rdy
          desc: Indicates clocks are calibrated and frequencies accurate
          struct: mubi4
          package: prim_mubi_pkg
          type: uni
          act: rcv
          width: 1
          default: prim_mubi_pkg::MuBi4True
          inst_name: clkmgr_aon
          external: true
          top_signame: calib_rdy
          conn_type: false
          index: -1
        }
        {
          name: tl
          struct: tl
          package: tlul_pkg
          type: req_rsp
          act: rsp
          width: 1
          inst_name: clkmgr_aon
          default: ""
          end_idx: -1
          top_signame: clkmgr_aon_tl
          index: -1
        }
      ]
      base_addrs:
      {
        null:
        {
          hart: 0x30420000
        }
      }
      generate_dif: true
    }
    {
      name: pinmux_aon
      type: pinmux
      template_type: pinmux
      clock_srcs:
      {
        clk_i: io_div4
        clk_aon_i: aon
      }
      clock_group: powerup
      reset_connections:
      {
        rst_ni:
        {
          name: lc_io_div4
          domain: Aon
        }
        rst_aon_ni:
        {
          name: lc_aon
          domain: Aon
        }
        rst_sys_ni:
        {
          name: sys_io_div4
          domain: Aon
        }
      }
      domain:
      [
        Aon
      ]
      attr: ipgen
      clock_connections:
      {
        clk_i: clkmgr_aon_clocks.clk_io_div4_powerup
        clk_aon_i: clkmgr_aon_clocks.clk_aon_powerup
      }
      param_decl: {}
      memory: {}
      param_list:
      [
        {
          name: TargetCfg
          desc: Target specific pinmux configuration.
          type: pinmux_pkg::target_cfg_t
          default: pinmux_pkg::DefaultTargetCfg
          local: "false"
          expose: "true"
          name_top: PinmuxAonTargetCfg
        }
      ]
      inter_signal_list:
      [
        {
          name: sleep_en
          desc: Level signal that is asserted when the power manager enters sleep.
          struct: logic
          type: uni
          act: rcv
          width: 1
          default: 1'b0
          inst_name: pinmux_aon
          package: ""
          top_signame: pwrmgr_aon_low_power
          index: -1
        }
        {
          name: pin_wkup_req
          desc: Wakeup request from wakeup detectors, to the power manager, running on the AON clock.
          struct: logic
          type: uni
          act: req
          width: 1
          default: 1'b0
          inst_name: pinmux_aon
          package: ""
          top_signame: pwrmgr_aon_wakeups
          index: 0
        }
        {
          name: tl
          struct: tl
          package: tlul_pkg
          type: req_rsp
          act: rsp
          width: 1
          inst_name: pinmux_aon
          default: ""
          end_idx: -1
          top_signame: pinmux_aon_tl
          index: -1
        }
      ]
      base_addrs:
      {
        null:
        {
          hart: 0x30460000
        }
      }
      generate_dif: true
    }
    {
      name: aon_timer_aon
      type: aon_timer
      clock_srcs:
      {
        clk_i: io_div4
        clk_aon_i: aon
      }
      clock_group: timers
      reset_connections:
      {
        rst_ni:
        {
          name: lc_io_div4
          domain: Aon
        }
        rst_aon_ni:
        {
          name: lc_aon
          domain: Aon
        }
      }
      domain:
      [
        Aon
      ]
      clock_connections:
      {
        clk_i: clkmgr_aon_clocks.clk_io_div4_timers
        clk_aon_i: clkmgr_aon_clocks.clk_aon_timers
      }
      param_decl: {}
      param_list: []
      inter_signal_list:
      [
        {
          name: nmi_wdog_timer_bark
          struct: logic
          type: uni
          act: req
          width: 1
          default: 1'b0
          inst_name: aon_timer_aon
          package: ""
          end_idx: -1
          top_type: broadcast
          top_signame: aon_timer_aon_nmi_wdog_timer_bark
          index: -1
        }
        {
          name: wkup_req
          struct: logic
          type: uni
          act: req
          width: 1
          default: 1'b0
          inst_name: aon_timer_aon
          package: ""
          top_signame: pwrmgr_aon_wakeups
          index: 1
        }
        {
          name: aon_timer_rst_req
          struct: logic
          type: uni
          act: req
          width: 1
          default: 1'b0
          inst_name: aon_timer_aon
          package: ""
          top_signame: pwrmgr_aon_rstreqs
          index: 0
        }
        {
          name: lc_escalate_en
          struct: lc_tx
          package: lc_ctrl_pkg
          type: uni
          act: rcv
          width: 1
          default: lc_ctrl_pkg::Off
          inst_name: aon_timer_aon
          top_signame: lc_ctrl_lc_escalate_en
          index: -1
        }
        {
          name: sleep_mode
          struct: logic
          type: uni
          act: rcv
          width: 1
          inst_name: aon_timer_aon
          default: ""
          package: ""
          top_signame: pwrmgr_aon_low_power
          index: -1
        }
        {
          name: racl_policies
          desc:
            '''
            Incoming RACL policy vector from a racl_ctrl instance.
            The policy selection vector (parameter) selects the policy for each register.
            '''
          struct: racl_policy_vec
          package: top_racl_pkg
          type: uni
          act: rcv
          width: 1
          inst_name: aon_timer_aon
          index: -1
        }
        {
          name: racl_error
          desc: RACL error log information of this module.
          struct: racl_error_log
          package: top_racl_pkg
          type: uni
          act: req
          width: 1
          inst_name: aon_timer_aon
          index: -1
        }
        {
          name: tl
          struct: tl
          package: tlul_pkg
          type: req_rsp
          act: rsp
          width: 1
          inst_name: aon_timer_aon
          default: ""
          end_idx: -1
          top_signame: aon_timer_aon_tl
          index: -1
        }
      ]
      base_addrs:
      {
        null:
        {
          hart: 0x30470000
        }
      }
      generate_dif: true
    }
    {
      name: ast
      type: ast
      clock_srcs:
      {
        clk_ast_tlul_i:
        {
          clock: io_div4
          group: infra
        }
        clk_ast_adc_i:
        {
          clock: aon
          group: peri
        }
        clk_ast_alert_i:
        {
          clock: io_div4
          group: secure
        }
        clk_ast_es_i:
        {
          clock: main
          group: secure
        }
        clk_ast_rng_i:
        {
          clock: main
          group: secure
        }
      }
      clock_group: secure
      reset_connections:
      {
        rst_ast_tlul_ni:
        {
          name: lc_io_div4
          domain: "0"
        }
        rst_ast_adc_ni:
        {
          name: lc_aon
          domain: Aon
        }
        rst_ast_alert_ni:
        {
          name: lc_io_div4
          domain: "0"
        }
        rst_ast_es_ni:
        {
          name: lc
          domain: "0"
        }
        rst_ast_rng_ni:
        {
          name: lc
          domain: "0"
        }
      }
      domain:
      [
        Aon
        "0"
      ]
      attr: reggen_only
      clock_connections:
      {
        clk_ast_tlul_i: clkmgr_aon_clocks.clk_io_div4_infra
        clk_ast_adc_i: clkmgr_aon_clocks.clk_aon_peri
        clk_ast_alert_i: clkmgr_aon_clocks.clk_io_div4_secure
        clk_ast_es_i: clkmgr_aon_clocks.clk_main_secure
        clk_ast_rng_i: clkmgr_aon_clocks.clk_main_secure
      }
      param_decl: {}
      param_list: []
      inter_signal_list:
      [
        {
          name: tl
          struct: tl
          package: tlul_pkg
          type: req_rsp
          act: rsp
          width: 1
          inst_name: ast
          index: -1
        }
      ]
      base_addrs:
      {
        null:
        {
          hart: 0x30480000
        }
      }
      generate_dif: true
    }
    {
      name: soc_proxy
      type: soc_proxy
      clock_srcs:
      {
        clk_i: main
        clk_aon_i: aon
      }
      clock_group: infra
      reset_connections:
      {
        rst_ni:
        {
          name: lc
          domain: "0"
        }
        rst_por_ni:
        {
          name: por_io_div4
          domain: Aon
        }
      }
      domain:
      [
        Aon
        "0"
      ]
      base_addrs:
      {
        core:
        {
          hart: 0x22030000
        }
        ctn:
        {
          hart: 0x40000000
        }
      }
      attr: reggen_top
      memory:
      {
        ctn:
        {
          label: ctn
          swaccess: rw
          data_intg_passthru: "true"
          exec: True
          byte_write: True
          size: 0x40000000
        }
      }
      clock_connections:
      {
        clk_i: clkmgr_aon_clocks.clk_main_infra
        clk_aon_i: clkmgr_aon_clocks.clk_aon_infra
      }
      param_decl: {}
      param_list: []
      inter_signal_list:
      [
        {
          name: dma_tl_h2d
          desc: TL-UL host port for the DMA to egress into CTN (request part), synchronous
          struct: tl_h2d
          package: tlul_pkg
          type: uni
          act: rcv
          width: 1
          inst_name: soc_proxy
          default: ""
          end_idx: -1
          top_type: broadcast
          top_signame: soc_proxy_dma_tl_h2d
          index: -1
        }
        {
          name: dma_tl_d2h
          desc: TL-UL host port for the DMA to egress into CTN (response part), synchronous
          struct: tl_d2h
          package: tlul_pkg
          type: uni
          act: req
          width: 1
          inst_name: soc_proxy
          default: ""
          end_idx: -1
          top_type: broadcast
          top_signame: soc_proxy_dma_tl_d2h
          index: -1
        }
        {
          name: misc_tl_h2d
          desc: TL-UL host port for the MISC to egress into CTN (request part), synchronous
          struct: tl_h2d
          package: tlul_pkg
          type: uni
          act: rcv
          width: 1
          inst_name: soc_proxy
          default: ""
          external: true
          top_signame: ctn_misc_tl_h2d
          conn_type: false
          index: -1
        }
        {
          name: misc_tl_d2h
          desc: TL-UL host port for the MISC to egress into CTN (response part), synchronous
          struct: tl_d2h
          package: tlul_pkg
          type: uni
          act: req
          width: 1
          inst_name: soc_proxy
          default: ""
          external: true
          top_signame: ctn_misc_tl_d2h
          conn_type: false
          index: -1
        }
        {
          name: wkup_internal_req
          struct: logic
          type: uni
          act: req
          width: 1
          inst_name: soc_proxy
          default: ""
          package: ""
          top_signame: pwrmgr_aon_wakeups
          index: 2
        }
        {
          name: wkup_external_req
          struct: logic
          type: uni
          act: req
          width: 1
          inst_name: soc_proxy
          default: ""
          package: ""
          top_signame: pwrmgr_aon_wakeups
          index: 3
        }
        {
          name: rst_req_external
          struct: logic
          type: uni
          act: req
          width: 1
          inst_name: soc_proxy
          default: ""
          package: ""
          top_signame: pwrmgr_aon_rstreqs
          index: 1
        }
        {
          name: ctn_tl_h2d
          desc: TL-UL host port for egress into CTN (request part), synchronous
          struct: tl_h2d
          package: tlul_pkg
          type: uni
          act: req
          width: 1
          inst_name: soc_proxy
          default: ""
          end_idx: -1
          top_type: broadcast
          top_signame: soc_proxy_ctn_tl_h2d
          index: -1
        }
        {
          name: ctn_tl_d2h
          desc: TL-UL host port for egress into CTN (response part), synchronous
          struct: tl_d2h
          package: tlul_pkg
          type: uni
          act: rcv
          width: 1
          inst_name: soc_proxy
          default: ""
          end_idx: -1
          top_type: broadcast
          top_signame: soc_proxy_ctn_tl_d2h
          index: -1
        }
        {
          name: i2c_lsio_trigger
          desc: LSIO trigger signal from I2C
          struct: logic
          type: uni
          act: rcv
          width: 1
          inst_name: soc_proxy
          default: ""
          package: ""
          top_signame: i2c0_lsio_trigger
          index: -1
        }
        {
          name: spi_host_lsio_trigger
          desc: LSIO trigger signal from SPI Host
          struct: logic
          type: uni
          act: rcv
          width: 1
          inst_name: soc_proxy
          default: ""
          package: ""
          top_signame: spi_host0_lsio_trigger
          index: -1
        }
        {
          name: uart_lsio_trigger
          desc: LSIO trigger signal from UART
          struct: logic
          type: uni
          act: rcv
          width: 1
          inst_name: soc_proxy
          default: ""
          package: ""
          top_signame: uart0_lsio_trigger
          index: -1
        }
        {
          name: soc_lsio_trigger
          desc: LSIO trigger signal from SoC, synchronous
          struct: logic
          type: uni
          act: rcv
          width: 8
          inst_name: soc_proxy
          default: ""
          package: ""
          external: true
          top_signame: soc_lsio_trigger
          conn_type: false
          index: -1
        }
        {
          name: dma_lsio_trigger
          desc: Collated synchronous LSIO trigger signals for DMA
          struct: lsio_trigger
          package: dma_pkg
          type: uni
          act: req
          width: 1
          inst_name: soc_proxy
          default: ""
          top_signame: dma_lsio_trigger
          index: -1
        }
        {
          name: soc_fatal_alert
          desc: Differential fatal alert from SoC, synchronous
          struct: soc_alert
          package: soc_proxy_pkg
          type: req_rsp
          act: rsp
          width: 24
          inst_name: soc_proxy
          default: ""
          external: true
          top_signame: soc_fatal_alert
          conn_type: false
          index: -1
        }
        {
          name: soc_recov_alert
          desc: Differential recoverable alert from SoC, synchronous
          struct: soc_alert
          package: soc_proxy_pkg
          type: req_rsp
          act: rsp
          width: 4
          inst_name: soc_proxy
          default: ""
          external: true
          top_signame: soc_recov_alert
          conn_type: false
          index: -1
        }
        {
          name: soc_wkup_async
          desc: Wakeup request from SoC, asynchronous, level-encoded
          struct: logic
          type: uni
          act: rcv
          width: 1
          inst_name: soc_proxy
          default: ""
          package: ""
          external: true
          top_signame: soc_wkup_async
          conn_type: false
          index: -1
        }
        {
          name: soc_rst_req_async
          desc: Reset request from SoC, asynchronous, level-encoded
          struct: logic
          type: uni
          act: rcv
          width: 1
          inst_name: soc_proxy
          default: ""
          package: ""
          external: true
          top_signame: soc_rst_req_async
          conn_type: false
          index: -1
        }
        {
          name: soc_intr_async
          desc: Interrupt request from SoC, asynchronous, level-encoded
          struct: logic
          type: uni
          act: rcv
          width: 32
          inst_name: soc_proxy
          default: ""
          package: ""
          external: true
          top_signame: soc_intr_async
          conn_type: false
          index: -1
        }
        {
          name: soc_gpi_async
          desc: GPI from SoC, async
          struct: logic
          type: uni
          act: req
          width: 16
          inst_name: soc_proxy
          default: ""
          package: ""
          external: true
          top_signame: soc_gpi_async
          conn_type: false
          index: -1
        }
        {
          name: soc_gpo_async
          desc: GPO from SoC, async
          struct: logic
          type: uni
          act: rcv
          width: 16
          inst_name: soc_proxy
          default: ""
          package: ""
          external: true
          top_signame: soc_gpo_async
          conn_type: false
          index: -1
        }
        {
          name: integrator_id
          desc: Integrator ID signal used in BAT
          struct: logic
          type: uni
          act: rcv
          width: 4
          inst_name: soc_proxy
          default: ""
          package: ""
          external: true
          top_signame: integrator_id
          conn_type: false
          index: -1
        }
        {
          name: core_tl
          struct: tl
          package: tlul_pkg
          type: req_rsp
          act: rsp
          width: 1
          inst_name: soc_proxy
          default: ""
          end_idx: -1
          top_signame: soc_proxy_core_tl
          index: -1
        }
        {
          name: ctn_tl
          struct: tl
          package: tlul_pkg
          type: req_rsp
          act: rsp
          width: 1
          inst_name: soc_proxy
          default: ""
          end_idx: -1
          top_signame: soc_proxy_ctn_tl
          index: -1
        }
      ]
      generate_dif: true
    }
    {
      name: sram_ctrl_ret_aon
      type: sram_ctrl
      clock_srcs:
      {
        clk_i: io_div4
        clk_otp_i: io_div4
      }
      clock_group: infra
      reset_connections:
      {
        rst_ni:
        {
          name: lc_io_div4
          domain: Aon
        }
        rst_otp_ni:
        {
          name: lc_io_div4
          domain: Aon
        }
      }
      domain:
      [
        Aon
      ]
      param_decl:
      {
        InstrExec: "0"
        InstSize: 4096
      }
      base_addrs:
      {
        regs:
        {
          hart: 0x30500000
        }
        ram:
        {
          hart: 0x30600000
        }
      }
      memory:
      {
        ram:
        {
          label: ram_ret_aon
          swaccess: rw
          data_intg_passthru: "true"
          exec: True
          byte_write: True
          size: 0x1000
        }
      }
      clock_connections:
      {
        clk_i: clkmgr_aon_clocks.clk_io_div4_infra
        clk_otp_i: clkmgr_aon_clocks.clk_io_div4_infra
      }
      param_list:
      [
        {
          name: RndCnstSramKey
          desc: Compile-time random reset value for SRAM scrambling key.
          type: otp_ctrl_pkg::sram_key_t
          randcount: 128
          randtype: data
          name_top: RndCnstSramCtrlRetAonSramKey
          default: 0x7b2ce9fc83ddaf1dd8c5a42e2ad24fa0
          randwidth: 128
        }
        {
          name: RndCnstSramNonce
          desc: Compile-time random reset value for SRAM scrambling nonce.
          type: otp_ctrl_pkg::sram_nonce_t
          randcount: 128
          randtype: data
          name_top: RndCnstSramCtrlRetAonSramNonce
          default: 0x2221b6ff5aad7a9c09d5d9fdd1cfcf51
          randwidth: 128
        }
        {
          name: RndCnstLfsrSeed
          desc: Compile-time random bits for initial LFSR seed
          type: sram_ctrl_pkg::lfsr_seed_t
          randcount: 32
          randtype: data
          name_top: RndCnstSramCtrlRetAonLfsrSeed
          default: 0x2835c0cf
          randwidth: 32
        }
        {
          name: RndCnstLfsrPerm
          desc: Compile-time random permutation for LFSR output
          type: sram_ctrl_pkg::lfsr_perm_t
          randcount: 32
          randtype: perm
          name_top: RndCnstSramCtrlRetAonLfsrPerm
          default: 0xe87d0cb10f19e4a018824f2ff75b6b6c693c68b5
          randwidth: 160
        }
        {
          name: MemSizeRam
          desc: Memory size of the RAM (in bytes).
          type: int
          name_top: MemSizeSramCtrlRetAonRam
          default: 4096
        }
        {
          name: InstSize
          desc: Memory size of a single RAM tile (in bytes).
          type: int
          default: 4096
          local: "false"
          expose: "true"
          name_top: SramCtrlRetAonInstSize
        }
        {
          name: NumRamInst
          desc: Number of internal RAM instances. Must be the same as ceil(MemSizeRam / InstSize) .
          type: int
          default: 1
          local: "false"
          expose: "true"
          name_top: SramCtrlRetAonNumRamInst
        }
        {
          name: InstrExec
          desc: Support execution from SRAM
          type: bit
          default: "0"
          local: "false"
          expose: "true"
          name_top: SramCtrlRetAonInstrExec
        }
        {
          name: NumPrinceRoundsHalf
          desc: Number of PRINCE half rounds for the SRAM scrambling feature
          type: int
          default: "3"
          local: "false"
          expose: "true"
          name_top: SramCtrlRetAonNumPrinceRoundsHalf
        }
        {
          name: Outstanding
          desc: Number of outstanding TLUL transactions
          type: int
          default: "2"
          local: "true"
          expose: "true"
          name_top: SramCtrlRetAonOutstanding
        }
        {
          name: EccCorrection
          desc: Enable single-bit error correction and error logging
          type: bit
          default: "0"
          local: "false"
          expose: "true"
          name_top: SramCtrlRetAonEccCorrection
        }
      ]
      inter_signal_list:
      [
        {
          name: sram_otp_key
          struct: sram_otp_key
          package: otp_ctrl_pkg
          type: req_rsp
          act: req
          width: 1
          inst_name: sram_ctrl_ret_aon
          default: ""
          top_signame: otp_ctrl_sram_otp_key
          index: 1
        }
        {
          name: cfg
          struct: ram_1p_cfg
          package: prim_ram_1p_pkg
          type: uni
          act: rcv
          width:
          {
            name: NumRamInst
            desc: Number of internal RAM instances. Must be the same as ceil(MemSizeRam / InstSize) .
            param_type: int
            unpacked_dimensions: null
            default: 1
            local: false
            expose: true
            name_top: SramCtrlRetAonNumRamInst
          }
          default: "'0"
          inst_name: sram_ctrl_ret_aon
          external: true
          top_signame: sram_ctrl_ret_aon_ram_1p_cfg
          conn_type: false
          index: -1
        }
        {
          name: cfg_rsp
          struct: ram_1p_cfg_rsp
          package: prim_ram_1p_pkg
          type: uni
          act: req
          width:
          {
            name: NumRamInst
            desc: Number of internal RAM instances. Must be the same as ceil(MemSizeRam / InstSize) .
            param_type: int
            unpacked_dimensions: null
            default: 1
            local: false
            expose: true
            name_top: SramCtrlRetAonNumRamInst
          }
          default: "'0"
          inst_name: sram_ctrl_ret_aon
          external: true
          top_signame: sram_ctrl_ret_aon_ram_1p_cfg_rsp
          conn_type: false
          index: -1
        }
        {
          name: lc_escalate_en
          struct: lc_tx
          package: lc_ctrl_pkg
          type: uni
          act: rcv
          width: 1
          default: lc_ctrl_pkg::Off
          inst_name: sram_ctrl_ret_aon
          top_signame: lc_ctrl_lc_escalate_en
          index: -1
        }
        {
          name: lc_hw_debug_en
          struct: lc_tx
          package: lc_ctrl_pkg
          type: uni
          act: rcv
          width: 1
          default: lc_ctrl_pkg::Off
          inst_name: sram_ctrl_ret_aon
          index: -1
        }
        {
          name: otp_en_sram_ifetch
          struct: mubi8
          package: prim_mubi_pkg
          type: uni
          act: rcv
          width: 1
          default: prim_mubi_pkg::MuBi8False
          inst_name: sram_ctrl_ret_aon
          index: -1
        }
        {
          name: racl_policies
          desc:
            '''
            Incoming RACL policy vector from a racl_ctrl instance.
            The policy selection vector (parameter) selects the policy for each register.
            '''
          struct: racl_policy_vec
          package: top_racl_pkg
          type: uni
          act: rcv
          width: 1
          inst_name: sram_ctrl_ret_aon
          index: -1
        }
        {
          name: racl_error
          desc: RACL error log information of this module.
          struct: racl_error_log
          package: top_racl_pkg
          type: uni
          act: req
          width: 1
          inst_name: sram_ctrl_ret_aon
          index: -1
        }
        {
          name: sram_rerror
          desc: SRAM read error indicating correctable and uncorrectable ECC errors.
          struct: sram_error_t
          package: sram_ctrl_pkg
          type: uni
          act: req
          width: 1
          inst_name: sram_ctrl_ret_aon
          index: -1
        }
        {
          name: regs_tl
          struct: tl
          package: tlul_pkg
          type: req_rsp
          act: rsp
          width: 1
          inst_name: sram_ctrl_ret_aon
          default: ""
          end_idx: -1
          top_signame: sram_ctrl_ret_aon_regs_tl
          index: -1
        }
        {
          name: ram_tl
          struct: tl
          package: tlul_pkg
          type: req_rsp
          act: rsp
          width: 1
          inst_name: sram_ctrl_ret_aon
          default: ""
          end_idx: -1
          top_signame: sram_ctrl_ret_aon_ram_tl
          index: -1
        }
      ]
      generate_dif: true
    }
    {
      name: rv_dm
      type: rv_dm
      clock_srcs:
      {
        clk_i: main
        clk_lc_i: main
      }
      clock_group: infra
      reset_connections:
      {
        rst_ni:
        {
          name: sys
          domain: "0"
        }
        rst_lc_ni:
        {
          name: lc
          domain: "0"
        }
      }
      base_addrs:
      {
        mem:
        {
          hart: 0x00040000
        }
        regs:
        {
          hart: 0x21200000
        }
        dbg:
        {
          soc_dbg: 0x00000000
        }
      }
      param_decl:
      {
        SecVolatileRawUnlockEn: top_pkg::SecVolatileRawUnlockEn
        UseDmiInterface: "1"
      }
      generate_dif: false
      clock_connections:
      {
        clk_i: clkmgr_aon_clocks.clk_main_infra
        clk_lc_i: clkmgr_aon_clocks.clk_main_infra
      }
      memory: {}
      param_list:
      [
        {
          name: IdcodeValue
          desc: RISC-V debug module JTAG ID code.
          type: logic [31:0]
          default: 32'h 0000_0001
          local: "false"
          expose: "true"
          name_top: RvDmIdcodeValue
        }
        {
          name: UseDmiInterface
          desc: When 1, a TLUL-based DMI interface is used. When 0, a JTAG TAP is used.
          type: bit
          default: "1"
          local: "false"
          expose: "true"
          name_top: RvDmUseDmiInterface
        }
        {
          name: SecVolatileRawUnlockEn
          desc:
            '''
            Disable (0) or enable (1) volatile RAW UNLOCK capability.
            If enabled, the strap_en_override_i input can be used to re-sample the straps at runtime.
            IMPORTANT NOTE: This should only be used in test chips. The parameter must be set
            to 0 in production tapeouts since this weakens the security posture of the RAW
            UNLOCK mechanism.
            '''
          type: bit
          default: top_pkg::SecVolatileRawUnlockEn
          local: "false"
          expose: "true"
          name_top: SecRvDmVolatileRawUnlockEn
        }
        {
          name: TlulHostUserRsvdBits
          desc: TLUL user bits sent on outgoing transfers.
          type: logic [tlul_pkg::RsvdWidth-1:0]
          default: "'0"
          local: "false"
          expose: "true"
          name_top: RvDmTlulHostUserRsvdBits
        }
      ]
      inter_signal_list:
      [
        {
          name: next_dm_addr
          desc:
            '''
            32bit word address of the next debug module.
            Set to 0x0 if this is the last debug module in the chain.
            '''
          struct: next_dm_addr
          package: rv_dm_pkg
          type: uni
          act: rcv
          width: 1
          default: "'0"
          inst_name: rv_dm
          external: true
          top_signame: rv_dm_next_dm_addr
          conn_type: false
          index: -1
        }
        {
          name: jtag
          desc: JTAG signals for the RISC-V TAP.
          struct: jtag
          package: jtag_pkg
          type: req_rsp
          act: rsp
          width: 1
          inst_name: rv_dm
          index: -1
        }
        {
          name: lc_hw_debug_en
          desc:
            '''
            Multibit life cycle hardware debug enable signal coming from life cycle controller,
            asserted when the hardware debug mechanisms are enabled in the system.
            '''
          struct: lc_tx
          package: lc_ctrl_pkg
          type: uni
          act: rcv
          width: 1
          default: lc_ctrl_pkg::Off
          inst_name: rv_dm
          top_signame: lc_ctrl_lc_hw_debug_en
          index: -1
        }
        {
          name: lc_dft_en
          desc:
            '''
            Multibit life cycle hardware debug enable signal coming from life cycle controller,
            asserted when the DFT mechanisms are enabled in the system.
            '''
          struct: lc_tx
          package: lc_ctrl_pkg
          type: uni
          act: rcv
          width: 1
          default: lc_ctrl_pkg::Off
          inst_name: rv_dm
          index: -1
        }
        {
          name: pinmux_hw_debug_en
          desc:
            '''
            Multibit life cycle hardware debug enable signal coming from pinmux.
            This is a latched version of the lc_hw_debug_en signal and is only used to
            gate the JTAG / TAP side of the RV_DM. It is used to keep a debug session live
            while the rest of the system undergoes an NDM reset.
            '''
          struct: lc_tx
          package: lc_ctrl_pkg
          type: uni
          act: rcv
          width: 1
          default: lc_ctrl_pkg::Off
          inst_name: rv_dm
          index: -1
        }
        {
          name: otp_dis_rv_dm_late_debug
          struct: mubi8
          package: prim_mubi_pkg
          type: uni
          act: rcv
          width: 1
          default: prim_mubi_pkg::MuBi8False
          inst_name: rv_dm
          top_signame: rv_dm_otp_dis_rv_dm_late_debug
          index: -1
        }
        {
          name: unavailable
          desc:
            '''
            This signal indicates to the debug module that the main processor is not available
            for debug (e.g. due to a low-power state).
            '''
          struct: logic
          type: uni
          act: rcv
          width: 1
          default: 1'b0
          inst_name: rv_dm
          index: -1
        }
        {
          name: ndmreset_req
          desc: Non-debug module reset request going to the system reset infrastructure.
          struct: logic
          type: uni
          act: req
          width: 1
          inst_name: rv_dm
          default: ""
          package: ""
          end_idx: -1
          top_type: broadcast
          top_signame: rv_dm_ndmreset_req
          index: -1
        }
        {
          name: dmactive
          desc:
            '''
            This signal indicates whether the debug module is active and can be used to prevent
            power down of the core and bus-attached peripherals.
            '''
          struct: logic
          type: uni
          act: req
          width: 1
          inst_name: rv_dm
          index: -1
        }
        {
          name: debug_req
          desc: This is the debug request interrupt going to the main processor.
          struct: logic [rv_dm_reg_pkg::NrHarts-1:0]
          type: uni
          act: req
          width: 1
          inst_name: rv_dm
          default: ""
          package: ""
          end_idx: -1
          top_type: broadcast
          top_signame: rv_dm_debug_req
          index: -1
        }
        {
          name: lc_escalate_en
          desc:
            '''
            Escalation enable signal coming from life cycle controller, used for invalidating
            the latched lc_hw_debug_en state inside the strap sampling logic.
            '''
          struct: lc_tx
          package: lc_ctrl_pkg
          type: uni
          act: rcv
          width: 1
          default: lc_ctrl_pkg::Off
          inst_name: rv_dm
          top_signame: lc_ctrl_lc_escalate_en
          index: -1
        }
        {
          name: lc_check_byp_en
          desc:
            '''
            Check bypass enable signal coming from life cycle controller, used for invalidating
            the latched lc_hw_debug_en state inside the strap sampling logic. This signal is asserted
            whenever the life cycle controller performs a life cycle transition. Its main use is
            to skip any background checks inside the life cycle partition of the OTP controller while
            a life cycle transition is in progress.
            '''
          struct: lc_tx
          package: lc_ctrl_pkg
          type: uni
          act: rcv
          width: 1
          default: lc_ctrl_pkg::Off
          inst_name: rv_dm
          top_signame: lc_ctrl_lc_check_byp_en
          index: -1
        }
        {
          name: strap_en
          desc: This signal is pulsed high by the power manager after reset in order to sample the HW straps.
          struct: logic
          type: uni
          act: rcv
          width: 1
          default: 1'b0
          inst_name: rv_dm
          package: ""
          top_signame: pwrmgr_aon_strap
          index: -1
        }
        {
          name: strap_en_override
          desc:
            '''
            This signal transitions from 0 -> 1 by the lc_ctrl manager after volatile RAW_UNLOCK in order to re-sample the HW straps.
            The signal must stay at 1 until reset.
            Note that this is only used in test chips when SecVolatileRawUnlockEn = 1.
            Otherwise this signal is unused.
            '''
          struct: logic
          type: uni
          act: rcv
          width: 1
          default: 1'b0
          inst_name: rv_dm
          package: ""
          top_signame: lc_ctrl_strap_en_override
          index: -1
        }
        {
          name: racl_policies
          desc:
            '''
            Incoming RACL policy vector from a racl_ctrl instance.
            The policy selection vector (parameter) selects the policy for each register.
            '''
          struct: racl_policy_vec
          package: top_racl_pkg
          type: uni
          act: rcv
          width: 1
          inst_name: rv_dm
          index: -1
        }
        {
          name: racl_error
          desc: RACL error log information of this module.
          struct: racl_error_log
          package: top_racl_pkg
          type: uni
          act: req
          width: 1
          inst_name: rv_dm
          index: -1
        }
        {
          name: sba_tl_h
          struct: tl
          package: tlul_pkg
          type: req_rsp
          act: req
          width: 1
          inst_name: rv_dm
          default: ""
          top_signame: main_tl_rv_dm__sba
          index: -1
        }
        {
          name: regs_tl_d
          struct: tl
          package: tlul_pkg
          type: req_rsp
          act: rsp
          width: 1
          inst_name: rv_dm
          default: ""
          end_idx: -1
          top_signame: rv_dm_regs_tl_d
          index: -1
        }
        {
          name: mem_tl_d
          struct: tl
          package: tlul_pkg
          type: req_rsp
          act: rsp
          width: 1
          inst_name: rv_dm
          default: ""
          end_idx: -1
          top_signame: rv_dm_mem_tl_d
          index: -1
        }
        {
          name: dbg_tl_d
          struct: tl
          package: tlul_pkg
          type: req_rsp
          act: rsp
          width: 1
          inst_name: rv_dm
          default: ""
          end_idx: -1
          top_signame: rv_dm_dbg_tl_d
          index: -1
        }
      ]
      domain:
      [
        "0"
      ]
    }
    {
      name: rv_plic
      type: rv_plic
      template_type: rv_plic
      clock_srcs:
      {
        clk_i: main
      }
      clock_group: secure
      reset_connections:
      {
        rst_ni:
        {
          name: lc
          domain: "0"
        }
      }
      attr: ipgen
      clock_connections:
      {
        clk_i: clkmgr_aon_clocks.clk_main_secure
      }
      param_decl: {}
      param_list: []
      inter_signal_list:
      [
        {
          name: irq
          struct: logic
          type: uni
          act: req
          width: 1
          inst_name: rv_plic
          default: ""
          package: ""
          end_idx: -1
          top_type: broadcast
          top_signame: rv_plic_irq
          index: -1
        }
        {
          name: irq_id
          struct: logic
          type: uni
          act: req
          width: 1
          inst_name: rv_plic
          index: -1
        }
        {
          name: msip
          struct: logic
          type: uni
          act: req
          width: 1
          inst_name: rv_plic
          default: ""
          package: ""
          end_idx: -1
          top_type: broadcast
          top_signame: rv_plic_msip
          index: -1
        }
        {
          name: tl
          struct: tl
          package: tlul_pkg
          type: req_rsp
          act: rsp
          width: 1
          inst_name: rv_plic
          default: ""
          end_idx: -1
          top_signame: rv_plic_tl
          index: -1
        }
      ]
      base_addrs:
      {
        null:
        {
          hart: 0x28000000
        }
      }
      generate_dif: true
      domain:
      [
        "0"
      ]
    }
    {
      name: aes
      type: aes
      clock_srcs:
      {
        clk_i: main
        clk_edn_i: main
      }
      clock_group: trans
      reset_connections:
      {
        rst_ni:
        {
          name: lc
          domain: "0"
        }
        rst_edn_ni:
        {
          name: lc
          domain: "0"
        }
      }
      param_decl:
      {
        SecMasking: "1"
        SecSBoxImpl: aes_pkg::SBoxImplDom
      }
      clock_connections:
      {
        clk_i: clkmgr_aon_clocks.clk_main_aes
        clk_edn_i: clkmgr_aon_clocks.clk_main_aes
      }
      memory: {}
      param_list:
      [
        {
          name: AES192Enable
          desc: Disable (0) or enable (1) support for 192-bit key lengths (AES-192).
          type: bit
          default: 1'b1
          local: "false"
          expose: "false"
          name_top: AesAES192Enable
        }
        {
          name: SecMasking
          desc:
            '''
            Disable (0) or enable (1) first-order masking of the AES cipher core.
            Masking requires the use of a masked S-Box, see SecSBoxImpl parameter.
            '''
          type: bit
          default: "1"
          local: "false"
          expose: "true"
          name_top: SecAesMasking
        }
        {
          name: SecSBoxImpl
          desc: Selection of the S-Box implementation. See aes_pkg.sv.
          type: aes_pkg::sbox_impl_e
          default: aes_pkg::SBoxImplDom
          local: "false"
          expose: "true"
          name_top: SecAesSBoxImpl
        }
        {
          name: SecStartTriggerDelay
          desc:
            '''
            Manual start trigger delay, useful for SCA measurements.
            A value of e.g. 40 allows the processor to go into sleep before AES starts operation.
            '''
          type: int unsigned
          default: "0"
          local: "false"
          expose: "true"
          name_top: SecAesStartTriggerDelay
        }
        {
          name: SecAllowForcingMasks
          desc:
            '''
            Forbid (0) or allow (1) forcing the masking PRNG output to a constant value via FORCE_MASKS bit in the Auxiliary Control Register.
            Useful for SCA measurements.
            Meaningful only if masking is enabled.
            '''
          type: bit
          default: 1'b0
          local: "false"
          expose: "true"
          name_top: SecAesAllowForcingMasks
        }
        {
          name: SecSkipPRNGReseeding
          desc:
            '''
            Perform (0) or skip (1) PRNG reseeding requests, useful for SCA measurements only.
            The current SCA setup doesn't provide sufficient resources to implement the infrastructure required for PRNG reseeding (CSRNG, EDN).
            To enable SCA resistance evaluations, we need to skip reseeding requests on the SCA platform.
            '''
          type: bit
          default: 1'b0
          local: "false"
          expose: "true"
          name_top: SecAesSkipPRNGReseeding
        }
        {
          name: RndCnstClearingLfsrSeed
          desc: Default seed of the PRNG used for register clearing.
          type: aes_pkg::clearing_lfsr_seed_t
          randcount: 64
          randtype: data
          name_top: RndCnstAesClearingLfsrSeed
          default: 0x9864fd4ce49d2cfc
          randwidth: 64
        }
        {
          name: RndCnstClearingLfsrPerm
          desc: Permutation applied to the LFSR of the PRNG used for clearing.
          type: aes_pkg::clearing_lfsr_perm_t
          randcount: 64
          randtype: perm
          name_top: RndCnstAesClearingLfsrPerm
          default: 0x8777abc015988e40cfc943a7a17e66b7177d895b35bee482185d1f67bffc2cd4c72a0abe95a338229011736e90244cdb
          randwidth: 384
        }
        {
          name: RndCnstClearingSharePerm
          desc: Permutation applied to the clearing PRNG output for clearing the second share of registers.
          type: aes_pkg::clearing_lfsr_perm_t
          randcount: 64
          randtype: perm
          name_top: RndCnstAesClearingSharePerm
          default: 0x9aafc50a72f0bbe55fb10265d29883ce15b713d78a1fc6406124646e3ece32d05c1ba3f136f7795384e0ad7a356b2d88
          randwidth: 384
        }
        {
          name: RndCnstMaskingLfsrSeed
          desc: Default seed of the PRNG used for masking.
          type: aes_pkg::masking_lfsr_seed_t
          randcount: 288
          randtype: data
          name_top: RndCnstAesMaskingLfsrSeed
          default: 0xdc0dc524d3b0554603562188552794dd2bebf67f318b5a490e55f7d8b8325652a92482cc
          randwidth: 288
        }
        {
          name: RndCnstMaskingLfsrPerm
          desc: Permutation applied to the output of the PRNG used for masking.
          type: aes_pkg::masking_lfsr_perm_t
          randcount: 160
          randtype: perm
          name_top: RndCnstAesMaskingLfsrPerm
          default: 0x4a9702757c9b5d49285626121b7769037f89926a8b4d433f7948722f81141f7b5f93007e54632a915336257d71176b5a1e1331955b6e9644607a57809c7655686f3e45276c66860e076d629a4b98583b0f65101974294c8e9e332b11709f1d61992e0b1687518a8d0632390421083d8278418459942009679d85500c4f3842904e3a220523883c64405c3501245e2c8f522d47830d151c18300a1a73378c4634
          randwidth: 1280
        }
      ]
      inter_signal_list:
      [
        {
          name: idle
          struct: mubi4
          package: prim_mubi_pkg
          type: uni
          act: req
          width: 1
          inst_name: aes
          default: ""
          top_signame: clkmgr_aon_idle
          index: 0
        }
        {
          name: lc_escalate_en
          struct: lc_tx
          package: lc_ctrl_pkg
          type: uni
          act: rcv
          width: 1
          default: lc_ctrl_pkg::Off
          inst_name: aes
          top_signame: lc_ctrl_lc_escalate_en
          index: -1
        }
        {
          name: edn
          struct: edn
          package: edn_pkg
          type: req_rsp
          act: req
          width: 1
          inst_name: aes
          default: ""
          top_signame: edn0_edn
          index: 5
        }
        {
          name: keymgr_key
          struct: hw_key_req
          package: keymgr_pkg
          type: uni
          act: rcv
          width: 1
          inst_name: aes
          default: ""
          top_signame: keymgr_dpe_aes_key
          index: -1
        }
        {
          name: tl
          struct: tl
          package: tlul_pkg
          type: req_rsp
          act: rsp
          width: 1
          inst_name: aes
          default: ""
          end_idx: -1
          top_signame: aes_tl
          index: -1
        }
      ]
      base_addrs:
      {
        null:
        {
          hart: 0x21100000
        }
      }
      generate_dif: true
      domain:
      [
        "0"
      ]
    }
    {
      name: hmac
      type: hmac
      clock_srcs:
      {
        clk_i: main
      }
      clock_group: trans
      reset_connections:
      {
        rst_ni:
        {
          name: lc
          domain: "0"
        }
      }
      clock_connections:
      {
        clk_i: clkmgr_aon_clocks.clk_main_hmac
      }
      param_decl: {}
      param_list: []
      inter_signal_list:
      [
        {
          name: idle
          struct: mubi4
          package: prim_mubi_pkg
          type: uni
          act: req
          width: 1
          inst_name: hmac
          default: ""
          top_signame: clkmgr_aon_idle
          index: 1
        }
        {
          name: tl
          struct: tl
          package: tlul_pkg
          type: req_rsp
          act: rsp
          width: 1
          inst_name: hmac
          default: ""
          end_idx: -1
          top_signame: hmac_tl
          index: -1
        }
      ]
      base_addrs:
      {
        null:
        {
          hart: 0x21110000
        }
      }
      generate_dif: true
      domain:
      [
        "0"
      ]
    }
    {
      name: kmac
      type: kmac
      param_decl:
      {
        EnMasking: "1"
        NumAppIntf: 4
        AppCfg:
          '''
          '{kmac_pkg::AppCfgKeyMgr,
                  kmac_pkg::AppCfgLcCtrl,
                  kmac_pkg::AppCfgRomCtrl,
                  kmac_pkg::AppCfgRomCtrl}
          '''
      }
      clock_srcs:
      {
        clk_i: main
        clk_edn_i: main
      }
      clock_group: trans
      reset_connections:
      {
        rst_ni:
        {
          name: lc
          domain: "0"
        }
        rst_edn_ni:
        {
          name: lc
          domain: "0"
        }
      }
      clock_connections:
      {
        clk_i: clkmgr_aon_clocks.clk_main_kmac
        clk_edn_i: clkmgr_aon_clocks.clk_main_kmac
      }
      memory: {}
      param_list:
      [
        {
          name: EnMasking
          desc: Disable(0) or enable(1) first-order masking of Keccak round.
          type: bit
          default: "1"
          local: "false"
          expose: "true"
          name_top: KmacEnMasking
        }
        {
          name: SwKeyMasked
          desc:
            '''
            Disable(0) or enable(1) software key masking in case masking is disabled (EnMasking == 0).
            If masking is enabled, this parameter has no effect.
            Mainly useful for software interface compatibility between the masked and unmasked design.
            Mostly relevant for SCA measurements.
            '''
          type: bit
          default: "0"
          local: "false"
          expose: "true"
          name_top: KmacSwKeyMasked
        }
        {
          name: SecCmdDelay
          desc:
            '''
            Command delay, useful for SCA measurements only.
            A value of e.g. 40 allows the processor to go into sleep before KMAC starts operation.
            If a value greater than 0 is chosen, software can pass two commands in series.
            The second command is buffered internally and will be presented to the hardware SecCmdDelay number of cycles after the first one.
            '''
          type: int
          default: "0"
          local: "false"
          expose: "true"
          name_top: SecKmacCmdDelay
        }
        {
          name: SecIdleAcceptSwMsg
          desc:
            '''
            If enabled (1), software writes to the message FIFO before having received a START command are not ignored.
            Disabled (0) by default.
            Useful for SCA measurements only.
            '''
          type: bit
          default: "0"
          local: "false"
          expose: "true"
          name_top: SecKmacIdleAcceptSwMsg
        }
        {
          name: NumAppIntf
          desc: Number of application interfaces
          type: int
          default: 4
          local: "false"
          expose: "true"
          name_top: KmacNumAppIntf
        }
        {
          name: AppCfg
          desc:
            '''
            Application interface configuration.
            Top-level connection to the application interface must follow this definition.
            '''
          type: kmac_pkg::app_config_t
          unpacked_dimensions: "[KmacNumAppIntf]"
          default:
            '''
            '{kmac_pkg::AppCfgKeyMgr,
                    kmac_pkg::AppCfgLcCtrl,
                    kmac_pkg::AppCfgRomCtrl,
                    kmac_pkg::AppCfgRomCtrl}
            '''
          local: "false"
          expose: "true"
          name_top: KmacAppCfg
        }
        {
          name: RndCnstLfsrSeed
          desc: Compile-time random data for PRNG default seed
          type: kmac_pkg::lfsr_seed_t
          randcount: 288
          randtype: data
          name_top: RndCnstKmacLfsrSeed
          default: 0x813c2b4c006e43bc22b155f9a5ba49b86b3c201409f20381b6ffcba3c838857079768444
          randwidth: 288
        }
        {
          name: RndCnstLfsrPerm
          desc: Compile-time random permutation for PRNG output
          type: kmac_pkg::lfsr_perm_t
          randcount: 800
          randtype: perm
          name_top: RndCnstKmacLfsrPerm
          default: 0xb8b04aad5251e951eaac21281068257eeb1066fa05c9b628e30e1cb3b8601de8c42007166c28e1b6b4a34899213ee69626992a4ce56c243402a86ad55505a8471a355369fe3e672ba225160bde87206d08dcdb427dbe26e982af6a564a9b1d7ac506956a136c58883c0515e638a5b5a0055edb8c13812467c015c18d56bd656a24e676d90089334b6ebbd23ac4a0b581ca1b9f584ce0a2c47178b9c522379afd0866a2387fc61a319aae5dd76680939f1bd36ca43fb089011c0315da1abc2deda9e127770cc8a20fa16de81287004fc27c6f1e4367385b94c71a29eaa0969786df9f8b217298c7165ba21b4e4020d46cb9f159ec3f5645527872650370c3115311f42a085e14d15c5473d85190ab79713361555fa0378cda4329bb66fb437101d4ca9c158071cc9cc7602c1e5ff026498271f172fd9a7fd912b6361444148ac104b0ca10fd17ed1b2506aa18681a3f4740f84173a7de78369c4d04c2997d979af93104b621e93adc3c9ad0e9286e219492b6af65288405390469690977c3d7596f68a141492c6c8e159903a947ca4dc3228263166d3ce9a284a27511974d4256a242d1a4994a87e9b1a7918749883511502b07762f62bc69ba84461d4b1144313eb99e5d9778c26d5d5604d73187e07d37a21678c4eaa8e292ab0b5a1255ac5db52ec0ec3291dc2a42f18311287ebe9be4298a49afd2e99951220111d2c7b8d9322c4e3894109e68062b20a6c333572c24980557125701184f1634ae9d4b09212b719e23b1e94d6c6a9d7b194fac19ae7da463be0e498942d49d20ac0240f93e2098947d7be2a48c534fe41ba5bf232439b13c8cadd01abb18afc401c0664f451703c7a929c4f66799d53c70acd0b4c4867f2b76844099d7453a4a1edf396e3c159c121ee475c042812906e500748357e94970809ac088b6ef9352f97e3d54f0f974096fb0d4c1482faf034a77861e036654bfce73ddee85a4b478dc394ff5b58b236fe512ce29c4a33c85161e47c61230e177c2c40f91091091525bcc2a155e5ab876b07424f3c1b40e4d13ae45a36553d563311073022b7b0ba8709aa46a08b0782c5ac04105038d6a5d98b990e726590b2d33a6f7aa93b4eaf37d016945b731ea18ccb6305fe69ddd7e2ad600c92f62037d179d0acad5754048fa3b1b5e9115b22ec167667df24c9b3120132eeee270812f02e1cdda46d3e7dcdd699b081d96248c88dcde1a0a3ae140714b863ef250c2db3d02b319ba5aca585709628fbe62f0a2c80c5d15f20125e80a880d44d95a9184632359e86b6e65752803258d398ea98146a6aa27c643310a02c5ab42ce0a12c2b51acbb5e9d5412a7e672b856e6eded985ba7123bb813d6a30e002cd0811a65c34482837f4ed32f1f45264588993a23943d83b96ed
          randwidth: 8000
        }
        {
          name: RndCnstBufferLfsrSeed
          desc: Compile-time random data for PRNG buffer default seed
          type: kmac_pkg::buffer_lfsr_seed_t
          randcount: 800
          randtype: data
          name_top: RndCnstKmacBufferLfsrSeed
          default: 0x3d1b23e5be54b9c0bf5b2dbd49ab2284a502186c26c4919624eb713bc42ae08eb2a09674c93f8c23868b585534b613e2828b0424f0f9eb900313dcddd6f8207b25a5b5b3f673ba36487d1ecaf61806ccc0803e75180ab65ee3eeeb76afebe2ee4702f603
          randwidth: 800
        }
        {
          name: RndCnstMsgPerm
          desc: Compile-time random permutation for LFSR Message output
          type: kmac_pkg::msg_perm_t
          randcount: 64
          randtype: perm
          name_top: RndCnstKmacMsgPerm
          default: 0x3eb027f1ab166fbbff8a085d67dd189514941382f15c68fa5470b67e621c4c3cb5dc1b45cc9339b8e36991efaa290a30
          randwidth: 384
        }
      ]
      inter_signal_list:
      [
        {
          name: keymgr_key
          struct: hw_key_req
          package: keymgr_pkg
          type: uni
          act: rcv
          width: 1
          inst_name: kmac
          default: ""
          top_signame: keymgr_dpe_kmac_key
          index: -1
        }
        {
          name: app
          struct: app
          package: kmac_pkg
          type: req_rsp
          act: rsp
          width:
          {
            name: NumAppIntf
            desc: Number of application interfaces
            param_type: int
            unpacked_dimensions: null
            default: 3
            local: false
            expose: true
            name_top: KmacNumAppIntf
          }
          inst_name: kmac
          default: ""
          end_idx: -1
          top_type: one-to-N
          top_signame: kmac_app
          index: -1
        }
        {
          name: entropy
          struct: edn
          package: edn_pkg
          type: req_rsp
          act: req
          width: 1
          inst_name: kmac
          default: ""
          top_signame: edn0_edn
          index: 3
        }
        {
          name: idle
          struct: mubi4
          package: prim_mubi_pkg
          type: uni
          act: req
          width: 1
          inst_name: kmac
          default: ""
          top_signame: clkmgr_aon_idle
          index: 2
        }
        {
          name: en_masking
          struct: logic
          type: uni
          act: req
          width: 1
          inst_name: kmac
          default: ""
          package: ""
          end_idx: -1
          top_type: broadcast
          top_signame: kmac_en_masking
          index: -1
        }
        {
          name: lc_escalate_en
          struct: lc_tx
          package: lc_ctrl_pkg
          type: uni
          act: rcv
          width: 1
          default: lc_ctrl_pkg::Off
          inst_name: kmac
          top_signame: lc_ctrl_lc_escalate_en
          index: -1
        }
        {
          name: tl
          struct: tl
          package: tlul_pkg
          type: req_rsp
          act: rsp
          width: 1
          inst_name: kmac
          default: ""
          end_idx: -1
          top_signame: kmac_tl
          index: -1
        }
      ]
      base_addrs:
      {
        null:
        {
          hart: 0x21120000
        }
      }
      generate_dif: true
      domain:
      [
        "0"
      ]
    }
    {
      name: otbn
      type: otbn
      clock_srcs:
      {
        clk_i:
        {
          clock: main
          group: trans
        }
        clk_edn_i:
        {
          clock: main
          group: secure
        }
        clk_otp_i:
        {
          clock: io_div4
          group: secure
        }
      }
      clock_group: trans
      reset_connections:
      {
        rst_ni:
        {
          name: lc
          domain: "0"
        }
        rst_edn_ni:
        {
          name: lc
          domain: "0"
        }
        rst_otp_ni:
        {
          name: lc_io_div4
          domain: "0"
        }
      }
      clock_connections:
      {
        clk_i: clkmgr_aon_clocks.clk_main_otbn
        clk_edn_i: clkmgr_aon_clocks.clk_main_secure
        clk_otp_i: clkmgr_aon_clocks.clk_io_div4_secure
      }
      param_decl: {}
      memory: {}
      param_list:
      [
        {
          name: Stub
          desc: Stub out the core of Otbn logic
          type: bit
          default: "0"
          local: "false"
          expose: "true"
          name_top: OtbnStub
        }
        {
          name: RegFile
          desc: Selection of the register file implementation. See otbn_pkg.sv.
          type: otbn_pkg::regfile_e
          default: otbn_pkg::RegFileFF
          local: "false"
          expose: "true"
          name_top: OtbnRegFile
        }
        {
          name: RndCnstUrndPrngSeed
          desc: Default seed of the PRNG used for URND.
          type: otbn_pkg::urnd_prng_seed_t
          randcount: 256
          randtype: data
          name_top: RndCnstOtbnUrndPrngSeed
          default: 0x42246b6c385a5aa3b4fe9c0a8d1f2128e03e0b01632e027e34c81340bcfd0fd5
          randwidth: 256
        }
        {
          name: SecMuteUrnd
          desc:
            '''
            If enabled (1), URND is advanced only when data is needed.
            Disabled (0) by default.
            Useful for SCA measurements only.
            '''
          type: bit
          default: "0"
          local: "false"
          expose: "true"
          name_top: SecOtbnMuteUrnd
        }
        {
          name: SecSkipUrndReseedAtStart
          desc:
            '''
            If enabled (1), URND reseed is skipped at the start of an operation.
            Disabled (0) by default.
            Useful for SCA measurements only.
            '''
          type: bit
          default: "0"
          local: "false"
          expose: "true"
          name_top: SecOtbnSkipUrndReseedAtStart
        }
        {
          name: RndCnstOtbnKey
          desc: Compile-time random reset value for IMem/DMem scrambling key.
          type: otp_ctrl_pkg::otbn_key_t
          randcount: 128
          randtype: data
          name_top: RndCnstOtbnOtbnKey
          default: 0x3473b5440b76763b45bca8166865fdaf
          randwidth: 128
        }
        {
          name: RndCnstOtbnNonce
          desc: Compile-time random reset value for IMem/DMem scrambling nonce.
          type: otp_ctrl_pkg::otbn_nonce_t
          randcount: 64
          randtype: data
          name_top: RndCnstOtbnOtbnNonce
          default: 0x59f386d5174cc7f5
          randwidth: 64
        }
      ]
      inter_signal_list:
      [
        {
          name: otbn_otp_key
          struct: otbn_otp_key
          package: otp_ctrl_pkg
          type: req_rsp
          act: req
          width: 1
          default: "'0"
          inst_name: otbn
          top_signame: otp_ctrl_otbn_otp_key
          index: -1
        }
        {
          name: edn_rnd
          struct: edn
          package: edn_pkg
          type: req_rsp
          act: req
          width: 1
          inst_name: otbn
          default: ""
          top_signame: edn1_edn
          index: 0
        }
        {
          name: edn_urnd
          struct: edn
          package: edn_pkg
          type: req_rsp
          act: req
          width: 1
          inst_name: otbn
          default: ""
          top_signame: edn0_edn
          index: 6
        }
        {
          name: idle
          struct: mubi4
          package: prim_mubi_pkg
          type: uni
          act: req
          width: 1
          inst_name: otbn
          default: ""
          top_signame: clkmgr_aon_idle
          index: 3
        }
        {
          name: ram_cfg_imem
          struct: ram_1p_cfg
          package: prim_ram_1p_pkg
          type: uni
          act: rcv
          width: 1
          inst_name: otbn
          default: ""
          external: true
          top_signame: otbn_imem_ram_1p_cfg
          conn_type: false
          index: -1
        }
        {
          name: ram_cfg_dmem
          struct: ram_1p_cfg
          package: prim_ram_1p_pkg
          type: uni
          act: rcv
          width: 1
          inst_name: otbn
          default: ""
          external: true
          top_signame: otbn_dmem_ram_1p_cfg
          conn_type: false
          index: -1
        }
        {
          name: ram_cfg_rsp_imem
          struct: ram_1p_cfg_rsp
          package: prim_ram_1p_pkg
          type: uni
          act: req
          width: 1
          inst_name: otbn
          default: ""
          external: true
          top_signame: otbn_imem_ram_1p_cfg_rsp
          conn_type: false
          index: -1
        }
        {
          name: ram_cfg_rsp_dmem
          struct: ram_1p_cfg_rsp
          package: prim_ram_1p_pkg
          type: uni
          act: req
          width: 1
          inst_name: otbn
          default: ""
          external: true
          top_signame: otbn_dmem_ram_1p_cfg_rsp
          conn_type: false
          index: -1
        }
        {
          name: lc_escalate_en
          struct: lc_tx
          package: lc_ctrl_pkg
          type: uni
          act: rcv
          width: 1
          default: lc_ctrl_pkg::Off
          inst_name: otbn
          top_signame: lc_ctrl_lc_escalate_en
          index: -1
        }
        {
          name: lc_rma_req
          struct: lc_tx
          package: lc_ctrl_pkg
          type: uni
          act: rcv
          width: 1
          default: lc_ctrl_pkg::Off
          inst_name: otbn
          top_signame: lc_ctrl_lc_flash_rma_req
          index: -1
        }
        {
          name: lc_rma_ack
          struct: lc_tx
          package: lc_ctrl_pkg
          type: uni
          act: req
          width: 1
          default: lc_ctrl_pkg::Off
          inst_name: otbn
          end_idx: -1
          top_type: broadcast
          top_signame: otbn_lc_rma_ack
          index: -1
        }
        {
          name: keymgr_key
          struct: otbn_key_req
          package: keymgr_pkg
          type: uni
          act: rcv
          width: 1
          inst_name: otbn
          default: ""
          top_signame: keymgr_dpe_otbn_key
          index: -1
        }
        {
          name: tl
          struct: tl
          package: tlul_pkg
          type: req_rsp
          act: rsp
          width: 1
          inst_name: otbn
          default: ""
          end_idx: -1
          top_signame: otbn_tl
          index: -1
        }
      ]
      base_addrs:
      {
        null:
        {
          hart: 0x21130000
        }
      }
      generate_dif: true
      domain:
      [
        "0"
      ]
    }
    {
      name: keymgr_dpe
      type: keymgr_dpe
      clock_srcs:
      {
        clk_i: main
        clk_edn_i: main
      }
      clock_group: secure
      reset_connections:
      {
        rst_ni:
        {
          name: lc
          domain: "0"
        }
        rst_edn_ni:
        {
          name: lc
          domain: "0"
        }
      }
      clock_connections:
      {
        clk_i: clkmgr_aon_clocks.clk_main_secure
        clk_edn_i: clkmgr_aon_clocks.clk_main_secure
      }
      param_decl: {}
      memory: {}
      param_list:
      [
        {
          name: KmacEnMasking
          desc: Flag indicating with kmac masking is enabled
          type: bit
          default: "1"
          local: "false"
          expose: "true"
          name_top: KeymgrDpeKmacEnMasking
        }
        {
          name: RndCnstLfsrSeed
          desc: Compile-time random bits for initial LFSR seed
          type: keymgr_pkg::lfsr_seed_t
          randcount: 64
          randtype: data
          name_top: RndCnstKeymgrDpeLfsrSeed
          default: 0xfd1f544b3a82c54e
          randwidth: 64
        }
        {
          name: RndCnstLfsrPerm
          desc: Compile-time random permutation for LFSR output
          type: keymgr_pkg::lfsr_perm_t
          randcount: 64
          randtype: perm
          name_top: RndCnstKeymgrDpeLfsrPerm
          default: 0xfb391f4f5b077b8a27f6e30998b09a57f362c391ab50ff2f4bb436c6dde929d5e303aa8ec846d69580742118590dc805
          randwidth: 384
        }
        {
          name: RndCnstRandPerm
          desc: Compile-time random permutation for entropy used in share overriding
          type: keymgr_pkg::rand_perm_t
          randcount: 32
          randtype: perm
          name_top: RndCnstKeymgrDpeRandPerm
          default: 0x27ee88eb0198f665f5e977a54142ace140acb4f6
          randwidth: 160
        }
        {
          name: RndCnstRevisionSeed
          desc: Compile-time random bits for revision seed
          type: keymgr_pkg::seed_t
          randcount: 256
          randtype: data
          name_top: RndCnstKeymgrDpeRevisionSeed
          default: 0xc1a496592784ac089e72877bdaf9f7954486164b58ea68f9b7f647cdafc1c9a9
          randwidth: 256
        }
        {
          name: RndCnstSoftOutputSeed
          desc: Compile-time random bits for software generation seed
          type: keymgr_pkg::seed_t
          randcount: 256
          randtype: data
          name_top: RndCnstKeymgrDpeSoftOutputSeed
          default: 0x5a7aa52efed17f8efa13e9543502f28c02c460aa8d2a575b899b4caae056cf2
          randwidth: 256
        }
        {
          name: RndCnstHardOutputSeed
          desc: Compile-time random bits for hardware generation seed
          type: keymgr_pkg::seed_t
          randcount: 256
          randtype: data
          name_top: RndCnstKeymgrDpeHardOutputSeed
          default: 0xb85353e1a33975e7b1209b868a4acd919ed9795d5f519aa8cd47ac68b65650a1
          randwidth: 256
        }
        {
          name: RndCnstAesSeed
          desc: Compile-time random bits for generation seed when aes destination selected
          type: keymgr_pkg::seed_t
          randcount: 256
          randtype: data
          name_top: RndCnstKeymgrDpeAesSeed
          default: 0xbb5a4a6dbf0bc7c1c7af8402bacd250ed8960c88b4b17ea9867b47ae9a95aaf9
          randwidth: 256
        }
        {
          name: RndCnstKmacSeed
          desc: Compile-time random bits for generation seed when kmac destination selected
          type: keymgr_pkg::seed_t
          randcount: 256
          randtype: data
          name_top: RndCnstKeymgrDpeKmacSeed
          default: 0x6dbe43a4472dc0c72f2488d40ccad7575333e5e48f00bbc1f91e5eea7ad029c2
          randwidth: 256
        }
        {
          name: RndCnstOtbnSeed
          desc: Compile-time random bits for generation seed when otbn destination selected
          type: keymgr_pkg::seed_t
          randcount: 256
          randtype: data
          name_top: RndCnstKeymgrDpeOtbnSeed
          default: 0x13141ee86e77b99bf0a1bcd67fb8941c331a44277bc08f711d2d33e72bc40a36
          randwidth: 256
        }
        {
          name: RndCnstNoneSeed
          desc: Compile-time random bits for generation seed when no destination selected
          type: keymgr_pkg::seed_t
          randcount: 256
          randtype: data
          name_top: RndCnstKeymgrDpeNoneSeed
          default: 0x399d8364dcd59508d525078e802f91d8583804fde71271f1738c1cac987a6b8a
          randwidth: 256
        }
      ]
      inter_signal_list:
      [
        {
          name: edn
          struct: edn
          package: edn_pkg
          type: req_rsp
          act: req
          width: 1
          inst_name: keymgr_dpe
          default: ""
          top_signame: edn0_edn
          index: 0
        }
        {
          name: aes_key
          struct: hw_key_req
          package: keymgr_pkg
          type: uni
          act: req
          width: 1
          inst_name: keymgr_dpe
          default: ""
          end_idx: -1
          top_type: broadcast
          top_signame: keymgr_dpe_aes_key
          index: -1
        }
        {
          name: kmac_key
          struct: hw_key_req
          package: keymgr_pkg
          type: uni
          act: req
          width: 1
          inst_name: keymgr_dpe
          default: ""
          end_idx: -1
          top_type: broadcast
          top_signame: keymgr_dpe_kmac_key
          index: -1
        }
        {
          name: otbn_key
          struct: otbn_key_req
          package: keymgr_pkg
          type: uni
          act: req
          width: 1
          inst_name: keymgr_dpe
          default: ""
          end_idx: -1
          top_type: broadcast
          top_signame: keymgr_dpe_otbn_key
          index: -1
        }
        {
          name: kmac_data
          struct: app
          package: kmac_pkg
          type: req_rsp
          act: req
          width: 1
          inst_name: keymgr_dpe
          default: ""
          top_signame: kmac_app
          index: 0
        }
        {
          name: otp_key
          struct: otp_keymgr_key
          package: otp_ctrl_pkg
          type: uni
          act: rcv
          width: 1
          inst_name: keymgr_dpe
          default: ""
          top_signame: otp_ctrl_otp_keymgr_key
          index: -1
        }
        {
          name: otp_device_id
          struct: otp_device_id
          package: otp_ctrl_pkg
          type: uni
          act: rcv
          width: 1
          inst_name: keymgr_dpe
          default: ""
          top_signame: keymgr_dpe_otp_device_id
          index: -1
        }
        {
          name: lc_keymgr_en
          struct: lc_tx
          package: lc_ctrl_pkg
          type: uni
          act: rcv
          width: 1
          default: lc_ctrl_pkg::On
          inst_name: keymgr_dpe
          top_signame: lc_ctrl_lc_keymgr_en
          index: -1
        }
        {
          name: lc_keymgr_div
          struct: lc_keymgr_div
          package: lc_ctrl_pkg
          type: uni
          act: rcv
          width: 1
          inst_name: keymgr_dpe
          default: ""
          top_signame: lc_ctrl_lc_keymgr_div
          index: -1
        }
        {
          name: rom_digest
          struct: keymgr_data
          package: rom_ctrl_pkg
          type: uni
          act: rcv
          width: 2
          default: rom_ctrl_pkg::KEYMGR_DATA_DEFAULT
          inst_name: keymgr_dpe
          end_idx: -1
          top_type: one-to-N
          top_signame: keymgr_dpe_rom_digest
          index: -1
        }
        {
          name: kmac_en_masking
          struct: logic
          type: uni
          act: rcv
          width: 1
          inst_name: keymgr_dpe
          default: ""
          package: ""
          top_signame: kmac_en_masking
          index: -1
        }
        {
          name: tl
          struct: tl
          package: tlul_pkg
          type: req_rsp
          act: rsp
          width: 1
          inst_name: keymgr_dpe
          default: ""
          end_idx: -1
          top_signame: keymgr_dpe_tl
          index: -1
        }
      ]
      base_addrs:
      {
        null:
        {
          hart: 0x21140000
        }
      }
      generate_dif: true
      domain:
      [
        "0"
      ]
    }
    {
      name: csrng
      type: csrng
      clock_srcs:
      {
        clk_i: main
      }
      clock_group: secure
      reset_connections:
      {
        rst_ni:
        {
          name: lc
          domain: "0"
        }
      }
      clock_connections:
      {
        clk_i: clkmgr_aon_clocks.clk_main_secure
      }
      param_decl: {}
      memory: {}
      param_list:
      [
        {
          name: RndCnstCsKeymgrDivNonProduction
          desc: Compile-time random bits for csrng state group diversification value
          type: csrng_pkg::cs_keymgr_div_t
          randcount: 384
          randtype: data
          name_top: RndCnstCsrngCsKeymgrDivNonProduction
          default: 0x7758b762216edd63070949c7834ab6ee6e7ad485ff3ca72c2242223ce6d70f17b4f4b32818aa49d125b4defb1f3c0be8
          randwidth: 384
        }
        {
          name: RndCnstCsKeymgrDivProduction
          desc: Compile-time random bits for csrng state group diversification value
          type: csrng_pkg::cs_keymgr_div_t
          randcount: 384
          randtype: data
          name_top: RndCnstCsrngCsKeymgrDivProduction
          default: 0xa29be065c26d23550bbc139ff6461763d7e966a8a7219eb2e8ef9f11a152e6c71aa23b8864416e750c01a3339c6c7aa1
          randwidth: 384
        }
        {
          name: SBoxImpl
          desc: Selection of the S-Box implementation. See aes_pkg.sv.
          type: aes_pkg::sbox_impl_e
          default: aes_pkg::SBoxImplCanright
          local: "false"
          expose: "true"
          name_top: CsrngSBoxImpl
        }
      ]
      inter_signal_list:
      [
        {
          name: csrng_cmd
          struct: csrng
          package: csrng_pkg
          type: req_rsp
          act: rsp
          width: 2
          inst_name: csrng
          default: ""
          end_idx: -1
          top_type: one-to-N
          top_signame: csrng_csrng_cmd
          index: -1
        }
        {
          name: entropy_src_hw_if
          struct: entropy_src_hw_if
          package: entropy_src_pkg
          type: req_rsp
          act: req
          width: 1
          inst_name: csrng
          default: ""
          external: true
          top_signame: entropy_src_hw_if
          conn_type: false
          index: -1
        }
        {
          name: cs_aes_halt
          desc:
            '''
            Coordinate activity between CSRNG's AES and Entropy Source's SHA3.
            When CSRNG gets a request and its AES is not active, it acknowledges and until the request has dropped neither runs its AES nor drops the acknowledge.
            '''
          struct: cs_aes_halt
          package: entropy_src_pkg
          type: req_rsp
          act: rsp
          width: 1
          inst_name: csrng
          index: -1
        }
        {
          name: otp_en_csrng_sw_app_read
          struct: mubi8
          package: prim_mubi_pkg
          type: uni
          act: rcv
          width: 1
          default: prim_mubi_pkg::MuBi8True
          inst_name: csrng
          index: -1
        }
        {
          name: lc_hw_debug_en
          struct: lc_tx
          package: lc_ctrl_pkg
          type: uni
          act: rcv
          width: 1
          default: lc_ctrl_pkg::Off
          inst_name: csrng
          top_signame: lc_ctrl_lc_hw_debug_en
          index: -1
        }
        {
          name: tl
          struct: tl
          package: tlul_pkg
          type: req_rsp
          act: rsp
          width: 1
          inst_name: csrng
          default: ""
          end_idx: -1
          top_signame: csrng_tl
          index: -1
        }
      ]
      base_addrs:
      {
        null:
        {
          hart: 0x21150000
        }
      }
      generate_dif: true
      domain:
      [
        "0"
      ]
    }
    {
      name: edn0
      type: edn
      clock_srcs:
      {
        clk_i: main
      }
      clock_group: secure
      reset_connections:
      {
        rst_ni:
        {
          name: lc
          domain: "0"
        }
      }
      clock_connections:
      {
        clk_i: clkmgr_aon_clocks.clk_main_secure
      }
      param_decl: {}
      param_list: []
      inter_signal_list:
      [
        {
          name: csrng_cmd
          desc: EDN supports a signal CSRNG application interface.
          struct: csrng
          package: csrng_pkg
          type: req_rsp
          act: req
          width: 1
          inst_name: edn0
          default: ""
          top_signame: csrng_csrng_cmd
          index: 0
        }
        {
          name: edn
          desc:
            '''
            The collection of peripheral ports supported by edn. The width (4)
            indicates the number of peripheral ports on a single instance.
            Due to limitations in the parametrization of top-level interconnects
            this value is not currently parameterizable.  However, the number
            of peripheral ports may change in a future revision.
            '''
          struct: edn
          package: edn_pkg
          type: req_rsp
          act: rsp
          width: 8
          default: "'0"
          inst_name: edn0
          end_idx: -1
          top_type: one-to-N
          top_signame: edn0_edn
          index: -1
        }
        {
          name: tl
          struct: tl
          package: tlul_pkg
          type: req_rsp
          act: rsp
          width: 1
          inst_name: edn0
          default: ""
          end_idx: -1
          top_signame: edn0_tl
          index: -1
        }
      ]
      base_addrs:
      {
        null:
        {
          hart: 0x21170000
        }
      }
      generate_dif: true
      domain:
      [
        "0"
      ]
    }
    {
      name: edn1
      type: edn
      clock_srcs:
      {
        clk_i: main
      }
      clock_group: secure
      reset_connections:
      {
        rst_ni:
        {
          name: lc
          domain: "0"
        }
      }
      clock_connections:
      {
        clk_i: clkmgr_aon_clocks.clk_main_secure
      }
      param_decl: {}
      param_list: []
      inter_signal_list:
      [
        {
          name: csrng_cmd
          desc: EDN supports a signal CSRNG application interface.
          struct: csrng
          package: csrng_pkg
          type: req_rsp
          act: req
          width: 1
          inst_name: edn1
          default: ""
          top_signame: csrng_csrng_cmd
          index: 1
        }
        {
          name: edn
          desc:
            '''
            The collection of peripheral ports supported by edn. The width (4)
            indicates the number of peripheral ports on a single instance.
            Due to limitations in the parametrization of top-level interconnects
            this value is not currently parameterizable.  However, the number
            of peripheral ports may change in a future revision.
            '''
          struct: edn
          package: edn_pkg
          type: req_rsp
          act: rsp
          width: 8
          default: "'0"
          inst_name: edn1
          end_idx: 1
          top_type: partial-one-to-N
          top_signame: edn1_edn
          index: -1
        }
        {
          name: tl
          struct: tl
          package: tlul_pkg
          type: req_rsp
          act: rsp
          width: 1
          inst_name: edn1
          default: ""
          end_idx: -1
          top_signame: edn1_tl
          index: -1
        }
      ]
      base_addrs:
      {
        null:
        {
          hart: 0x21180000
        }
      }
      generate_dif: true
      domain:
      [
        "0"
      ]
    }
    {
      name: sram_ctrl_main
      type: sram_ctrl
      clock_srcs:
      {
        clk_i: main
        clk_otp_i: io_div4
      }
      clock_group: infra
      reset_connections:
      {
        rst_ni:
        {
          name: lc
          domain: "0"
        }
        rst_otp_ni:
        {
          name: lc_io_div4
          domain: "0"
        }
      }
      param_decl:
      {
        InstrExec: "1"
        InstSize: 65536
      }
      base_addrs:
      {
        regs:
        {
          hart: 0x211c0000
        }
        ram:
        {
          hart: 0x10000000
        }
      }
      memory:
      {
        ram:
        {
          label: ram_main
          swaccess: rw
          data_intg_passthru: "true"
          exec: True
          byte_write: True
          size: 0x10000
        }
      }
      clock_connections:
      {
        clk_i: clkmgr_aon_clocks.clk_main_infra
        clk_otp_i: clkmgr_aon_clocks.clk_io_div4_infra
      }
      param_list:
      [
        {
          name: RndCnstSramKey
          desc: Compile-time random reset value for SRAM scrambling key.
          type: otp_ctrl_pkg::sram_key_t
          randcount: 128
          randtype: data
          name_top: RndCnstSramCtrlMainSramKey
          default: 0x1244ecd28a62cb1b851078c2a5f18eee
          randwidth: 128
        }
        {
          name: RndCnstSramNonce
          desc: Compile-time random reset value for SRAM scrambling nonce.
          type: otp_ctrl_pkg::sram_nonce_t
          randcount: 128
          randtype: data
          name_top: RndCnstSramCtrlMainSramNonce
          default: 0x28d0b562043b7312efad871f92e7527d
          randwidth: 128
        }
        {
          name: RndCnstLfsrSeed
          desc: Compile-time random bits for initial LFSR seed
          type: sram_ctrl_pkg::lfsr_seed_t
          randcount: 32
          randtype: data
          name_top: RndCnstSramCtrlMainLfsrSeed
          default: 0xa865d661
          randwidth: 32
        }
        {
          name: RndCnstLfsrPerm
          desc: Compile-time random permutation for LFSR output
          type: sram_ctrl_pkg::lfsr_perm_t
          randcount: 32
          randtype: perm
          name_top: RndCnstSramCtrlMainLfsrPerm
          default: 0x9839bf5c89ae64a439947e1763402269ffa8f465
          randwidth: 160
        }
        {
          name: MemSizeRam
          desc: Memory size of the RAM (in bytes).
          type: int
          name_top: MemSizeSramCtrlMainRam
          default: 65536
        }
        {
          name: InstSize
          desc: Memory size of a single RAM tile (in bytes).
          type: int
          default: 65536
          local: "false"
          expose: "true"
          name_top: SramCtrlMainInstSize
        }
        {
          name: NumRamInst
          desc: Number of internal RAM instances. Must be the same as ceil(MemSizeRam / InstSize) .
          type: int
          default: 1
          local: "false"
          expose: "true"
          name_top: SramCtrlMainNumRamInst
        }
        {
          name: InstrExec
          desc: Support execution from SRAM
          type: bit
          default: "1"
          local: "false"
          expose: "true"
          name_top: SramCtrlMainInstrExec
        }
        {
          name: NumPrinceRoundsHalf
          desc: Number of PRINCE half rounds for the SRAM scrambling feature
          type: int
          default: "3"
          local: "false"
          expose: "true"
          name_top: SramCtrlMainNumPrinceRoundsHalf
        }
        {
          name: Outstanding
          desc: Number of outstanding TLUL transactions
          type: int
          default: "2"
          local: "true"
          expose: "true"
          name_top: SramCtrlMainOutstanding
        }
        {
          name: EccCorrection
          desc: Enable single-bit error correction and error logging
          type: bit
          default: "0"
          local: "false"
          expose: "true"
          name_top: SramCtrlMainEccCorrection
        }
      ]
      inter_signal_list:
      [
        {
          name: sram_otp_key
          struct: sram_otp_key
          package: otp_ctrl_pkg
          type: req_rsp
          act: req
          width: 1
          inst_name: sram_ctrl_main
          default: ""
          top_signame: otp_ctrl_sram_otp_key
          index: 0
        }
        {
          name: cfg
          struct: ram_1p_cfg
          package: prim_ram_1p_pkg
          type: uni
          act: rcv
          width:
          {
            name: NumRamInst
            desc: Number of internal RAM instances. Must be the same as ceil(MemSizeRam / InstSize) .
            param_type: int
            unpacked_dimensions: null
            default: 1
            local: false
            expose: true
            name_top: SramCtrlMainNumRamInst
          }
          default: "'0"
          inst_name: sram_ctrl_main
          external: true
          top_signame: sram_ctrl_main_ram_1p_cfg
          conn_type: false
          index: -1
        }
        {
          name: cfg_rsp
          struct: ram_1p_cfg_rsp
          package: prim_ram_1p_pkg
          type: uni
          act: req
          width:
          {
            name: NumRamInst
            desc: Number of internal RAM instances. Must be the same as ceil(MemSizeRam / InstSize) .
            param_type: int
            unpacked_dimensions: null
            default: 1
            local: false
            expose: true
            name_top: SramCtrlMainNumRamInst
          }
          default: "'0"
          inst_name: sram_ctrl_main
          external: true
          top_signame: sram_ctrl_main_ram_1p_cfg_rsp
          conn_type: false
          index: -1
        }
        {
          name: lc_escalate_en
          struct: lc_tx
          package: lc_ctrl_pkg
          type: uni
          act: rcv
          width: 1
          default: lc_ctrl_pkg::Off
          inst_name: sram_ctrl_main
          top_signame: lc_ctrl_lc_escalate_en
          index: -1
        }
        {
          name: lc_hw_debug_en
          struct: lc_tx
          package: lc_ctrl_pkg
          type: uni
          act: rcv
          width: 1
          default: lc_ctrl_pkg::Off
          inst_name: sram_ctrl_main
          top_signame: lc_ctrl_lc_hw_debug_en
          index: -1
        }
        {
          name: otp_en_sram_ifetch
          struct: mubi8
          package: prim_mubi_pkg
          type: uni
          act: rcv
          width: 1
          default: prim_mubi_pkg::MuBi8False
          inst_name: sram_ctrl_main
          top_signame: sram_ctrl_main_otp_en_sram_ifetch
          index: -1
        }
        {
          name: racl_policies
          desc:
            '''
            Incoming RACL policy vector from a racl_ctrl instance.
            The policy selection vector (parameter) selects the policy for each register.
            '''
          struct: racl_policy_vec
          package: top_racl_pkg
          type: uni
          act: rcv
          width: 1
          inst_name: sram_ctrl_main
          index: -1
        }
        {
          name: racl_error
          desc: RACL error log information of this module.
          struct: racl_error_log
          package: top_racl_pkg
          type: uni
          act: req
          width: 1
          inst_name: sram_ctrl_main
          index: -1
        }
        {
          name: sram_rerror
          desc: SRAM read error indicating correctable and uncorrectable ECC errors.
          struct: sram_error_t
          package: sram_ctrl_pkg
          type: uni
          act: req
          width: 1
          inst_name: sram_ctrl_main
          index: -1
        }
        {
          name: regs_tl
          struct: tl
          package: tlul_pkg
          type: req_rsp
          act: rsp
          width: 1
          inst_name: sram_ctrl_main
          default: ""
          end_idx: -1
          top_signame: sram_ctrl_main_regs_tl
          index: -1
        }
        {
          name: ram_tl
          struct: tl
          package: tlul_pkg
          type: req_rsp
          act: rsp
          width: 1
          inst_name: sram_ctrl_main
          default: ""
          end_idx: -1
          top_signame: sram_ctrl_main_ram_tl
          index: -1
        }
      ]
      generate_dif: true
      domain:
      [
        "0"
      ]
    }
    {
      name: sram_ctrl_mbox
      type: sram_ctrl
      clock_srcs:
      {
        clk_i: main
        clk_otp_i: io_div4
      }
      clock_group: infra
      reset_connections:
      {
        rst_ni:
        {
          name: lc
          domain: "0"
        }
        rst_otp_ni:
        {
          name: lc_io_div4
          domain: "0"
        }
      }
      param_decl:
      {
        InstrExec: "0"
        InstSize: 4096
      }
      base_addrs:
      {
        regs:
        {
          hart: 0x211d0000
        }
        ram:
        {
          hart: 0x11000000
        }
      }
      memory:
      {
        ram:
        {
          label: ram_mbox
          swaccess: rw
          data_intg_passthru: "true"
          exec: False
          byte_write: True
          size: 0x1000
        }
      }
      clock_connections:
      {
        clk_i: clkmgr_aon_clocks.clk_main_infra
        clk_otp_i: clkmgr_aon_clocks.clk_io_div4_infra
      }
      param_list:
      [
        {
          name: RndCnstSramKey
          desc: Compile-time random reset value for SRAM scrambling key.
          type: otp_ctrl_pkg::sram_key_t
          randcount: 128
          randtype: data
          name_top: RndCnstSramCtrlMboxSramKey
          default: 0x4d7194e4707ada81f8a6db14ca845bee
          randwidth: 128
        }
        {
          name: RndCnstSramNonce
          desc: Compile-time random reset value for SRAM scrambling nonce.
          type: otp_ctrl_pkg::sram_nonce_t
          randcount: 128
          randtype: data
          name_top: RndCnstSramCtrlMboxSramNonce
          default: 0xe60798289ad4fb0df176829639015270
          randwidth: 128
        }
        {
          name: RndCnstLfsrSeed
          desc: Compile-time random bits for initial LFSR seed
          type: sram_ctrl_pkg::lfsr_seed_t
          randcount: 32
          randtype: data
          name_top: RndCnstSramCtrlMboxLfsrSeed
          default: 0xe078ec5
          randwidth: 32
        }
        {
          name: RndCnstLfsrPerm
          desc: Compile-time random permutation for LFSR output
          type: sram_ctrl_pkg::lfsr_perm_t
          randcount: 32
          randtype: perm
          name_top: RndCnstSramCtrlMboxLfsrPerm
          default: 0x662343bd21bcc1ce8fc8d1a4d77e0b16cb925955
          randwidth: 160
        }
        {
          name: MemSizeRam
          desc: Memory size of the RAM (in bytes).
          type: int
          name_top: MemSizeSramCtrlMboxRam
          default: 4096
        }
        {
          name: InstSize
          desc: Memory size of a single RAM tile (in bytes).
          type: int
          default: 4096
          local: "false"
          expose: "true"
          name_top: SramCtrlMboxInstSize
        }
        {
          name: NumRamInst
          desc: Number of internal RAM instances. Must be the same as ceil(MemSizeRam / InstSize) .
          type: int
          default: 1
          local: "false"
          expose: "true"
          name_top: SramCtrlMboxNumRamInst
        }
        {
          name: InstrExec
          desc: Support execution from SRAM
          type: bit
          default: "0"
          local: "false"
          expose: "true"
          name_top: SramCtrlMboxInstrExec
        }
        {
          name: NumPrinceRoundsHalf
          desc: Number of PRINCE half rounds for the SRAM scrambling feature
          type: int
          default: "3"
          local: "false"
          expose: "true"
          name_top: SramCtrlMboxNumPrinceRoundsHalf
        }
        {
          name: Outstanding
          desc: Number of outstanding TLUL transactions
          type: int
          default: "2"
          local: "true"
          expose: "true"
          name_top: SramCtrlMboxOutstanding
        }
        {
          name: EccCorrection
          desc: Enable single-bit error correction and error logging
          type: bit
          default: "0"
          local: "false"
          expose: "true"
          name_top: SramCtrlMboxEccCorrection
        }
      ]
      inter_signal_list:
      [
        {
          name: sram_otp_key
          struct: sram_otp_key
          package: otp_ctrl_pkg
          type: req_rsp
          act: req
          width: 1
          inst_name: sram_ctrl_mbox
          default: ""
          top_signame: otp_ctrl_sram_otp_key
          index: 2
        }
        {
          name: cfg
          struct: ram_1p_cfg
          package: prim_ram_1p_pkg
          type: uni
          act: rcv
          width:
          {
            name: NumRamInst
            desc: Number of internal RAM instances. Must be the same as ceil(MemSizeRam / InstSize) .
            param_type: int
            unpacked_dimensions: null
            default: 1
            local: false
            expose: true
            name_top: SramCtrlMboxNumRamInst
          }
          default: "'0"
          inst_name: sram_ctrl_mbox
          external: true
          top_signame: sram_ctrl_mbox_ram_1p_cfg
          conn_type: false
          index: -1
        }
        {
          name: cfg_rsp
          struct: ram_1p_cfg_rsp
          package: prim_ram_1p_pkg
          type: uni
          act: req
          width:
          {
            name: NumRamInst
            desc: Number of internal RAM instances. Must be the same as ceil(MemSizeRam / InstSize) .
            param_type: int
            unpacked_dimensions: null
            default: 1
            local: false
            expose: true
            name_top: SramCtrlMboxNumRamInst
          }
          default: "'0"
          inst_name: sram_ctrl_mbox
          external: true
          top_signame: sram_ctrl_mbox_ram_1p_cfg_rsp
          conn_type: false
          index: -1
        }
        {
          name: lc_escalate_en
          struct: lc_tx
          package: lc_ctrl_pkg
          type: uni
          act: rcv
          width: 1
          default: lc_ctrl_pkg::Off
          inst_name: sram_ctrl_mbox
          top_signame: lc_ctrl_lc_escalate_en
          index: -1
        }
        {
          name: lc_hw_debug_en
          struct: lc_tx
          package: lc_ctrl_pkg
          type: uni
          act: rcv
          width: 1
          default: lc_ctrl_pkg::Off
          inst_name: sram_ctrl_mbox
          index: -1
        }
        {
          name: otp_en_sram_ifetch
          struct: mubi8
          package: prim_mubi_pkg
          type: uni
          act: rcv
          width: 1
          default: prim_mubi_pkg::MuBi8False
          inst_name: sram_ctrl_mbox
          index: -1
        }
        {
          name: racl_policies
          desc:
            '''
            Incoming RACL policy vector from a racl_ctrl instance.
            The policy selection vector (parameter) selects the policy for each register.
            '''
          struct: racl_policy_vec
          package: top_racl_pkg
          type: uni
          act: rcv
          width: 1
          inst_name: sram_ctrl_mbox
          index: -1
        }
        {
          name: racl_error
          desc: RACL error log information of this module.
          struct: racl_error_log
          package: top_racl_pkg
          type: uni
          act: req
          width: 1
          inst_name: sram_ctrl_mbox
          index: -1
        }
        {
          name: sram_rerror
          desc: SRAM read error indicating correctable and uncorrectable ECC errors.
          struct: sram_error_t
          package: sram_ctrl_pkg
          type: uni
          act: req
          width: 1
          inst_name: sram_ctrl_mbox
          index: -1
        }
        {
          name: regs_tl
          struct: tl
          package: tlul_pkg
          type: req_rsp
          act: rsp
          width: 1
          inst_name: sram_ctrl_mbox
          default: ""
          end_idx: -1
          top_signame: sram_ctrl_mbox_regs_tl
          index: -1
        }
        {
          name: ram_tl
          struct: tl
          package: tlul_pkg
          type: req_rsp
          act: rsp
          width: 1
          inst_name: sram_ctrl_mbox
          default: ""
          end_idx: -1
          top_signame: sram_ctrl_mbox_ram_tl
          index: -1
        }
      ]
      generate_dif: true
      domain:
      [
        "0"
      ]
    }
    {
      name: rom_ctrl0
      type: rom_ctrl
      clock_srcs:
      {
        clk_i: main
      }
      clock_group: infra
      reset_connections:
      {
        rst_ni:
        {
          name: lc
          domain: "0"
        }
      }
      base_addrs:
      {
        rom:
        {
          hart: 0x00008000
        }
        regs:
        {
          hart: 0x211e0000
        }
      }
      memory:
      {
        rom:
        {
          label: rom0
          swaccess: ro
          data_intg_passthru: True
          exec: True
          byte_write: False
          size: 0x8000
        }
      }
      param_decl:
      {
        SecDisableScrambling: 1'b0
      }
      clock_connections:
      {
        clk_i: clkmgr_aon_clocks.clk_main_infra
      }
      param_list:
      [
        {
          name: BootRomInitFile
          desc: Contents of ROM
          type: ""
          default: '''""'''
          local: "false"
          expose: "true"
          name_top: RomCtrl0BootRomInitFile
        }
        {
          name: RndCnstScrNonce
          desc: Fixed nonce used for address / data scrambling
          type: bit [63:0]
          randcount: 64
          randtype: data
          name_top: RndCnstRomCtrl0ScrNonce
          default: 0x2704f5e21287fa16
          randwidth: 64
        }
        {
          name: RndCnstScrKey
          desc: Randomised constant used as a scrambling key for ROM data
          type: bit [127:0]
          randcount: 128
          randtype: data
          name_top: RndCnstRomCtrl0ScrKey
          default: 0x8af251b370d034cda605152662f4d11b
          randwidth: 128
        }
        {
          name: SecDisableScrambling
          desc:
            '''
            Disable scrambling and checking in rom_ctrl, turning the block into a
            simple ROM wrapper. This isn't intended for real chips, but is useful
            for small FPGA targets where there's not space for the PRINCE
            primitives.
            '''
          type: bit
          default: 1'b0
          local: "false"
          expose: "true"
          name_top: SecRomCtrl0DisableScrambling
        }
        {
          name: MemSizeRom
          desc: Memory size of the ROM (in bytes).
          type: int
          name_top: MemSizeRomCtrl0Rom
          default: 32768
        }
      ]
      inter_signal_list:
      [
        {
          name: rom_cfg
          struct: rom_cfg
          package: prim_rom_pkg
          type: uni
          act: rcv
          width: 1
          inst_name: rom_ctrl0
          default: ""
          external: true
          top_signame: rom_ctrl0_cfg
          conn_type: false
          index: -1
        }
        {
          name: pwrmgr_data
          struct: pwrmgr_data
          package: rom_ctrl_pkg
          type: uni
          act: req
          width: 1
          inst_name: rom_ctrl0
          default: ""
          top_signame: pwrmgr_aon_rom_ctrl
          index: 0
        }
        {
          name: keymgr_data
          struct: keymgr_data
          package: rom_ctrl_pkg
          type: uni
          act: req
          width: 1
          inst_name: rom_ctrl0
          default: ""
          top_signame: keymgr_dpe_rom_digest
          index: 0
        }
        {
          name: kmac_data
          struct: app
          package: kmac_pkg
          type: req_rsp
          act: req
          width: 1
          inst_name: rom_ctrl0
          default: ""
          top_signame: kmac_app
          index: 2
        }
        {
          name: regs_tl
          struct: tl
          package: tlul_pkg
          type: req_rsp
          act: rsp
          width: 1
          inst_name: rom_ctrl0
          default: ""
          end_idx: -1
          top_signame: rom_ctrl0_regs_tl
          index: -1
        }
        {
          name: rom_tl
          struct: tl
          package: tlul_pkg
          type: req_rsp
          act: rsp
          width: 1
          inst_name: rom_ctrl0
          default: ""
          end_idx: -1
          top_signame: rom_ctrl0_rom_tl
          index: -1
        }
      ]
      generate_dif: true
      domain:
      [
        "0"
      ]
    }
    {
      name: rom_ctrl1
      type: rom_ctrl
      clock_srcs:
      {
        clk_i: main
      }
      clock_group: infra
      reset_connections:
      {
        rst_ni:
        {
          name: lc
          domain: "0"
        }
      }
      base_addrs:
      {
        rom:
        {
          hart: 0x00020000
        }
        regs:
        {
          hart: 0x211e1000
        }
      }
      memory:
      {
        rom:
        {
          label: rom1
          swaccess: ro
          data_intg_passthru: True
          exec: True
          byte_write: False
          size: 0x10000
        }
      }
      param_decl:
      {
        SecDisableScrambling: 1'b0
      }
      clock_connections:
      {
        clk_i: clkmgr_aon_clocks.clk_main_infra
      }
      param_list:
      [
        {
          name: BootRomInitFile
          desc: Contents of ROM
          type: ""
          default: '''""'''
          local: "false"
          expose: "true"
          name_top: RomCtrl1BootRomInitFile
        }
        {
          name: RndCnstScrNonce
          desc: Fixed nonce used for address / data scrambling
          type: bit [63:0]
          randcount: 64
          randtype: data
          name_top: RndCnstRomCtrl1ScrNonce
          default: 0x3245d5943ea5fd2e
          randwidth: 64
        }
        {
          name: RndCnstScrKey
          desc: Randomised constant used as a scrambling key for ROM data
          type: bit [127:0]
          randcount: 128
          randtype: data
          name_top: RndCnstRomCtrl1ScrKey
          default: 0x4bea016b7911deaf01df742547371445
          randwidth: 128
        }
        {
          name: SecDisableScrambling
          desc:
            '''
            Disable scrambling and checking in rom_ctrl, turning the block into a
            simple ROM wrapper. This isn't intended for real chips, but is useful
            for small FPGA targets where there's not space for the PRINCE
            primitives.
            '''
          type: bit
          default: 1'b0
          local: "false"
          expose: "true"
          name_top: SecRomCtrl1DisableScrambling
        }
        {
          name: MemSizeRom
          desc: Memory size of the ROM (in bytes).
          type: int
          name_top: MemSizeRomCtrl1Rom
          default: 65536
        }
      ]
      inter_signal_list:
      [
        {
          name: rom_cfg
          struct: rom_cfg
          package: prim_rom_pkg
          type: uni
          act: rcv
          width: 1
          inst_name: rom_ctrl1
          default: ""
          external: true
          top_signame: rom_ctrl1_cfg
          conn_type: false
          index: -1
        }
        {
          name: pwrmgr_data
          struct: pwrmgr_data
          package: rom_ctrl_pkg
          type: uni
          act: req
          width: 1
          inst_name: rom_ctrl1
          default: ""
          top_signame: pwrmgr_aon_rom_ctrl
          index: 1
        }
        {
          name: keymgr_data
          struct: keymgr_data
          package: rom_ctrl_pkg
          type: uni
          act: req
          width: 1
          inst_name: rom_ctrl1
          default: ""
          top_signame: keymgr_dpe_rom_digest
          index: 1
        }
        {
          name: kmac_data
          struct: app
          package: kmac_pkg
          type: req_rsp
          act: req
          width: 1
          inst_name: rom_ctrl1
          default: ""
          top_signame: kmac_app
          index: 3
        }
        {
          name: regs_tl
          struct: tl
          package: tlul_pkg
          type: req_rsp
          act: rsp
          width: 1
          inst_name: rom_ctrl1
          default: ""
          end_idx: -1
          top_signame: rom_ctrl1_regs_tl
          index: -1
        }
        {
          name: rom_tl
          struct: tl
          package: tlul_pkg
          type: req_rsp
          act: rsp
          width: 1
          inst_name: rom_ctrl1
          default: ""
          end_idx: -1
          top_signame: rom_ctrl1_rom_tl
          index: -1
        }
      ]
      generate_dif: true
      domain:
      [
        "0"
      ]
    }
    {
      name: dma
      type: dma
      clock_srcs:
      {
        clk_i: main
      }
      clock_group: infra
      reset_connections:
      {
        rst_ni:
        {
          name: lc
          domain: "0"
        }
      }
      clock_connections:
      {
        clk_i: clkmgr_aon_clocks.clk_main_infra
      }
      param_decl: {}
      memory: {}
      param_list:
      [
        {
          name: EnableDataIntgGen
          desc: Compute integrity bits for A channel data on all TL-UL host ports
          type: bit
          default: 1'b1
          local: "false"
          expose: "true"
          name_top: DmaEnableDataIntgGen
        }
        {
          name: EnableRspDataIntgCheck
          desc: Enable integrity checks on the response TL-UL D channel
          type: bit
          default: 1'b1
          local: "false"
          expose: "true"
          name_top: DmaEnableRspDataIntgCheck
        }
        {
          name: TlUserRsvd
          desc: Value of `rsvd` field in A channel of all TL-UL host ports
          type: logic [tlul_pkg::RsvdWidth-1:0]
          default: "'0"
          local: "false"
          expose: "true"
          name_top: DmaTlUserRsvd
        }
        {
          name: SysRacl
          desc: Value of `racl_vec` field in `sys` output
          type: logic [dma_pkg::SYS_RACL_WIDTH-1:0]
          default: "'0"
          local: "false"
          expose: "true"
          name_top: DmaSysRacl
        }
        {
          name: OtAgentId
          desc: OT Agent ID
          type: int unsigned
          default: "0"
          local: "false"
          expose: "true"
          name_top: DmaOtAgentId
        }
      ]
      inter_signal_list:
      [
        {
          name: lsio_trigger
          struct: lsio_trigger
          package: dma_pkg
          type: uni
          act: rcv
          width: 1
          inst_name: dma
          default: ""
          end_idx: -1
          top_type: broadcast
          top_signame: dma_lsio_trigger
          index: -1
        }
        {
          name: sys
          struct: sys
          package: dma_pkg
          type: req_rsp
          act: req
          width: 1
          inst_name: dma
          default: ""
          external: true
          top_signame: dma_sys
          conn_type: false
          index: -1
        }
        {
          name: ctn_tl_h2d
          desc: TL-UL host port for egress into CTN (request part), synchronous
          struct: tl_h2d
          package: tlul_pkg
          type: uni
          act: req
          width: 1
          inst_name: dma
          default: ""
          top_signame: soc_proxy_dma_tl_h2d
          index: -1
        }
        {
          name: ctn_tl_d2h
          desc: TL-UL host port for egress into CTN (response part), synchronous
          struct: tl_d2h
          package: tlul_pkg
          type: uni
          act: rcv
          width: 1
          inst_name: dma
          default: ""
          top_signame: soc_proxy_dma_tl_d2h
          index: -1
        }
        {
          name: racl_policies
          desc:
            '''
            Incoming RACL policy vector from a racl_ctrl instance.
            The policy selection vector (parameter) selects the policy for each register.
            '''
          struct: racl_policy_vec
          package: top_racl_pkg
          type: uni
          act: rcv
          width: 1
          inst_name: dma
          index: -1
        }
        {
          name: racl_error
          desc: RACL error log information of this module.
          struct: racl_error_log
          package: top_racl_pkg
          type: uni
          act: req
          width: 1
          inst_name: dma
          index: -1
        }
        {
          name: host_tl_h
          struct: tl
          package: tlul_pkg
          type: req_rsp
          act: req
          width: 1
          inst_name: dma
          default: ""
          top_signame: main_tl_dma__host
          index: -1
        }
        {
          name: tl_d
          struct: tl
          package: tlul_pkg
          type: req_rsp
          act: rsp
          width: 1
          inst_name: dma
          default: ""
          end_idx: -1
          top_signame: dma_tl_d
          index: -1
        }
      ]
      base_addrs:
      {
        null:
        {
          hart: 0x22010000
        }
      }
      generate_dif: true
      domain:
      [
        "0"
      ]
    }
    {
      name: mbx0
      type: mbx
      clock_srcs:
      {
        clk_i: main
      }
      clock_group: infra
      reset_connections:
      {
        rst_ni:
        {
          name: lc
          domain: "0"
        }
      }
      base_addrs:
      {
        core:
        {
          hart: 0x22000000
        }
        soc:
        {
          soc_mbx: 0x01465000
        }
      }
      racl_mappings:
      {
        soc:
        {
          racl_group: Null
          register_mapping:
          {
            SOC_CONTROL: 0
            SOC_STATUS: 0
            SOC_DOE_INTR_MSG_ADDR: 0
            SOC_DOE_INTR_MSG_DATA: 0
          }
          window_mapping:
          {
            WDATA: 0
            RDATA: 0
          }
          range_mapping: []
        }
      }
      clock_connections:
      {
        clk_i: clkmgr_aon_clocks.clk_main_infra
      }
      param_decl: {}
      param_list: []
      inter_signal_list:
      [
        {
          name: doe_intr_support
          struct: logic
          type: uni
          act: req
          width: 1
          default: 1'b0
          inst_name: mbx0
          package: ""
          external: true
          top_signame: mbx0_doe_intr_support
          conn_type: false
          index: -1
        }
        {
          name: doe_intr_en
          struct: logic
          type: uni
          act: req
          width: 1
          default: 1'b0
          inst_name: mbx0
          package: ""
          external: true
          top_signame: mbx0_doe_intr_en
          conn_type: false
          index: -1
        }
        {
          name: doe_intr
          struct: logic
          type: uni
          act: req
          width: 1
          default: 1'b0
          inst_name: mbx0
          package: ""
          external: true
          top_signame: mbx0_doe_intr
          conn_type: false
          index: -1
        }
        {
          name: doe_async_msg_support
          struct: logic
          type: uni
          act: req
          width: 1
          default: 1'b0
          inst_name: mbx0
          package: ""
          external: true
          top_signame: mbx0_doe_async_msg_support
          conn_type: false
          index: -1
        }
        {
          name: racl_policies
          desc:
            '''
            Incoming RACL policy vector from a racl_ctrl instance.
            The policy selection vector (parameter) selects the policy for each register.
            '''
          struct: racl_policy_vec
          package: top_racl_pkg
          type: uni
          act: rcv
          width: 1
          inst_name: mbx0
          default: ""
          top_signame: racl_ctrl_racl_policies
          index: -1
        }
        {
          name: racl_error
          desc: RACL error log information of this module.
          struct: racl_error_log
          package: top_racl_pkg
          type: uni
          act: req
          width: 1
          inst_name: mbx0
          default: ""
          top_signame: racl_ctrl_racl_error
          index: 0
        }
        {
          name: sram_tl_h
          struct: tl
          package: tlul_pkg
          type: req_rsp
          act: req
          width: 1
          inst_name: mbx0
          default: ""
          top_signame: main_tl_mbx0__sram
          index: -1
        }
        {
          name: core_tl_d
          struct: tl
          package: tlul_pkg
          type: req_rsp
          act: rsp
          width: 1
          inst_name: mbx0
          default: ""
          end_idx: -1
          top_signame: mbx0_core_tl_d
          index: -1
        }
        {
          name: soc_tl_d
          struct: tl
          package: tlul_pkg
          type: req_rsp
          act: rsp
          width: 1
          inst_name: mbx0
          default: ""
          end_idx: -1
          top_signame: mbx0_soc_tl_d
          index: -1
        }
      ]
      generate_dif: true
      domain:
      [
        "0"
      ]
    }
    {
      name: mbx1
      type: mbx
      clock_srcs:
      {
        clk_i: main
      }
      clock_group: infra
      reset_connections:
      {
        rst_ni:
        {
          name: lc
          domain: "0"
        }
      }
      base_addrs:
      {
        core:
        {
          hart: 0x22000100
        }
        soc:
        {
          soc_mbx: 0x01465100
        }
      }
      racl_mappings:
      {
        soc:
        {
          racl_group: Null
          register_mapping:
          {
            SOC_CONTROL: 0
            SOC_STATUS: 0
            SOC_DOE_INTR_MSG_ADDR: 0
            SOC_DOE_INTR_MSG_DATA: 0
          }
          window_mapping:
          {
            WDATA: 0
            RDATA: 0
          }
          range_mapping: []
        }
      }
      clock_connections:
      {
        clk_i: clkmgr_aon_clocks.clk_main_infra
      }
      param_decl: {}
      param_list: []
      inter_signal_list:
      [
        {
          name: doe_intr_support
          struct: logic
          type: uni
          act: req
          width: 1
          default: 1'b0
          inst_name: mbx1
          package: ""
          external: true
          top_signame: mbx1_doe_intr_support
          conn_type: false
          index: -1
        }
        {
          name: doe_intr_en
          struct: logic
          type: uni
          act: req
          width: 1
          default: 1'b0
          inst_name: mbx1
          package: ""
          external: true
          top_signame: mbx1_doe_intr_en
          conn_type: false
          index: -1
        }
        {
          name: doe_intr
          struct: logic
          type: uni
          act: req
          width: 1
          default: 1'b0
          inst_name: mbx1
          package: ""
          external: true
          top_signame: mbx1_doe_intr
          conn_type: false
          index: -1
        }
        {
          name: doe_async_msg_support
          struct: logic
          type: uni
          act: req
          width: 1
          default: 1'b0
          inst_name: mbx1
          package: ""
          external: true
          top_signame: mbx1_doe_async_msg_support
          conn_type: false
          index: -1
        }
        {
          name: racl_policies
          desc:
            '''
            Incoming RACL policy vector from a racl_ctrl instance.
            The policy selection vector (parameter) selects the policy for each register.
            '''
          struct: racl_policy_vec
          package: top_racl_pkg
          type: uni
          act: rcv
          width: 1
          inst_name: mbx1
          default: ""
          top_signame: racl_ctrl_racl_policies
          index: -1
        }
        {
          name: racl_error
          desc: RACL error log information of this module.
          struct: racl_error_log
          package: top_racl_pkg
          type: uni
          act: req
          width: 1
          inst_name: mbx1
          default: ""
          top_signame: racl_ctrl_racl_error
          index: 1
        }
        {
          name: sram_tl_h
          struct: tl
          package: tlul_pkg
          type: req_rsp
          act: req
          width: 1
          inst_name: mbx1
          default: ""
          top_signame: main_tl_mbx1__sram
          index: -1
        }
        {
          name: core_tl_d
          struct: tl
          package: tlul_pkg
          type: req_rsp
          act: rsp
          width: 1
          inst_name: mbx1
          default: ""
          end_idx: -1
          top_signame: mbx1_core_tl_d
          index: -1
        }
        {
          name: soc_tl_d
          struct: tl
          package: tlul_pkg
          type: req_rsp
          act: rsp
          width: 1
          inst_name: mbx1
          default: ""
          end_idx: -1
          top_signame: mbx1_soc_tl_d
          index: -1
        }
      ]
      generate_dif: true
      domain:
      [
        "0"
      ]
    }
    {
      name: mbx2
      type: mbx
      clock_srcs:
      {
        clk_i: main
      }
      clock_group: infra
      reset_connections:
      {
        rst_ni:
        {
          name: lc
          domain: "0"
        }
      }
      base_addrs:
      {
        core:
        {
          hart: 0x22000200
        }
        soc:
        {
          soc_mbx: 0x01465200
        }
      }
      racl_mappings:
      {
        soc:
        {
          racl_group: Null
          register_mapping:
          {
            SOC_CONTROL: 0
            SOC_STATUS: 0
            SOC_DOE_INTR_MSG_ADDR: 0
            SOC_DOE_INTR_MSG_DATA: 0
          }
          window_mapping:
          {
            WDATA: 0
            RDATA: 0
          }
          range_mapping: []
        }
      }
      clock_connections:
      {
        clk_i: clkmgr_aon_clocks.clk_main_infra
      }
      param_decl: {}
      param_list: []
      inter_signal_list:
      [
        {
          name: doe_intr_support
          struct: logic
          type: uni
          act: req
          width: 1
          default: 1'b0
          inst_name: mbx2
          package: ""
          external: true
          top_signame: mbx2_doe_intr_support
          conn_type: false
          index: -1
        }
        {
          name: doe_intr_en
          struct: logic
          type: uni
          act: req
          width: 1
          default: 1'b0
          inst_name: mbx2
          package: ""
          external: true
          top_signame: mbx2_doe_intr_en
          conn_type: false
          index: -1
        }
        {
          name: doe_intr
          struct: logic
          type: uni
          act: req
          width: 1
          default: 1'b0
          inst_name: mbx2
          package: ""
          external: true
          top_signame: mbx2_doe_intr
          conn_type: false
          index: -1
        }
        {
          name: doe_async_msg_support
          struct: logic
          type: uni
          act: req
          width: 1
          default: 1'b0
          inst_name: mbx2
          package: ""
          external: true
          top_signame: mbx2_doe_async_msg_support
          conn_type: false
          index: -1
        }
        {
          name: racl_policies
          desc:
            '''
            Incoming RACL policy vector from a racl_ctrl instance.
            The policy selection vector (parameter) selects the policy for each register.
            '''
          struct: racl_policy_vec
          package: top_racl_pkg
          type: uni
          act: rcv
          width: 1
          inst_name: mbx2
          default: ""
          top_signame: racl_ctrl_racl_policies
          index: -1
        }
        {
          name: racl_error
          desc: RACL error log information of this module.
          struct: racl_error_log
          package: top_racl_pkg
          type: uni
          act: req
          width: 1
          inst_name: mbx2
          default: ""
          top_signame: racl_ctrl_racl_error
          index: 2
        }
        {
          name: sram_tl_h
          struct: tl
          package: tlul_pkg
          type: req_rsp
          act: req
          width: 1
          inst_name: mbx2
          default: ""
          top_signame: main_tl_mbx2__sram
          index: -1
        }
        {
          name: core_tl_d
          struct: tl
          package: tlul_pkg
          type: req_rsp
          act: rsp
          width: 1
          inst_name: mbx2
          default: ""
          end_idx: -1
          top_signame: mbx2_core_tl_d
          index: -1
        }
        {
          name: soc_tl_d
          struct: tl
          package: tlul_pkg
          type: req_rsp
          act: rsp
          width: 1
          inst_name: mbx2
          default: ""
          end_idx: -1
          top_signame: mbx2_soc_tl_d
          index: -1
        }
      ]
      generate_dif: true
      domain:
      [
        "0"
      ]
    }
    {
      name: mbx3
      type: mbx
      clock_srcs:
      {
        clk_i: main
      }
      clock_group: infra
      reset_connections:
      {
        rst_ni:
        {
          name: lc
          domain: "0"
        }
      }
      base_addrs:
      {
        core:
        {
          hart: 0x22000300
        }
        soc:
        {
          soc_mbx: 0x01465300
        }
      }
      racl_mappings:
      {
        soc:
        {
          racl_group: Null
          register_mapping:
          {
            SOC_CONTROL: 0
            SOC_STATUS: 0
            SOC_DOE_INTR_MSG_ADDR: 0
            SOC_DOE_INTR_MSG_DATA: 0
          }
          window_mapping:
          {
            WDATA: 0
            RDATA: 0
          }
          range_mapping: []
        }
      }
      clock_connections:
      {
        clk_i: clkmgr_aon_clocks.clk_main_infra
      }
      param_decl: {}
      param_list: []
      inter_signal_list:
      [
        {
          name: doe_intr_support
          struct: logic
          type: uni
          act: req
          width: 1
          default: 1'b0
          inst_name: mbx3
          package: ""
          external: true
          top_signame: mbx3_doe_intr_support
          conn_type: false
          index: -1
        }
        {
          name: doe_intr_en
          struct: logic
          type: uni
          act: req
          width: 1
          default: 1'b0
          inst_name: mbx3
          package: ""
          external: true
          top_signame: mbx3_doe_intr_en
          conn_type: false
          index: -1
        }
        {
          name: doe_intr
          struct: logic
          type: uni
          act: req
          width: 1
          default: 1'b0
          inst_name: mbx3
          package: ""
          external: true
          top_signame: mbx3_doe_intr
          conn_type: false
          index: -1
        }
        {
          name: doe_async_msg_support
          struct: logic
          type: uni
          act: req
          width: 1
          default: 1'b0
          inst_name: mbx3
          package: ""
          external: true
          top_signame: mbx3_doe_async_msg_support
          conn_type: false
          index: -1
        }
        {
          name: racl_policies
          desc:
            '''
            Incoming RACL policy vector from a racl_ctrl instance.
            The policy selection vector (parameter) selects the policy for each register.
            '''
          struct: racl_policy_vec
          package: top_racl_pkg
          type: uni
          act: rcv
          width: 1
          inst_name: mbx3
          default: ""
          top_signame: racl_ctrl_racl_policies
          index: -1
        }
        {
          name: racl_error
          desc: RACL error log information of this module.
          struct: racl_error_log
          package: top_racl_pkg
          type: uni
          act: req
          width: 1
          inst_name: mbx3
          default: ""
          top_signame: racl_ctrl_racl_error
          index: 3
        }
        {
          name: sram_tl_h
          struct: tl
          package: tlul_pkg
          type: req_rsp
          act: req
          width: 1
          inst_name: mbx3
          default: ""
          top_signame: main_tl_mbx3__sram
          index: -1
        }
        {
          name: core_tl_d
          struct: tl
          package: tlul_pkg
          type: req_rsp
          act: rsp
          width: 1
          inst_name: mbx3
          default: ""
          end_idx: -1
          top_signame: mbx3_core_tl_d
          index: -1
        }
        {
          name: soc_tl_d
          struct: tl
          package: tlul_pkg
          type: req_rsp
          act: rsp
          width: 1
          inst_name: mbx3
          default: ""
          end_idx: -1
          top_signame: mbx3_soc_tl_d
          index: -1
        }
      ]
      generate_dif: true
      domain:
      [
        "0"
      ]
    }
    {
      name: mbx4
      type: mbx
      clock_srcs:
      {
        clk_i: main
      }
      clock_group: infra
      reset_connections:
      {
        rst_ni:
        {
          name: lc
          domain: "0"
        }
      }
      base_addrs:
      {
        core:
        {
          hart: 0x22000400
        }
        soc:
        {
          soc_mbx: 0x01465400
        }
      }
      racl_mappings:
      {
        soc:
        {
          racl_group: Null
          register_mapping:
          {
            SOC_CONTROL: 0
            SOC_STATUS: 0
            SOC_DOE_INTR_MSG_ADDR: 0
            SOC_DOE_INTR_MSG_DATA: 0
          }
          window_mapping:
          {
            WDATA: 0
            RDATA: 0
          }
          range_mapping: []
        }
      }
      clock_connections:
      {
        clk_i: clkmgr_aon_clocks.clk_main_infra
      }
      param_decl: {}
      param_list: []
      inter_signal_list:
      [
        {
          name: doe_intr_support
          struct: logic
          type: uni
          act: req
          width: 1
          default: 1'b0
          inst_name: mbx4
          package: ""
          external: true
          top_signame: mbx4_doe_intr_support
          conn_type: false
          index: -1
        }
        {
          name: doe_intr_en
          struct: logic
          type: uni
          act: req
          width: 1
          default: 1'b0
          inst_name: mbx4
          package: ""
          external: true
          top_signame: mbx4_doe_intr_en
          conn_type: false
          index: -1
        }
        {
          name: doe_intr
          struct: logic
          type: uni
          act: req
          width: 1
          default: 1'b0
          inst_name: mbx4
          package: ""
          external: true
          top_signame: mbx4_doe_intr
          conn_type: false
          index: -1
        }
        {
          name: doe_async_msg_support
          struct: logic
          type: uni
          act: req
          width: 1
          default: 1'b0
          inst_name: mbx4
          package: ""
          external: true
          top_signame: mbx4_doe_async_msg_support
          conn_type: false
          index: -1
        }
        {
          name: racl_policies
          desc:
            '''
            Incoming RACL policy vector from a racl_ctrl instance.
            The policy selection vector (parameter) selects the policy for each register.
            '''
          struct: racl_policy_vec
          package: top_racl_pkg
          type: uni
          act: rcv
          width: 1
          inst_name: mbx4
          default: ""
          top_signame: racl_ctrl_racl_policies
          index: -1
        }
        {
          name: racl_error
          desc: RACL error log information of this module.
          struct: racl_error_log
          package: top_racl_pkg
          type: uni
          act: req
          width: 1
          inst_name: mbx4
          default: ""
          top_signame: racl_ctrl_racl_error
          index: 4
        }
        {
          name: sram_tl_h
          struct: tl
          package: tlul_pkg
          type: req_rsp
          act: req
          width: 1
          inst_name: mbx4
          default: ""
          top_signame: main_tl_mbx4__sram
          index: -1
        }
        {
          name: core_tl_d
          struct: tl
          package: tlul_pkg
          type: req_rsp
          act: rsp
          width: 1
          inst_name: mbx4
          default: ""
          end_idx: -1
          top_signame: mbx4_core_tl_d
          index: -1
        }
        {
          name: soc_tl_d
          struct: tl
          package: tlul_pkg
          type: req_rsp
          act: rsp
          width: 1
          inst_name: mbx4
          default: ""
          end_idx: -1
          top_signame: mbx4_soc_tl_d
          index: -1
        }
      ]
      generate_dif: true
      domain:
      [
        "0"
      ]
    }
    {
      name: mbx5
      type: mbx
      clock_srcs:
      {
        clk_i: main
      }
      clock_group: infra
      reset_connections:
      {
        rst_ni:
        {
          name: lc
          domain: "0"
        }
      }
      base_addrs:
      {
        core:
        {
          hart: 0x22000500
        }
        soc:
        {
          soc_mbx: 0x01465500
        }
      }
      racl_mappings:
      {
        soc:
        {
          racl_group: Null
          register_mapping:
          {
            SOC_CONTROL: 0
            SOC_STATUS: 0
            SOC_DOE_INTR_MSG_ADDR: 0
            SOC_DOE_INTR_MSG_DATA: 0
          }
          window_mapping:
          {
            WDATA: 0
            RDATA: 0
          }
          range_mapping: []
        }
      }
      clock_connections:
      {
        clk_i: clkmgr_aon_clocks.clk_main_infra
      }
      param_decl: {}
      param_list: []
      inter_signal_list:
      [
        {
          name: doe_intr_support
          struct: logic
          type: uni
          act: req
          width: 1
          default: 1'b0
          inst_name: mbx5
          package: ""
          external: true
          top_signame: mbx5_doe_intr_support
          conn_type: false
          index: -1
        }
        {
          name: doe_intr_en
          struct: logic
          type: uni
          act: req
          width: 1
          default: 1'b0
          inst_name: mbx5
          package: ""
          external: true
          top_signame: mbx5_doe_intr_en
          conn_type: false
          index: -1
        }
        {
          name: doe_intr
          struct: logic
          type: uni
          act: req
          width: 1
          default: 1'b0
          inst_name: mbx5
          package: ""
          external: true
          top_signame: mbx5_doe_intr
          conn_type: false
          index: -1
        }
        {
          name: doe_async_msg_support
          struct: logic
          type: uni
          act: req
          width: 1
          default: 1'b0
          inst_name: mbx5
          package: ""
          external: true
          top_signame: mbx5_doe_async_msg_support
          conn_type: false
          index: -1
        }
        {
          name: racl_policies
          desc:
            '''
            Incoming RACL policy vector from a racl_ctrl instance.
            The policy selection vector (parameter) selects the policy for each register.
            '''
          struct: racl_policy_vec
          package: top_racl_pkg
          type: uni
          act: rcv
          width: 1
          inst_name: mbx5
          default: ""
          top_signame: racl_ctrl_racl_policies
          index: -1
        }
        {
          name: racl_error
          desc: RACL error log information of this module.
          struct: racl_error_log
          package: top_racl_pkg
          type: uni
          act: req
          width: 1
          inst_name: mbx5
          default: ""
          top_signame: racl_ctrl_racl_error
          index: 5
        }
        {
          name: sram_tl_h
          struct: tl
          package: tlul_pkg
          type: req_rsp
          act: req
          width: 1
          inst_name: mbx5
          default: ""
          top_signame: main_tl_mbx5__sram
          index: -1
        }
        {
          name: core_tl_d
          struct: tl
          package: tlul_pkg
          type: req_rsp
          act: rsp
          width: 1
          inst_name: mbx5
          default: ""
          end_idx: -1
          top_signame: mbx5_core_tl_d
          index: -1
        }
        {
          name: soc_tl_d
          struct: tl
          package: tlul_pkg
          type: req_rsp
          act: rsp
          width: 1
          inst_name: mbx5
          default: ""
          end_idx: -1
          top_signame: mbx5_soc_tl_d
          index: -1
        }
      ]
      generate_dif: true
      domain:
      [
        "0"
      ]
    }
    {
      name: mbx6
      type: mbx
      clock_srcs:
      {
        clk_i: main
      }
      clock_group: infra
      reset_connections:
      {
        rst_ni:
        {
          name: lc
          domain: "0"
        }
      }
      base_addrs:
      {
        core:
        {
          hart: 0x22000600
        }
        soc:
        {
          soc_mbx: 0x01496000
        }
      }
      racl_mappings:
      {
        soc:
        {
          racl_group: Null
          register_mapping:
          {
            SOC_CONTROL: 0
            SOC_STATUS: 0
            SOC_DOE_INTR_MSG_ADDR: 0
            SOC_DOE_INTR_MSG_DATA: 0
          }
          window_mapping:
          {
            WDATA: 0
            RDATA: 0
          }
          range_mapping: []
        }
      }
      clock_connections:
      {
        clk_i: clkmgr_aon_clocks.clk_main_infra
      }
      param_decl: {}
      param_list: []
      inter_signal_list:
      [
        {
          name: doe_intr_support
          struct: logic
          type: uni
          act: req
          width: 1
          default: 1'b0
          inst_name: mbx6
          package: ""
          external: true
          top_signame: mbx6_doe_intr_support
          conn_type: false
          index: -1
        }
        {
          name: doe_intr_en
          struct: logic
          type: uni
          act: req
          width: 1
          default: 1'b0
          inst_name: mbx6
          package: ""
          external: true
          top_signame: mbx6_doe_intr_en
          conn_type: false
          index: -1
        }
        {
          name: doe_intr
          struct: logic
          type: uni
          act: req
          width: 1
          default: 1'b0
          inst_name: mbx6
          package: ""
          external: true
          top_signame: mbx6_doe_intr
          conn_type: false
          index: -1
        }
        {
          name: doe_async_msg_support
          struct: logic
          type: uni
          act: req
          width: 1
          default: 1'b0
          inst_name: mbx6
          package: ""
          external: true
          top_signame: mbx6_doe_async_msg_support
          conn_type: false
          index: -1
        }
        {
          name: racl_policies
          desc:
            '''
            Incoming RACL policy vector from a racl_ctrl instance.
            The policy selection vector (parameter) selects the policy for each register.
            '''
          struct: racl_policy_vec
          package: top_racl_pkg
          type: uni
          act: rcv
          width: 1
          inst_name: mbx6
          default: ""
          top_signame: racl_ctrl_racl_policies
          index: -1
        }
        {
          name: racl_error
          desc: RACL error log information of this module.
          struct: racl_error_log
          package: top_racl_pkg
          type: uni
          act: req
          width: 1
          inst_name: mbx6
          default: ""
          top_signame: racl_ctrl_racl_error
          index: 6
        }
        {
          name: sram_tl_h
          struct: tl
          package: tlul_pkg
          type: req_rsp
          act: req
          width: 1
          inst_name: mbx6
          default: ""
          top_signame: main_tl_mbx6__sram
          index: -1
        }
        {
          name: core_tl_d
          struct: tl
          package: tlul_pkg
          type: req_rsp
          act: rsp
          width: 1
          inst_name: mbx6
          default: ""
          end_idx: -1
          top_signame: mbx6_core_tl_d
          index: -1
        }
        {
          name: soc_tl_d
          struct: tl
          package: tlul_pkg
          type: req_rsp
          act: rsp
          width: 1
          inst_name: mbx6
          default: ""
          end_idx: -1
          top_signame: mbx6_soc_tl_d
          index: -1
        }
      ]
      generate_dif: true
      domain:
      [
        "0"
      ]
    }
    {
      name: mbx_jtag
      type: mbx
      clock_srcs:
      {
        clk_i: main
      }
      clock_group: infra
      reset_connections:
      {
        rst_ni:
        {
          name: lc
          domain: "0"
        }
      }
      base_addrs:
      {
        core:
        {
          hart: 0x22000800
        }
        soc:
        {
          soc_dbg: 0x2200
        }
      }
      racl_mappings:
      {
        soc:
        {
          racl_group: Null
          register_mapping:
          {
            SOC_CONTROL: 0
            SOC_STATUS: 0
            SOC_DOE_INTR_MSG_ADDR: 0
            SOC_DOE_INTR_MSG_DATA: 0
          }
          window_mapping:
          {
            WDATA: 0
            RDATA: 0
          }
          range_mapping: []
        }
      }
      clock_connections:
      {
        clk_i: clkmgr_aon_clocks.clk_main_infra
      }
      param_decl: {}
      param_list: []
      inter_signal_list:
      [
        {
          name: doe_intr_support
          struct: logic
          type: uni
          act: req
          width: 1
          default: 1'b0
          inst_name: mbx_jtag
          package: ""
          external: true
          top_signame: mbx_jtag_doe_intr_support
          conn_type: false
          index: -1
        }
        {
          name: doe_intr_en
          struct: logic
          type: uni
          act: req
          width: 1
          default: 1'b0
          inst_name: mbx_jtag
          package: ""
          external: true
          top_signame: mbx_jtag_doe_intr_en
          conn_type: false
          index: -1
        }
        {
          name: doe_intr
          struct: logic
          type: uni
          act: req
          width: 1
          default: 1'b0
          inst_name: mbx_jtag
          package: ""
          external: true
          top_signame: mbx_jtag_doe_intr
          conn_type: false
          index: -1
        }
        {
          name: doe_async_msg_support
          struct: logic
          type: uni
          act: req
          width: 1
          default: 1'b0
          inst_name: mbx_jtag
          package: ""
          external: true
          top_signame: mbx_jtag_doe_async_msg_support
          conn_type: false
          index: -1
        }
        {
          name: racl_policies
          desc:
            '''
            Incoming RACL policy vector from a racl_ctrl instance.
            The policy selection vector (parameter) selects the policy for each register.
            '''
          struct: racl_policy_vec
          package: top_racl_pkg
          type: uni
          act: rcv
          width: 1
          inst_name: mbx_jtag
          default: ""
          top_signame: racl_ctrl_racl_policies
          index: -1
        }
        {
          name: racl_error
          desc: RACL error log information of this module.
          struct: racl_error_log
          package: top_racl_pkg
          type: uni
          act: req
          width: 1
          inst_name: mbx_jtag
          default: ""
          top_signame: racl_ctrl_racl_error
          index: 7
        }
        {
          name: sram_tl_h
          struct: tl
          package: tlul_pkg
          type: req_rsp
          act: req
          width: 1
          inst_name: mbx_jtag
          default: ""
          top_signame: main_tl_mbx_jtag__sram
          index: -1
        }
        {
          name: core_tl_d
          struct: tl
          package: tlul_pkg
          type: req_rsp
          act: rsp
          width: 1
          inst_name: mbx_jtag
          default: ""
          end_idx: -1
          top_signame: mbx_jtag_core_tl_d
          index: -1
        }
        {
          name: soc_tl_d
          struct: tl
          package: tlul_pkg
          type: req_rsp
          act: rsp
          width: 1
          inst_name: mbx_jtag
          default: ""
          end_idx: -1
          top_signame: mbx_jtag_soc_tl_d
          index: -1
        }
      ]
      generate_dif: true
      domain:
      [
        "0"
      ]
    }
    {
      name: mbx_pcie0
      type: mbx
      clock_srcs:
      {
        clk_i: main
      }
      clock_group: infra
      reset_connections:
      {
        rst_ni:
        {
          name: lc
          domain: "0"
        }
      }
      base_addrs:
      {
        core:
        {
          hart: 0x22040000
        }
        soc:
        {
          soc_mbx: 0x01460100
        }
      }
      racl_mappings:
      {
        soc:
        {
          racl_group: Null
          register_mapping:
          {
            SOC_CONTROL: 2
            SOC_STATUS: 2
            SOC_DOE_INTR_MSG_ADDR: 2
            SOC_DOE_INTR_MSG_DATA: 2
          }
          window_mapping:
          {
            WDATA: 2
            RDATA: 2
          }
          range_mapping: []
        }
      }
      clock_connections:
      {
        clk_i: clkmgr_aon_clocks.clk_main_infra
      }
      param_decl: {}
      param_list: []
      inter_signal_list:
      [
        {
          name: doe_intr_support
          struct: logic
          type: uni
          act: req
          width: 1
          default: 1'b0
          inst_name: mbx_pcie0
          package: ""
          external: true
          top_signame: mbx_pcie0_doe_intr_support
          conn_type: false
          index: -1
        }
        {
          name: doe_intr_en
          struct: logic
          type: uni
          act: req
          width: 1
          default: 1'b0
          inst_name: mbx_pcie0
          package: ""
          external: true
          top_signame: mbx_pcie0_doe_intr_en
          conn_type: false
          index: -1
        }
        {
          name: doe_intr
          struct: logic
          type: uni
          act: req
          width: 1
          default: 1'b0
          inst_name: mbx_pcie0
          package: ""
          external: true
          top_signame: mbx_pcie0_doe_intr
          conn_type: false
          index: -1
        }
        {
          name: doe_async_msg_support
          struct: logic
          type: uni
          act: req
          width: 1
          default: 1'b0
          inst_name: mbx_pcie0
          package: ""
          external: true
          top_signame: mbx_pcie0_doe_async_msg_support
          conn_type: false
          index: -1
        }
        {
          name: racl_policies
          desc:
            '''
            Incoming RACL policy vector from a racl_ctrl instance.
            The policy selection vector (parameter) selects the policy for each register.
            '''
          struct: racl_policy_vec
          package: top_racl_pkg
          type: uni
          act: rcv
          width: 1
          inst_name: mbx_pcie0
          default: ""
          top_signame: racl_ctrl_racl_policies
          index: -1
        }
        {
          name: racl_error
          desc: RACL error log information of this module.
          struct: racl_error_log
          package: top_racl_pkg
          type: uni
          act: req
          width: 1
          inst_name: mbx_pcie0
          default: ""
          top_signame: racl_ctrl_racl_error
          index: 8
        }
        {
          name: sram_tl_h
          struct: tl
          package: tlul_pkg
          type: req_rsp
          act: req
          width: 1
          inst_name: mbx_pcie0
          default: ""
          top_signame: main_tl_mbx_pcie0__sram
          index: -1
        }
        {
          name: core_tl_d
          struct: tl
          package: tlul_pkg
          type: req_rsp
          act: rsp
          width: 1
          inst_name: mbx_pcie0
          default: ""
          end_idx: -1
          top_signame: mbx_pcie0_core_tl_d
          index: -1
        }
        {
          name: soc_tl_d
          struct: tl
          package: tlul_pkg
          type: req_rsp
          act: rsp
          width: 1
          inst_name: mbx_pcie0
          default: ""
          end_idx: -1
          top_signame: mbx_pcie0_soc_tl_d
          index: -1
        }
      ]
      generate_dif: true
      domain:
      [
        "0"
      ]
    }
    {
      name: mbx_pcie1
      type: mbx
      clock_srcs:
      {
        clk_i: main
      }
      clock_group: infra
      reset_connections:
      {
        rst_ni:
        {
          name: lc
          domain: "0"
        }
      }
      base_addrs:
      {
        core:
        {
          hart: 0x22040100
        }
        soc:
        {
          soc_mbx: 0x01460200
        }
      }
      racl_mappings:
      {
        soc:
        {
          racl_group: Null
          register_mapping:
          {
            SOC_CONTROL: 2
            SOC_STATUS: 2
            SOC_DOE_INTR_MSG_ADDR: 2
            SOC_DOE_INTR_MSG_DATA: 2
          }
          window_mapping:
          {
            WDATA: 2
            RDATA: 2
          }
          range_mapping: []
        }
      }
      clock_connections:
      {
        clk_i: clkmgr_aon_clocks.clk_main_infra
      }
      param_decl: {}
      param_list: []
      inter_signal_list:
      [
        {
          name: doe_intr_support
          struct: logic
          type: uni
          act: req
          width: 1
          default: 1'b0
          inst_name: mbx_pcie1
          package: ""
          external: true
          top_signame: mbx_pcie1_doe_intr_support
          conn_type: false
          index: -1
        }
        {
          name: doe_intr_en
          struct: logic
          type: uni
          act: req
          width: 1
          default: 1'b0
          inst_name: mbx_pcie1
          package: ""
          external: true
          top_signame: mbx_pcie1_doe_intr_en
          conn_type: false
          index: -1
        }
        {
          name: doe_intr
          struct: logic
          type: uni
          act: req
          width: 1
          default: 1'b0
          inst_name: mbx_pcie1
          package: ""
          external: true
          top_signame: mbx_pcie1_doe_intr
          conn_type: false
          index: -1
        }
        {
          name: doe_async_msg_support
          struct: logic
          type: uni
          act: req
          width: 1
          default: 1'b0
          inst_name: mbx_pcie1
          package: ""
          external: true
          top_signame: mbx_pcie1_doe_async_msg_support
          conn_type: false
          index: -1
        }
        {
          name: racl_policies
          desc:
            '''
            Incoming RACL policy vector from a racl_ctrl instance.
            The policy selection vector (parameter) selects the policy for each register.
            '''
          struct: racl_policy_vec
          package: top_racl_pkg
          type: uni
          act: rcv
          width: 1
          inst_name: mbx_pcie1
          default: ""
          top_signame: racl_ctrl_racl_policies
          index: -1
        }
        {
          name: racl_error
          desc: RACL error log information of this module.
          struct: racl_error_log
          package: top_racl_pkg
          type: uni
          act: req
          width: 1
          inst_name: mbx_pcie1
          default: ""
          top_signame: racl_ctrl_racl_error
          index: 9
        }
        {
          name: sram_tl_h
          struct: tl
          package: tlul_pkg
          type: req_rsp
          act: req
          width: 1
          inst_name: mbx_pcie1
          default: ""
          top_signame: main_tl_mbx_pcie1__sram
          index: -1
        }
        {
          name: core_tl_d
          struct: tl
          package: tlul_pkg
          type: req_rsp
          act: rsp
          width: 1
          inst_name: mbx_pcie1
          default: ""
          end_idx: -1
          top_signame: mbx_pcie1_core_tl_d
          index: -1
        }
        {
          name: soc_tl_d
          struct: tl
          package: tlul_pkg
          type: req_rsp
          act: rsp
          width: 1
          inst_name: mbx_pcie1
          default: ""
          end_idx: -1
          top_signame: mbx_pcie1_soc_tl_d
          index: -1
        }
      ]
      generate_dif: true
      domain:
      [
        "0"
      ]
    }
    {
      name: soc_dbg_ctrl
      type: soc_dbg_ctrl
      clock_srcs:
      {
        clk_i: io_div4
      }
      clock_group: secure
      reset_connections:
      {
        rst_ni:
        {
          name: lc_io_div4
          domain: "0"
        }
      }
      base_addrs:
      {
        core:
        {
          hart: 0x30170000
        }
        jtag:
        {
          soc_dbg: 0x2300
        }
      }
      clock_connections:
      {
        clk_i: clkmgr_aon_clocks.clk_io_div4_secure
      }
      param_decl: {}
      param_list: []
      inter_signal_list:
      [
        {
          name: boot_status
          struct: pwr_boot_status
          package: pwrmgr_pkg
          type: uni
          act: rcv
          width: 1
          inst_name: soc_dbg_ctrl
          default: ""
          top_signame: pwrmgr_aon_boot_status
          index: -1
        }
        {
          name: soc_dbg_state
          struct: soc_dbg_state
          package: lc_ctrl_state_pkg
          type: uni
          act: rcv
          width: 1
          inst_name: soc_dbg_ctrl
          default: ""
          top_signame: soc_dbg_ctrl_soc_dbg_state
          index: -1
        }
        {
          name: soc_dbg_policy_bus
          struct: soc_dbg_policy
          package: soc_dbg_ctrl_pkg
          type: uni
          act: req
          width: 1
          inst_name: soc_dbg_ctrl
          default: ""
          external: true
          top_signame: soc_dbg_policy_bus
          conn_type: false
          index: -1
        }
        {
          name: lc_hw_debug_en
          desc: Multibit life cycle hardware debug enable signal coming from life cycle controller, asserted when the hardware debug mechanisms are enabled in the system.
          struct: lc_tx
          package: lc_ctrl_pkg
          type: uni
          act: rcv
          width: 1
          default: lc_ctrl_pkg::Off
          inst_name: soc_dbg_ctrl
          top_signame: lc_ctrl_lc_hw_debug_en
          index: -1
        }
        {
          name: lc_dft_en
          desc:
            '''
            Test enable qualifier coming from life cycle controller.
            This signals enables TEST & RMA mode accesses.
            '''
          struct: lc_tx
          package: lc_ctrl_pkg
          type: uni
          act: rcv
          width: 1
          default: lc_ctrl_pkg::Off
          inst_name: soc_dbg_ctrl
          top_signame: lc_ctrl_lc_dft_en
          index: -1
        }
        {
          name: lc_raw_test_rma
          desc:
            '''
            Test enable qualifier coming from life cycle controller.
            This signals enables RAW, TEST and RMA mode accesses.
            '''
          struct: lc_tx
          package: lc_ctrl_pkg
          type: uni
          act: rcv
          width: 1
          default: lc_ctrl_pkg::Off
          inst_name: soc_dbg_ctrl
          top_signame: lc_ctrl_lc_raw_test_rma
          index: -1
        }
        {
          name: halt_cpu_boot
          desc: External request to halt the CPU until a JTAG command allows the boot process to continue.
          struct: logic
          type: uni
          act: rcv
          width: 1
          inst_name: soc_dbg_ctrl
          default: ""
          package: ""
          external: true
          top_signame: debug_halt_cpu_boot
          conn_type: false
          index: -1
        }
        {
          name: continue_cpu_boot
          desc: Artificial ROM control input to the pwrmgr to halt the boot process.
          struct: pwrmgr_data
          package: rom_ctrl_pkg
          type: uni
          act: req
          width: 1
          inst_name: soc_dbg_ctrl
          default: ""
          top_signame: pwrmgr_aon_rom_ctrl
          index: 2
        }
        {
          name: core_tl
          struct: tl
          package: tlul_pkg
          type: req_rsp
          act: rsp
          width: 1
          inst_name: soc_dbg_ctrl
          default: ""
          end_idx: -1
          top_signame: soc_dbg_ctrl_core_tl
          index: -1
        }
        {
          name: jtag_tl
          struct: tl
          package: tlul_pkg
          type: req_rsp
          act: rsp
          width: 1
          inst_name: soc_dbg_ctrl
          default: ""
          end_idx: -1
          top_signame: soc_dbg_ctrl_jtag_tl
          index: -1
        }
      ]
      generate_dif: true
      domain:
      [
        "0"
      ]
    }
    {
      name: racl_ctrl
      type: racl_ctrl
      template_type: racl_ctrl
      clock_srcs:
      {
        clk_i: main
      }
      clock_group: infra
      reset_connections:
      {
        rst_ni:
        {
          name: lc
          domain: "0"
        }
      }
      attr: ipgen
      clock_connections:
      {
        clk_i: clkmgr_aon_clocks.clk_main_infra
      }
      param_decl: {}
      memory: {}
      param_list:
      [
        {
          name: NumSubscribingIps
          desc: Number of subscribing RACL IPs
          type: int
          default: 11
          local: "true"
          expose: "true"
          name_top: RaclCtrlNumSubscribingIps
        }
        {
          name: NumExternalSubscribingIps
          desc: Number of external subscribing RACL IPs
          type: int
          default: 1
          local: "false"
          expose: "true"
          name_top: RaclCtrlNumExternalSubscribingIps
        }
      ]
      inter_signal_list:
      [
        {
          name: racl_policies
          desc: Policy vector distributed to the subscribing RACL IPs.
          struct: racl_policy_vec
          package: top_racl_pkg
          type: uni
          act: req
          width: 1
          inst_name: racl_ctrl
          default: ""
          end_idx: -1
          top_type: broadcast
          top_signame: racl_ctrl_racl_policies
          index: -1
          external: true
          conn_type: true
        }
        {
          name: racl_error
          desc:
            '''
            Error log information from all IPs.
            Only one IP can raise an error at a time.
            '''
          struct: racl_error_log
          package: top_racl_pkg
          type: uni
          act: rcv
          width:
          {
            name: NumSubscribingIps
            desc: Number of subscribing RACL IPs
            param_type: int
            unpacked_dimensions: null
            default: 11
            local: true
            expose: true
            name_top: RaclCtrlNumSubscribingIps
          }
          inst_name: racl_ctrl
          default: ""
          end_idx: -1
          top_type: one-to-N
          top_signame: racl_ctrl_racl_error
          index: -1
        }
        {
          name: racl_error_external
          desc:
            '''
            Error log information from all external IPs.
            Only one IP can raise an error at a time.
            '''
          struct: racl_error_log
          package: top_racl_pkg
          type: uni
          act: rcv
          width:
          {
            name: NumExternalSubscribingIps
            desc: Number of external subscribing RACL IPs
            param_type: int
            unpacked_dimensions: null
            default: 1
            local: false
            expose: true
            name_top: RaclCtrlNumExternalSubscribingIps
          }
          inst_name: racl_ctrl
          default: ""
          external: true
          top_signame: racl_error
          conn_type: false
          index: -1
        }
        {
          name: tl
          struct: tl
          package: tlul_pkg
          type: req_rsp
          act: rsp
          width: 1
          inst_name: racl_ctrl
          default: ""
          end_idx: -1
          top_signame: racl_ctrl_tl
          index: -1
        }
      ]
      base_addrs:
      {
        null:
        {
          soc_mbx: 0x01461f00
        }
      }
      generate_dif: true
      domain:
      [
        "0"
      ]
    }
    {
      name: ac_range_check
      type: ac_range_check
      template_type: ac_range_check
      clock_srcs:
      {
        clk_i: main
      }
      clock_group: secure
      reset_connections:
      {
        rst_ni:
        {
          name: lc
          domain: "0"
        }
      }
      ipgen_param:
      {
        num_ranges: 32
      }
      attr: ipgen
      clock_connections:
      {
        clk_i: clkmgr_aon_clocks.clk_main_secure
      }
      param_decl: {}
      memory: {}
      param_list:
      [
        {
          name: RangeCheckErrorRsp
          desc:
            '''
            Error behavior on blocked requests:
            1: A denied request returns a TLUL error (.d_error = 1 on the response)
            0: Writes are dropped and reads return all-zero, without a TLUL error
            '''
          type: bit
          default: "1"
          local: "false"
          expose: "true"
          name_top: AcRangeCheckRangeCheckErrorRsp
        }
      ]
      inter_signal_list:
      [
        {
          name: range_check_overwrite
          desc: Overwrites all ranges and let all requests pass through.
          struct: mubi8
          package: prim_mubi_pkg
          type: uni
          act: rcv
          width: 1
          inst_name: ac_range_check
          default: ""
          external: true
          top_signame: ac_range_check_overwrite
          conn_type: false
          index: -1
        }
        {
          name: ctn_tl_h2d
          desc: TL-UL input port (request part), synchronous
          struct: tl_h2d
          package: tlul_pkg
          type: uni
          act: rcv
          width: 1
          inst_name: ac_range_check
          default: ""
          top_signame: soc_proxy_ctn_tl_h2d
          index: -1
        }
        {
          name: ctn_tl_d2h
          desc: TL-UL input port (response part), synchronous
          struct: tl_d2h
          package: tlul_pkg
          type: uni
          act: req
          width: 1
          inst_name: ac_range_check
          default: ""
          top_signame: soc_proxy_ctn_tl_d2h
          index: -1
        }
        {
          name: ctn_filtered_tl_h2d
          desc: Filtered TL-UL output port (request part), synchronous
          struct: tl_h2d
          package: tlul_pkg
          type: uni
          act: req
          width: 1
          inst_name: ac_range_check
          default: ""
          external: true
          top_signame: ctn_tl_h2d
          conn_type: false
          index: -1
        }
        {
          name: ctn_filtered_tl_d2h
          desc: Filtered TL-UL output port (response part), synchronous
          struct: tl_d2h
          package: tlul_pkg
          type: uni
          act: rcv
          width: 1
          inst_name: ac_range_check
          default: ""
          external: true
          top_signame: ctn_tl_d2h
          conn_type: false
          index: -1
        }
        {
          name: racl_policies
          desc:
            '''
            Incoming RACL policy vector from a racl_ctrl instance.
            The policy selection vector (parameter) selects the policy for each register.
            '''
          struct: racl_policy_vec
          package: top_racl_pkg
          type: uni
          act: rcv
          width: 1
          inst_name: ac_range_check
          default: ""
          top_signame: racl_ctrl_racl_policies
          index: -1
        }
        {
          name: racl_error
          desc: RACL error log information of this module.
          struct: racl_error_log
          package: top_racl_pkg
          type: uni
          act: req
          width: 1
          inst_name: ac_range_check
          default: ""
          top_signame: racl_ctrl_racl_error
          index: 10
        }
        {
          name: tl
          struct: tl
          package: tlul_pkg
          type: req_rsp
          act: rsp
          width: 1
          inst_name: ac_range_check
          default: ""
          end_idx: -1
          top_signame: ac_range_check_tl
          index: -1
        }
      ]
      base_addrs:
      {
        null:
        {
          soc_mbx: 0x01464000
        }
      }
      generate_dif: true
      racl_mappings:
      {
        null:
        {
          racl_group: Null
          register_mapping:
          {
            INTR_STATE: 2
            INTR_ENABLE: 2
            INTR_TEST: 2
            ALERT_TEST: 2
            ALERT_STATUS: 2
            LOG_CONFIG: 2
            LOG_STATUS: 2
            LOG_ADDRESS: 2
            RANGE_REGWEN_0: 2
            RANGE_REGWEN_1: 2
            RANGE_REGWEN_2: 2
            RANGE_REGWEN_3: 2
            RANGE_REGWEN_4: 2
            RANGE_REGWEN_5: 2
            RANGE_REGWEN_6: 2
            RANGE_REGWEN_7: 2
            RANGE_REGWEN_8: 2
            RANGE_REGWEN_9: 2
            RANGE_REGWEN_10: 2
            RANGE_REGWEN_11: 2
            RANGE_REGWEN_12: 2
            RANGE_REGWEN_13: 2
            RANGE_REGWEN_14: 2
            RANGE_REGWEN_15: 2
            RANGE_REGWEN_16: 2
            RANGE_REGWEN_17: 2
            RANGE_REGWEN_18: 2
            RANGE_REGWEN_19: 2
            RANGE_REGWEN_20: 2
            RANGE_REGWEN_21: 2
            RANGE_REGWEN_22: 2
            RANGE_REGWEN_23: 2
            RANGE_REGWEN_24: 2
            RANGE_REGWEN_25: 2
            RANGE_REGWEN_26: 2
            RANGE_REGWEN_27: 2
            RANGE_REGWEN_28: 2
            RANGE_REGWEN_29: 2
            RANGE_REGWEN_30: 2
            RANGE_REGWEN_31: 2
            RANGE_BASE_0: 2
            RANGE_BASE_1: 2
            RANGE_BASE_2: 2
            RANGE_BASE_3: 2
            RANGE_BASE_4: 2
            RANGE_BASE_5: 2
            RANGE_BASE_6: 2
            RANGE_BASE_7: 2
            RANGE_BASE_8: 2
            RANGE_BASE_9: 2
            RANGE_BASE_10: 2
            RANGE_BASE_11: 2
            RANGE_BASE_12: 2
            RANGE_BASE_13: 2
            RANGE_BASE_14: 2
            RANGE_BASE_15: 2
            RANGE_BASE_16: 2
            RANGE_BASE_17: 2
            RANGE_BASE_18: 2
            RANGE_BASE_19: 2
            RANGE_BASE_20: 2
            RANGE_BASE_21: 2
            RANGE_BASE_22: 2
            RANGE_BASE_23: 2
            RANGE_BASE_24: 2
            RANGE_BASE_25: 2
            RANGE_BASE_26: 2
            RANGE_BASE_27: 2
            RANGE_BASE_28: 2
            RANGE_BASE_29: 2
            RANGE_BASE_30: 2
            RANGE_BASE_31: 2
            RANGE_LIMIT_0: 2
            RANGE_LIMIT_1: 2
            RANGE_LIMIT_2: 2
            RANGE_LIMIT_3: 2
            RANGE_LIMIT_4: 2
            RANGE_LIMIT_5: 2
            RANGE_LIMIT_6: 2
            RANGE_LIMIT_7: 2
            RANGE_LIMIT_8: 2
            RANGE_LIMIT_9: 2
            RANGE_LIMIT_10: 2
            RANGE_LIMIT_11: 2
            RANGE_LIMIT_12: 2
            RANGE_LIMIT_13: 2
            RANGE_LIMIT_14: 2
            RANGE_LIMIT_15: 2
            RANGE_LIMIT_16: 2
            RANGE_LIMIT_17: 2
            RANGE_LIMIT_18: 2
            RANGE_LIMIT_19: 2
            RANGE_LIMIT_20: 2
            RANGE_LIMIT_21: 2
            RANGE_LIMIT_22: 2
            RANGE_LIMIT_23: 2
            RANGE_LIMIT_24: 2
            RANGE_LIMIT_25: 2
            RANGE_LIMIT_26: 2
            RANGE_LIMIT_27: 2
            RANGE_LIMIT_28: 2
            RANGE_LIMIT_29: 2
            RANGE_LIMIT_30: 2
            RANGE_LIMIT_31: 2
            RANGE_ATTR_0: 2
            RANGE_ATTR_1: 2
            RANGE_ATTR_2: 2
            RANGE_ATTR_3: 2
            RANGE_ATTR_4: 2
            RANGE_ATTR_5: 2
            RANGE_ATTR_6: 2
            RANGE_ATTR_7: 2
            RANGE_ATTR_8: 2
            RANGE_ATTR_9: 2
            RANGE_ATTR_10: 2
            RANGE_ATTR_11: 2
            RANGE_ATTR_12: 2
            RANGE_ATTR_13: 2
            RANGE_ATTR_14: 2
            RANGE_ATTR_15: 2
            RANGE_ATTR_16: 2
            RANGE_ATTR_17: 2
            RANGE_ATTR_18: 2
            RANGE_ATTR_19: 2
            RANGE_ATTR_20: 2
            RANGE_ATTR_21: 2
            RANGE_ATTR_22: 2
            RANGE_ATTR_23: 2
            RANGE_ATTR_24: 2
            RANGE_ATTR_25: 2
            RANGE_ATTR_26: 2
            RANGE_ATTR_27: 2
            RANGE_ATTR_28: 2
            RANGE_ATTR_29: 2
            RANGE_ATTR_30: 2
            RANGE_ATTR_31: 2
            RANGE_RACL_POLICY_SHADOWED_0: 2
            RANGE_RACL_POLICY_SHADOWED_1: 2
            RANGE_RACL_POLICY_SHADOWED_2: 2
            RANGE_RACL_POLICY_SHADOWED_3: 2
            RANGE_RACL_POLICY_SHADOWED_4: 2
            RANGE_RACL_POLICY_SHADOWED_5: 2
            RANGE_RACL_POLICY_SHADOWED_6: 2
            RANGE_RACL_POLICY_SHADOWED_7: 2
            RANGE_RACL_POLICY_SHADOWED_8: 2
            RANGE_RACL_POLICY_SHADOWED_9: 2
            RANGE_RACL_POLICY_SHADOWED_10: 2
            RANGE_RACL_POLICY_SHADOWED_11: 2
            RANGE_RACL_POLICY_SHADOWED_12: 2
            RANGE_RACL_POLICY_SHADOWED_13: 2
            RANGE_RACL_POLICY_SHADOWED_14: 2
            RANGE_RACL_POLICY_SHADOWED_15: 2
            RANGE_RACL_POLICY_SHADOWED_16: 2
            RANGE_RACL_POLICY_SHADOWED_17: 2
            RANGE_RACL_POLICY_SHADOWED_18: 2
            RANGE_RACL_POLICY_SHADOWED_19: 2
            RANGE_RACL_POLICY_SHADOWED_20: 2
            RANGE_RACL_POLICY_SHADOWED_21: 2
            RANGE_RACL_POLICY_SHADOWED_22: 2
            RANGE_RACL_POLICY_SHADOWED_23: 2
            RANGE_RACL_POLICY_SHADOWED_24: 2
            RANGE_RACL_POLICY_SHADOWED_25: 2
            RANGE_RACL_POLICY_SHADOWED_26: 2
            RANGE_RACL_POLICY_SHADOWED_27: 2
            RANGE_RACL_POLICY_SHADOWED_28: 2
            RANGE_RACL_POLICY_SHADOWED_29: 2
            RANGE_RACL_POLICY_SHADOWED_30: 2
            RANGE_RACL_POLICY_SHADOWED_31: 2
          }
          window_mapping: {}
          range_mapping: []
        }
      }
      domain:
      [
        "0"
      ]
    }
    {
      name: rv_core_ibex
      type: rv_core_ibex
      template_type: rv_core_ibex
      attr: ipgen
      ipgen_param:
      {
        NumRegions: 32
      }
      param_decl:
      {
        PMPEnable: "1"
        PMPGranularity: "0"
        PMPNumRegions: "16"
        MHPMCounterNum: "10"
        MHPMCounterWidth: "32"
        PMPRstCfg: ibex_pmp_reset_pkg::PmpCfgRst
        PMPRstAddr: ibex_pmp_reset_pkg::PmpAddrRst
        PMPRstMsecCfg: ibex_pmp_reset_pkg::PmpMseccfgRst
        RV32E: "0"
        RV32M: ibex_pkg::RV32MSingleCycle
        RV32B: ibex_pkg::RV32BOTEarlGrey
        RegFile: ibex_pkg::RegFileFF
        BranchTargetALU: "1"
        WritebackStage: "1"
        ICache: "1"
        ICacheECC: "1"
        ICacheScramble: "1"
        BranchPredictor: "0"
        DbgTriggerEn: "1"
        DbgHwBreakNum: "4"
        SecureIbex: "1"
        DmBaseAddr: tl_main_pkg::ADDR_SPACE_RV_DM__MEM
        DmAddrMask: tl_main_pkg::ADDR_MASK_RV_DM__MEM
        DmHaltAddr: tl_main_pkg::ADDR_SPACE_RV_DM__MEM + dm::HaltAddress[31:0]
        DmExceptionAddr: tl_main_pkg::ADDR_SPACE_RV_DM__MEM + dm::ExceptionAddress[31:0]
        PipeLine: "1"
        NEscalationSeverities: AlertHandlerEscNumSeverities
        WidthPingCounter: AlertHandlerEscPingCountWidth
      }
      clock_srcs:
      {
        clk_i: main
        clk_edn_i: main
        clk_esc_i:
        {
          clock: io_div4
          group: secure
        }
        clk_otp_i:
        {
          clock: io_div4
          group: secure
        }
      }
      clock_group: infra
      reset_connections:
      {
        rst_ni:
        {
          name: lc
          domain: "0"
        }
        rst_edn_ni:
        {
          name: lc
          domain: "0"
        }
        rst_esc_ni:
        {
          name: lc_io_div4
          domain: "0"
        }
        rst_otp_ni:
        {
          name: lc_io_div4
          domain: "0"
        }
      }
      clock_connections:
      {
        clk_i: clkmgr_aon_clocks.clk_main_infra
        clk_edn_i: clkmgr_aon_clocks.clk_main_infra
        clk_esc_i: clkmgr_aon_clocks.clk_io_div4_secure
        clk_otp_i: clkmgr_aon_clocks.clk_io_div4_secure
      }
      memory: {}
      param_list:
      [
        {
          name: RndCnstLfsrSeed
          desc: Default seed of the PRNG used for random instructions.
          type: ibex_pkg::lfsr_seed_t
          randcount: 32
          randtype: data
          name_top: RndCnstRvCoreIbexLfsrSeed
          default: 0xd6e39551
          randwidth: 32
        }
        {
          name: RndCnstLfsrPerm
          desc: Permutation applied to the LFSR of the PRNG used for random instructions.
          type: ibex_pkg::lfsr_perm_t
          randcount: 32
          randtype: perm
          name_top: RndCnstRvCoreIbexLfsrPerm
          default: 0xb855af9470711fb15b06931a78afd9ed2b348388
          randwidth: 160
        }
        {
          name: RndCnstIbexKeyDefault
          desc: Default icache scrambling key
          type: logic [ibex_pkg::SCRAMBLE_KEY_W-1:0]
          randcount: 128
          randtype: data
          name_top: RndCnstRvCoreIbexIbexKeyDefault
          default: 0x47d3d7b758b37d1d1ca19a079c48d7d4
          randwidth: 128
        }
        {
          name: RndCnstIbexNonceDefault
          desc: Default icache scrambling nonce
          type: logic [ibex_pkg::SCRAMBLE_NONCE_W-1:0]
          randcount: 64
          randtype: data
          name_top: RndCnstRvCoreIbexIbexNonceDefault
          default: 0xe67100a6aaebe45b
          randwidth: 64
        }
        {
          name: NEscalationSeverities
          desc: Number of escalation severities
          type: int unsigned
          default: AlertHandlerEscNumSeverities
          local: "false"
          expose: "false"
          name_top: RvCoreIbexNEscalationSeverities
        }
        {
          name: WidthPingCounter
          desc: Width of the ping counter
          type: int unsigned
          default: AlertHandlerEscPingCountWidth
          local: "false"
          expose: "false"
          name_top: RvCoreIbexWidthPingCounter
        }
        {
          name: PMPEnable
          desc: Enable PMP
          type: bit
          default: "1"
          local: "false"
          expose: "true"
          name_top: RvCoreIbexPMPEnable
        }
        {
          name: PMPGranularity
          desc: PMP Granularity
          type: int unsigned
          default: "0"
          local: "false"
          expose: "true"
          name_top: RvCoreIbexPMPGranularity
        }
        {
          name: PMPNumRegions
          desc: PMP number of regions
          type: int unsigned
          default: "16"
          local: "false"
          expose: "true"
          name_top: RvCoreIbexPMPNumRegions
        }
        {
          name: MHPMCounterNum
          desc: "Number of the MHPM counter "
          type: int unsigned
          default: "10"
          local: "false"
          expose: "true"
          name_top: RvCoreIbexMHPMCounterNum
        }
        {
          name: MHPMCounterWidth
          desc: "Width of the MHPM Counter "
          type: int unsigned
          default: "32"
          local: "false"
          expose: "true"
          name_top: RvCoreIbexMHPMCounterWidth
        }
        {
          name: PMPRstCfg
          desc: Reset value of PMP config CSRs
          type: ibex_pkg::pmp_cfg_t
          unpacked_dimensions: "[16]"
          default: ibex_pmp_reset_pkg::PmpCfgRst
          local: "false"
          expose: "true"
          name_top: RvCoreIbexPMPRstCfg
        }
        {
          name: PMPRstAddr
          desc: Reset value of PMP address CSRs
          type: logic [33:0]
          unpacked_dimensions: "[16]"
          default: ibex_pmp_reset_pkg::PmpAddrRst
          local: "false"
          expose: "true"
          name_top: RvCoreIbexPMPRstAddr
        }
        {
          name: PMPRstMsecCfg
          desc: Reset value of MSECCFG CSR
          type: ibex_pkg::pmp_mseccfg_t
          default: ibex_pmp_reset_pkg::PmpMseccfgRst
          local: "false"
          expose: "true"
          name_top: RvCoreIbexPMPRstMsecCfg
        }
        {
          name: RV32E
          desc: RV32E
          type: bit
          default: "0"
          local: "false"
          expose: "true"
          name_top: RvCoreIbexRV32E
        }
        {
          name: RV32M
          desc: RV32M
          type: ibex_pkg::rv32m_e
          default: ibex_pkg::RV32MSingleCycle
          local: "false"
          expose: "true"
          name_top: RvCoreIbexRV32M
        }
        {
          name: RV32B
          desc: RV32B
          type: ibex_pkg::rv32b_e
          default: ibex_pkg::RV32BOTEarlGrey
          local: "false"
          expose: "true"
          name_top: RvCoreIbexRV32B
        }
        {
          name: RegFile
          desc: Reg file
          type: ibex_pkg::regfile_e
          default: ibex_pkg::RegFileFF
          local: "false"
          expose: "true"
          name_top: RvCoreIbexRegFile
        }
        {
          name: BranchTargetALU
          desc: Branch target ALU
          type: bit
          default: "1"
          local: "false"
          expose: "true"
          name_top: RvCoreIbexBranchTargetALU
        }
        {
          name: WritebackStage
          desc: Write back stage
          type: bit
          default: "1"
          local: "false"
          expose: "true"
          name_top: RvCoreIbexWritebackStage
        }
        {
          name: ICache
          desc: Instruction cache
          type: bit
          default: "1"
          local: "false"
          expose: "true"
          name_top: RvCoreIbexICache
        }
        {
          name: ICacheECC
          desc: Instruction cache ECC
          type: bit
          default: "1"
          local: "false"
          expose: "true"
          name_top: RvCoreIbexICacheECC
        }
        {
          name: ICacheScramble
          desc: Scramble instruction cach
          type: bit
          default: "1"
          local: "false"
          expose: "true"
          name_top: RvCoreIbexICacheScramble
        }
        {
          name: ICacheNWays
          desc: Number of instruction cache ways
          type: int unsigned
          default: 2
          local: "false"
          expose: "true"
          name_top: RvCoreIbexICacheNWays
        }
        {
          name: BranchPredictor
          desc: Branch predictor
          type: bit
          default: "0"
          local: "false"
          expose: "true"
          name_top: RvCoreIbexBranchPredictor
        }
        {
          name: DbgTriggerEn
          desc: Enable degug trigger
          type: bit
          default: "1"
          local: "false"
          expose: "true"
          name_top: RvCoreIbexDbgTriggerEn
        }
        {
          name: DbgHwBreakNum
          desc: Number of debug hardware break
          type: int
          default: "4"
          local: "false"
          expose: "true"
          name_top: RvCoreIbexDbgHwBreakNum
        }
        {
          name: SecureIbex
          desc: "Width of the MHPM Counter "
          type: bit
          default: "1"
          local: "false"
          expose: "true"
          name_top: RvCoreIbexSecureIbex
        }
        {
          name: DmBaseAddr
          desc: Base address of Debug Module
          type: int unsigned
          default: tl_main_pkg::ADDR_SPACE_RV_DM__MEM
          local: "false"
          expose: "true"
          name_top: RvCoreIbexDmBaseAddr
        }
        {
          name: DmAddrMask
          desc: Adress mask of Debug Module
          type: int unsigned
          default: tl_main_pkg::ADDR_MASK_RV_DM__MEM
          local: "false"
          expose: "true"
          name_top: RvCoreIbexDmAddrMask
        }
        {
          name: DmHaltAddr
          desc: Halt address
          type: int unsigned
          default: tl_main_pkg::ADDR_SPACE_RV_DM__MEM + dm::HaltAddress[31:0]
          local: "false"
          expose: "true"
          name_top: RvCoreIbexDmHaltAddr
        }
        {
          name: DmExceptionAddr
          desc: Exception address
          type: int unsigned
          default: tl_main_pkg::ADDR_SPACE_RV_DM__MEM + dm::ExceptionAddress[31:0]
          local: "false"
          expose: "true"
          name_top: RvCoreIbexDmExceptionAddr
        }
        {
          name: PipeLine
          desc: Pipe line
          type: bit
          default: "1"
          local: "false"
          expose: "true"
          name_top: RvCoreIbexPipeLine
        }
        {
          name: TlulHostUserRsvdBits
          desc: TLUL user bits sent on outgoing transfers.
          type: logic [tlul_pkg::RsvdWidth-1:0]
          default: "'0"
          local: "false"
          expose: "true"
          name_top: RvCoreIbexTlulHostUserRsvdBits
        }
        {
          name: CsrMvendorId
          desc:
            '''
            mvendorid: encoding of manufacturer/provider
            0 indicates this field is not implemented.
            Ibex implementors may wish to set their own JEDEC ID here.
            '''
          type: logic [31:0]
          default: "'0"
          local: "false"
          expose: "true"
          name_top: RvCoreIbexCsrMvendorId
        }
        {
          name: CsrMimpId
          desc:
            '''
            mimpid: encoding of processor implementation version
            0 indicates this field is not implemented.
            Ibex implementors may wish to indicate an RTL/netlist version here using their own unique encoding (e.g. 32 bits of the git hash of the implemented commit).
            '''
          type: logic [31:0]
          default: "'0"
          local: "false"
          expose: "true"
          name_top: RvCoreIbexCsrMimpId
        }
      ]
      inter_signal_list:
      [
        {
          name: rst_cpu_n
          struct: logic
          type: uni
          act: req
          width: 1
          inst_name: rv_core_ibex
          index: -1
        }
        {
          name: ram_cfg_icache_tag
          struct: ram_1p_cfg
          package: prim_ram_1p_pkg
          type: uni
          act: rcv
          width: 1
          inst_name: rv_core_ibex
          default: ""
          external: true
          top_signame: rv_core_ibex_icache_tag_ram_1p_cfg
          conn_type: false
          index: -1
        }
        {
          name: ram_cfg_rsp_icache_tag
          struct: ram_1p_cfg_rsp
          package: prim_ram_1p_pkg
          type: uni
          act: req
          width:
          {
            name: ICacheNWays
            desc: Number of instruction cache ways
            param_type: int unsigned
            unpacked_dimensions: null
            default: 2
            local: false
            expose: true
            name_top: RvCoreIbexICacheNWays
          }
          inst_name: rv_core_ibex
          default: ""
          external: true
          top_signame: rv_core_ibex_icache_tag_ram_1p_cfg_rsp
          conn_type: false
          index: -1
        }
        {
          name: ram_cfg_icache_data
          struct: ram_1p_cfg
          package: prim_ram_1p_pkg
          type: uni
          act: rcv
          width: 1
          inst_name: rv_core_ibex
          default: ""
          external: true
          top_signame: rv_core_ibex_icache_data_ram_1p_cfg
          conn_type: false
          index: -1
        }
        {
          name: ram_cfg_rsp_icache_data
          struct: ram_1p_cfg_rsp
          package: prim_ram_1p_pkg
          type: uni
          act: req
          width:
          {
            name: ICacheNWays
            desc: Number of instruction cache ways
            param_type: int unsigned
            unpacked_dimensions: null
            default: 2
            local: false
            expose: true
            name_top: RvCoreIbexICacheNWays
          }
          inst_name: rv_core_ibex
          default: ""
          external: true
          top_signame: rv_core_ibex_icache_data_ram_1p_cfg_rsp
          conn_type: false
          index: -1
        }
        {
          name: hart_id
          struct: logic
          type: uni
          act: rcv
          width: 32
          inst_name: rv_core_ibex
          default: ""
          package: ""
          top_signame: rv_core_ibex_hart_id
          index: -1
        }
        {
          name: boot_addr
          struct: logic
          type: uni
          act: rcv
          width: 32
          inst_name: rv_core_ibex
          default: ""
          package: ""
          top_signame: rv_core_ibex_boot_addr
          index: -1
        }
        {
          name: irq_software
          struct: logic
          type: uni
          act: rcv
          width: 1
          inst_name: rv_core_ibex
          default: ""
          package: ""
          top_signame: rv_plic_msip
          index: -1
        }
        {
          name: irq_timer
          struct: logic
          type: uni
          act: rcv
          width: 1
          inst_name: rv_core_ibex
          default: ""
          package: ""
          top_signame: rv_core_ibex_irq_timer
          index: -1
        }
        {
          name: irq_external
          struct: logic
          type: uni
          act: rcv
          width: 1
          inst_name: rv_core_ibex
          default: ""
          package: ""
          top_signame: rv_plic_irq
          index: -1
        }
        {
          name: esc_tx
          struct: esc_tx
          package: prim_esc_pkg
          type: uni
          act: rcv
          width: 1
          inst_name: rv_core_ibex
          default: ""
          top_signame: alert_handler_esc_tx
          index: 0
        }
        {
          name: esc_rx
          struct: esc_rx
          package: prim_esc_pkg
          type: uni
          act: req
          width: 1
          inst_name: rv_core_ibex
          default: ""
          top_signame: alert_handler_esc_rx
          index: 0
        }
        {
          name: debug_req
          struct: logic
          type: uni
          act: rcv
          width: 1
          inst_name: rv_core_ibex
          default: ""
          package: ""
          top_signame: rv_dm_debug_req
          index: -1
        }
        {
          name: crash_dump
          struct: cpu_crash_dump
          package: rv_core_ibex_pkg
          type: uni
          act: req
          width: 1
          inst_name: rv_core_ibex
          default: ""
          end_idx: -1
          top_type: broadcast
          top_signame: rv_core_ibex_crash_dump
          index: -1
        }
        {
          name: lc_cpu_en
          struct: lc_tx
          package: lc_ctrl_pkg
          type: uni
          act: rcv
          width: 1
          inst_name: rv_core_ibex
          default: ""
          top_signame: lc_ctrl_lc_cpu_en
          index: -1
        }
        {
          name: pwrmgr_cpu_en
          struct: lc_tx
          package: lc_ctrl_pkg
          type: uni
          act: rcv
          width: 1
          inst_name: rv_core_ibex
          default: ""
          top_signame: pwrmgr_aon_fetch_en
          index: -1
        }
        {
          name: pwrmgr
          struct: cpu_pwrmgr
          package: rv_core_ibex_pkg
          type: uni
          act: req
          width: 1
          inst_name: rv_core_ibex
          default: ""
          end_idx: -1
          top_type: broadcast
          top_signame: rv_core_ibex_pwrmgr
          index: -1
        }
        {
          name: nmi_wdog
          struct: logic
          type: uni
          act: rcv
          width: 1
          inst_name: rv_core_ibex
          default: ""
          package: ""
          top_signame: aon_timer_aon_nmi_wdog_timer_bark
          index: -1
        }
        {
          name: edn
          struct: edn
          package: edn_pkg
          type: req_rsp
          act: req
          width: 1
          inst_name: rv_core_ibex
          default: ""
          top_signame: edn0_edn
          index: 7
        }
        {
          name: icache_otp_key
          struct: sram_otp_key
          package: otp_ctrl_pkg
          type: req_rsp
          act: req
          width: 1
          inst_name: rv_core_ibex
          default: ""
          top_signame: otp_ctrl_sram_otp_key
          index: 3
        }
        {
          name: fpga_info
          struct: logic
          type: uni
          act: rcv
          width: 32
          inst_name: rv_core_ibex
          default: ""
          package: ""
          external: true
          top_signame: fpga_info
          conn_type: false
          index: -1
        }
        {
          name: corei_tl_h
          struct: tl
          package: tlul_pkg
          type: req_rsp
          act: req
          width: 1
          inst_name: rv_core_ibex
          default: ""
          top_signame: main_tl_rv_core_ibex__corei
          index: -1
        }
        {
          name: cored_tl_h
          struct: tl
          package: tlul_pkg
          type: req_rsp
          act: req
          width: 1
          inst_name: rv_core_ibex
          default: ""
          top_signame: main_tl_rv_core_ibex__cored
          index: -1
        }
        {
          name: cfg_tl_d
          struct: tl
          package: tlul_pkg
          type: req_rsp
          act: rsp
          width: 1
          inst_name: rv_core_ibex
          default: ""
          end_idx: -1
          top_signame: rv_core_ibex_cfg_tl_d
          index: -1
        }
      ]
      base_addrs:
      {
        cfg:
        {
          hart: 0x211f0000
        }
      }
      generate_dif: true
      domain:
      [
        "0"
      ]
    }
  ]
  memory: []
  port:
  [
    {
      name: ast
      inter_signal_list:
      [
        {
          struct: edn
          type: req_rsp
          name: edn
          act: rsp
          package: edn_pkg
          inst_name: ast
          width: 1
          default: ""
          top_signame: edn0_edn
          index: 2
          external: true
          conn_type: true
        }
        {
          struct: lc_tx
          type: uni
          name: lc_dft_en
          act: req
          package: lc_ctrl_pkg
          inst_name: ast
          width: 1
          default: ""
          top_signame: lc_ctrl_lc_dft_en
          index: -1
          external: true
          conn_type: true
        }
        {
          struct: lc_tx
          type: uni
          name: lc_hw_debug_en
          act: req
          package: lc_ctrl_pkg
          inst_name: ast
          width: 1
          default: ""
          top_signame: lc_ctrl_lc_hw_debug_en
          index: -1
          external: true
          conn_type: true
        }
        {
          struct: ast_obs_ctrl
          type: uni
          name: obs_ctrl
          act: rcv
          package: ast_pkg
          inst_name: ast
          width: 1
          default: ""
          end_idx: -1
          top_type: broadcast
          top_signame: ast_obs_ctrl
          index: -1
          external: true
          conn_type: true
        }
      ]
    }
  ]
  inter_module:
  {
    connect:
    {
      ast.obs_ctrl:
      [
        otp_macro.obs_ctrl
      ]
      alert_handler.crashdump:
      [
        rstmgr_aon.alert_dump
      ]
      alert_handler.esc_rx:
      [
        rv_core_ibex.esc_rx
        lc_ctrl.esc_scrap_state0_rx
        lc_ctrl.esc_scrap_state1_rx
        pwrmgr_aon.esc_rst_rx
      ]
      alert_handler.esc_tx:
      [
        rv_core_ibex.esc_tx
        lc_ctrl.esc_scrap_state0_tx
        lc_ctrl.esc_scrap_state1_tx
        pwrmgr_aon.esc_rst_tx
      ]
      aon_timer_aon.nmi_wdog_timer_bark:
      [
        rv_core_ibex.nmi_wdog
      ]
      csrng.csrng_cmd:
      [
        edn0.csrng_cmd
        edn1.csrng_cmd
      ]
      otp_ctrl.sram_otp_key:
      [
        sram_ctrl_main.sram_otp_key
        sram_ctrl_ret_aon.sram_otp_key
        sram_ctrl_mbox.sram_otp_key
        rv_core_ibex.icache_otp_key
      ]
      pwrmgr_aon.pwr_rst:
      [
        rstmgr_aon.pwr
      ]
      pwrmgr_aon.pwr_clk:
      [
        clkmgr_aon.pwr
      ]
      pwrmgr_aon.pwr_otp:
      [
        otp_ctrl.pwr_otp
      ]
      pwrmgr_aon.pwr_lc:
      [
        lc_ctrl.pwr_lc
      ]
      pwrmgr_aon.strap:
      [
        gpio.strap_en
        rv_dm.strap_en
      ]
      pwrmgr_aon.low_power:
      [
        pinmux_aon.sleep_en
        aon_timer_aon.sleep_mode
      ]
      pwrmgr_aon.fetch_en:
      [
        rv_core_ibex.pwrmgr_cpu_en
      ]
      pwrmgr_aon.rom_ctrl:
      [
        rom_ctrl0.pwrmgr_data
        rom_ctrl1.pwrmgr_data
        soc_dbg_ctrl.continue_cpu_boot
      ]
      pwrmgr_aon.boot_status:
      [
        soc_dbg_ctrl.boot_status
      ]
      keymgr_dpe.rom_digest:
      [
        rom_ctrl0.keymgr_data
        rom_ctrl1.keymgr_data
      ]
      dma.lsio_trigger:
      [
        soc_proxy.dma_lsio_trigger
      ]
      i2c0.lsio_trigger:
      [
        soc_proxy.i2c_lsio_trigger
      ]
      spi_host0.lsio_trigger:
      [
        soc_proxy.spi_host_lsio_trigger
      ]
      uart0.lsio_trigger:
      [
        soc_proxy.uart_lsio_trigger
      ]
      lc_ctrl.lc_flash_rma_req:
      [
        otbn.lc_rma_req
      ]
      otbn.lc_rma_ack:
      [
        lc_ctrl.lc_flash_rma_ack
      ]
      edn0.edn:
      [
        keymgr_dpe.edn
        otp_ctrl.edn
        ast.edn
        kmac.entropy
        alert_handler.edn
        aes.edn
        otbn.edn_urnd
        rv_core_ibex.edn
      ]
      edn1.edn:
      [
        otbn.edn_rnd
      ]
      otp_ctrl.otbn_otp_key:
      [
        otbn.otbn_otp_key
      ]
      otp_ctrl.otp_keymgr_key:
      [
        keymgr_dpe.otp_key
      ]
      keymgr_dpe.aes_key:
      [
        aes.keymgr_key
      ]
      keymgr_dpe.kmac_key:
      [
        kmac.keymgr_key
      ]
      keymgr_dpe.otbn_key:
      [
        otbn.keymgr_key
      ]
      kmac.app:
      [
        keymgr_dpe.kmac_data
        lc_ctrl.kmac_data
        rom_ctrl0.kmac_data
        rom_ctrl1.kmac_data
      ]
      kmac.en_masking:
      [
        keymgr_dpe.kmac_en_masking
      ]
      clkmgr_aon.idle:
      [
        aes.idle
        hmac.idle
        kmac.idle
        otbn.idle
      ]
      otp_ctrl.otp_lc_data:
      [
        lc_ctrl.otp_lc_data
      ]
      lc_ctrl.lc_otp_program:
      [
        otp_ctrl.lc_otp_program
      ]
      lc_ctrl.lc_otp_vendor_test:
      [
        otp_macro.test
      ]
      lc_ctrl.lc_keymgr_div:
      [
        keymgr_dpe.lc_keymgr_div
      ]
      lc_ctrl.strap_en_override:
      [
        rv_dm.strap_en_override
      ]
      lc_ctrl.lc_raw_test_rma:
      [
        soc_dbg_ctrl.lc_raw_test_rma
      ]
      lc_ctrl.lc_dft_en:
      [
        otp_macro.lc_dft_en
        ast.lc_dft_en
        pwrmgr_aon.lc_dft_en
        soc_dbg_ctrl.lc_dft_en
      ]
      lc_ctrl.lc_hw_debug_en:
      [
        sram_ctrl_main.lc_hw_debug_en
        ast.lc_hw_debug_en
        csrng.lc_hw_debug_en
        rv_dm.lc_hw_debug_en
        clkmgr_aon.lc_hw_debug_en
        pwrmgr_aon.lc_hw_debug_en
        soc_dbg_ctrl.lc_hw_debug_en
      ]
      lc_ctrl.lc_cpu_en:
      [
        rv_core_ibex.lc_cpu_en
      ]
      lc_ctrl.lc_keymgr_en:
      [
        keymgr_dpe.lc_keymgr_en
      ]
      lc_ctrl.lc_escalate_en:
      [
        aes.lc_escalate_en
        kmac.lc_escalate_en
        otbn.lc_escalate_en
        otp_ctrl.lc_escalate_en
        sram_ctrl_main.lc_escalate_en
        sram_ctrl_ret_aon.lc_escalate_en
        sram_ctrl_mbox.lc_escalate_en
        aon_timer_aon.lc_escalate_en
        rv_dm.lc_escalate_en
      ]
      lc_ctrl.lc_check_byp_en:
      [
        otp_ctrl.lc_check_byp_en
        rv_dm.lc_check_byp_en
      ]
      lc_ctrl.lc_clk_byp_req:
      [
        clkmgr_aon.lc_clk_byp_req
      ]
      lc_ctrl.lc_clk_byp_ack:
      [
        clkmgr_aon.lc_clk_byp_ack
      ]
      lc_ctrl.lc_creator_seed_sw_rw_en:
      [
        otp_ctrl.lc_creator_seed_sw_rw_en
      ]
      lc_ctrl.lc_owner_seed_sw_rw_en:
      [
        otp_ctrl.lc_owner_seed_sw_rw_en
      ]
      lc_ctrl.lc_seed_hw_rd_en:
      [
        otp_ctrl.lc_seed_hw_rd_en
      ]
      otp_ctrl.otp_macro:
      [
        otp_macro.otp
      ]
      rv_plic.msip:
      [
        rv_core_ibex.irq_software
      ]
      rv_plic.irq:
      [
        rv_core_ibex.irq_external
      ]
      rv_dm.debug_req:
      [
        rv_core_ibex.debug_req
      ]
      rv_core_ibex.crash_dump:
      [
        rstmgr_aon.cpu_dump
      ]
      rv_core_ibex.pwrmgr:
      [
        pwrmgr_aon.pwr_cpu
      ]
      spi_device.passthrough:
      [
        spi_host0.passthrough
      ]
      rv_dm.ndmreset_req:
      [
        pwrmgr_aon.ndmreset_req
      ]
      rstmgr_aon.sw_rst_req:
      [
        pwrmgr_aon.sw_rst_req
      ]
      soc_proxy.dma_tl_h2d:
      [
        dma.ctn_tl_h2d
      ]
      soc_proxy.dma_tl_d2h:
      [
        dma.ctn_tl_d2h
      ]
      soc_proxy.ctn_tl_h2d:
      [
        ac_range_check.ctn_tl_h2d
      ]
      soc_proxy.ctn_tl_d2h:
      [
        ac_range_check.ctn_tl_d2h
      ]
      pwrmgr_aon.wakeups:
      [
        pinmux_aon.pin_wkup_req
        aon_timer_aon.wkup_req
        soc_proxy.wkup_internal_req
        soc_proxy.wkup_external_req
      ]
      pwrmgr_aon.rstreqs:
      [
        aon_timer_aon.aon_timer_rst_req
        soc_proxy.rst_req_external
      ]
      main.tl_rv_core_ibex__corei:
      [
        rv_core_ibex.corei_tl_h
      ]
      main.tl_rv_core_ibex__cored:
      [
        rv_core_ibex.cored_tl_h
      ]
      main.tl_rv_dm__sba:
      [
        rv_dm.sba_tl_h
      ]
      rv_dm.regs_tl_d:
      [
        main.tl_rv_dm__regs
      ]
      rv_dm.mem_tl_d:
      [
        main.tl_rv_dm__mem
      ]
      rom_ctrl0.rom_tl:
      [
        main.tl_rom_ctrl0__rom
      ]
      rom_ctrl0.regs_tl:
      [
        main.tl_rom_ctrl0__regs
      ]
      rom_ctrl1.rom_tl:
      [
        main.tl_rom_ctrl1__rom
      ]
      rom_ctrl1.regs_tl:
      [
        main.tl_rom_ctrl1__regs
      ]
      main.tl_peri:
      [
        peri.tl_main
      ]
      soc_proxy.core_tl:
      [
        main.tl_soc_proxy__core
      ]
      soc_proxy.ctn_tl:
      [
        main.tl_soc_proxy__ctn
      ]
      hmac.tl:
      [
        main.tl_hmac
      ]
      kmac.tl:
      [
        main.tl_kmac
      ]
      aes.tl:
      [
        main.tl_aes
      ]
      csrng.tl:
      [
        main.tl_csrng
      ]
      edn0.tl:
      [
        main.tl_edn0
      ]
      edn1.tl:
      [
        main.tl_edn1
      ]
      rv_plic.tl:
      [
        main.tl_rv_plic
      ]
      otbn.tl:
      [
        main.tl_otbn
      ]
      keymgr_dpe.tl:
      [
        main.tl_keymgr_dpe
      ]
      rv_core_ibex.cfg_tl_d:
      [
        main.tl_rv_core_ibex__cfg
      ]
      sram_ctrl_main.regs_tl:
      [
        main.tl_sram_ctrl_main__regs
      ]
      sram_ctrl_main.ram_tl:
      [
        main.tl_sram_ctrl_main__ram
      ]
      sram_ctrl_mbox.regs_tl:
      [
        main.tl_sram_ctrl_mbox__regs
      ]
      sram_ctrl_mbox.ram_tl:
      [
        main.tl_sram_ctrl_mbox__ram
      ]
      dma.tl_d:
      [
        main.tl_dma
      ]
      main.tl_dma__host:
      [
        dma.host_tl_h
      ]
      mbx0.core_tl_d:
      [
        main.tl_mbx0__core
      ]
      main.tl_mbx0__sram:
      [
        mbx0.sram_tl_h
      ]
      mbx1.core_tl_d:
      [
        main.tl_mbx1__core
      ]
      main.tl_mbx1__sram:
      [
        mbx1.sram_tl_h
      ]
      mbx2.core_tl_d:
      [
        main.tl_mbx2__core
      ]
      main.tl_mbx2__sram:
      [
        mbx2.sram_tl_h
      ]
      mbx3.core_tl_d:
      [
        main.tl_mbx3__core
      ]
      main.tl_mbx3__sram:
      [
        mbx3.sram_tl_h
      ]
      mbx4.core_tl_d:
      [
        main.tl_mbx4__core
      ]
      main.tl_mbx4__sram:
      [
        mbx4.sram_tl_h
      ]
      mbx5.core_tl_d:
      [
        main.tl_mbx5__core
      ]
      main.tl_mbx5__sram:
      [
        mbx5.sram_tl_h
      ]
      mbx6.core_tl_d:
      [
        main.tl_mbx6__core
      ]
      main.tl_mbx6__sram:
      [
        mbx6.sram_tl_h
      ]
      mbx_jtag.core_tl_d:
      [
        main.tl_mbx_jtag__core
      ]
      main.tl_mbx_jtag__sram:
      [
        mbx_jtag.sram_tl_h
      ]
      mbx_pcie0.core_tl_d:
      [
        main.tl_mbx_pcie0__core
      ]
      main.tl_mbx_pcie0__sram:
      [
        mbx_pcie0.sram_tl_h
      ]
      mbx_pcie1.core_tl_d:
      [
        main.tl_mbx_pcie1__core
      ]
      main.tl_mbx_pcie1__sram:
      [
        mbx_pcie1.sram_tl_h
      ]
      uart0.tl:
      [
        peri.tl_uart0
      ]
      i2c0.tl:
      [
        peri.tl_i2c0
      ]
      gpio.tl:
      [
        peri.tl_gpio
      ]
      spi_host0.tl:
      [
        peri.tl_spi_host0
      ]
      spi_device.tl:
      [
        peri.tl_spi_device
      ]
      rv_timer.tl:
      [
        peri.tl_rv_timer
      ]
      pwrmgr_aon.tl:
      [
        peri.tl_pwrmgr_aon
      ]
      rstmgr_aon.tl:
      [
        peri.tl_rstmgr_aon
      ]
      clkmgr_aon.tl:
      [
        peri.tl_clkmgr_aon
      ]
      pinmux_aon.tl:
      [
        peri.tl_pinmux_aon
      ]
      otp_ctrl.core_tl:
      [
        peri.tl_otp_ctrl__core
      ]
      otp_macro.tl:
      [
        peri.tl_otp_macro
      ]
      lc_ctrl.regs_tl:
      [
        peri.tl_lc_ctrl__regs
      ]
      alert_handler.tl:
      [
        peri.tl_alert_handler
      ]
      sram_ctrl_ret_aon.regs_tl:
      [
        peri.tl_sram_ctrl_ret_aon__regs
      ]
      sram_ctrl_ret_aon.ram_tl:
      [
        peri.tl_sram_ctrl_ret_aon__ram
      ]
      aon_timer_aon.tl:
      [
        peri.tl_aon_timer_aon
      ]
      soc_dbg_ctrl.core_tl:
      [
        peri.tl_soc_dbg_ctrl__core
      ]
      mbx0.soc_tl_d:
      [
        mbx.tl_mbx0__soc
      ]
      mbx1.soc_tl_d:
      [
        mbx.tl_mbx1__soc
      ]
      mbx2.soc_tl_d:
      [
        mbx.tl_mbx2__soc
      ]
      mbx3.soc_tl_d:
      [
        mbx.tl_mbx3__soc
      ]
      mbx4.soc_tl_d:
      [
        mbx.tl_mbx4__soc
      ]
      mbx5.soc_tl_d:
      [
        mbx.tl_mbx5__soc
      ]
      mbx6.soc_tl_d:
      [
        mbx.tl_mbx6__soc
      ]
      mbx_pcie0.soc_tl_d:
      [
        mbx.tl_mbx_pcie0__soc
      ]
      mbx_pcie1.soc_tl_d:
      [
        mbx.tl_mbx_pcie1__soc
      ]
      racl_ctrl.tl:
      [
        mbx.tl_racl_ctrl
      ]
      ac_range_check.tl:
      [
        mbx.tl_ac_range_check
      ]
      rv_dm.dbg_tl_d:
      [
        dbg.tl_rv_dm__dbg
      ]
      mbx_jtag.soc_tl_d:
      [
        dbg.tl_mbx_jtag__soc
      ]
      lc_ctrl.dmi_tl:
      [
        dbg.tl_lc_ctrl__dmi
      ]
      soc_dbg_ctrl.jtag_tl:
      [
        dbg.tl_soc_dbg_ctrl__jtag
      ]
      racl_ctrl.racl_policies:
      [
        mbx0.racl_policies
        mbx1.racl_policies
        mbx2.racl_policies
        mbx3.racl_policies
        mbx4.racl_policies
        mbx5.racl_policies
        mbx6.racl_policies
        mbx_jtag.racl_policies
        mbx_pcie0.racl_policies
        mbx_pcie1.racl_policies
        ac_range_check.racl_policies
      ]
      racl_ctrl.racl_error:
      [
        mbx0.racl_error
        mbx1.racl_error
        mbx2.racl_error
        mbx3.racl_error
        mbx4.racl_error
        mbx5.racl_error
        mbx6.racl_error
        mbx_jtag.racl_error
        mbx_pcie0.racl_error
        mbx_pcie1.racl_error
        ac_range_check.racl_error
      ]
    }
    top:
    [
      clkmgr_aon.clocks
      clkmgr_aon.cg_en
      rstmgr_aon.resets
      rstmgr_aon.rst_en
      rv_core_ibex.irq_timer
      rv_core_ibex.hart_id
      rv_core_ibex.boot_addr
      otp_ctrl.otp_broadcast
      soc_dbg_ctrl.soc_dbg_state
      lc_ctrl.otp_device_id
      lc_ctrl.otp_manuf_state
      keymgr_dpe.otp_device_id
      sram_ctrl_main.otp_en_sram_ifetch
      rv_dm.otp_dis_rv_dm_late_debug
    ]
    external:
    {
      ast.edn: ""
      ast.lc_dft_en: ""
      ast.lc_hw_debug_en: ""
      ast.obs_ctrl: obs_ctrl
      rom_ctrl0.rom_cfg: rom_ctrl0_cfg
      rom_ctrl1.rom_cfg: rom_ctrl1_cfg
      i2c0.ram_cfg: i2c_ram_1p_cfg
      i2c0.ram_cfg_rsp: i2c_ram_1p_cfg_rsp
      sram_ctrl_ret_aon.cfg: sram_ctrl_ret_aon_ram_1p_cfg
      sram_ctrl_ret_aon.cfg_rsp: sram_ctrl_ret_aon_ram_1p_cfg_rsp
      sram_ctrl_main.cfg: sram_ctrl_main_ram_1p_cfg
      sram_ctrl_main.cfg_rsp: sram_ctrl_main_ram_1p_cfg_rsp
      sram_ctrl_mbox.cfg: sram_ctrl_mbox_ram_1p_cfg
      sram_ctrl_mbox.cfg_rsp: sram_ctrl_mbox_ram_1p_cfg_rsp
      otbn.ram_cfg_imem: otbn_imem_ram_1p_cfg
      otbn.ram_cfg_rsp_imem: otbn_imem_ram_1p_cfg_rsp
      otbn.ram_cfg_dmem: otbn_dmem_ram_1p_cfg
      otbn.ram_cfg_rsp_dmem: otbn_dmem_ram_1p_cfg_rsp
      rv_core_ibex.ram_cfg_icache_tag: rv_core_ibex_icache_tag_ram_1p_cfg
      rv_core_ibex.ram_cfg_rsp_icache_tag: rv_core_ibex_icache_tag_ram_1p_cfg_rsp
      rv_core_ibex.ram_cfg_icache_data: rv_core_ibex_icache_data_ram_1p_cfg
      rv_core_ibex.ram_cfg_rsp_icache_data: rv_core_ibex_icache_data_ram_1p_cfg_rsp
      spi_device.ram_cfg_sys2spi: spi_device_ram_2p_cfg_sys2spi
      spi_device.ram_cfg_rsp_sys2spi: spi_device_ram_2p_cfg_rsp_sys2spi
      spi_device.ram_cfg_rsp_spi2sys: spi_device_ram_2p_cfg_rsp_spi2sys
      spi_device.ram_cfg_spi2sys: spi_device_ram_2p_cfg_spi2sys
      pwrmgr_aon.boot_status: pwrmgr_boot_status
      clkmgr_aon.jitter_en: clk_main_jitter_en
      clkmgr_aon.io_clk_byp_req: io_clk_byp_req
      clkmgr_aon.io_clk_byp_ack: io_clk_byp_ack
      clkmgr_aon.all_clk_byp_req: all_clk_byp_req
      clkmgr_aon.all_clk_byp_ack: all_clk_byp_ack
      clkmgr_aon.hi_speed_sel: hi_speed_sel
      clkmgr_aon.div_step_down_req: div_step_down_req
      clkmgr_aon.calib_rdy: calib_rdy
      csrng.entropy_src_hw_if: entropy_src_hw_if
      dma.sys: dma_sys
      mbx.tl_mbx: mbx_tl
      mbx0.doe_intr: mbx0_doe_intr
      mbx0.doe_intr_en: mbx0_doe_intr_en
      mbx0.doe_intr_support: mbx0_doe_intr_support
      mbx0.doe_async_msg_support: mbx0_doe_async_msg_support
      mbx1.doe_intr: mbx1_doe_intr
      mbx1.doe_intr_en: mbx1_doe_intr_en
      mbx1.doe_intr_support: mbx1_doe_intr_support
      mbx1.doe_async_msg_support: mbx1_doe_async_msg_support
      mbx2.doe_intr: mbx2_doe_intr
      mbx2.doe_intr_en: mbx2_doe_intr_en
      mbx2.doe_intr_support: mbx2_doe_intr_support
      mbx2.doe_async_msg_support: mbx2_doe_async_msg_support
      mbx3.doe_intr: mbx3_doe_intr
      mbx3.doe_intr_en: mbx3_doe_intr_en
      mbx3.doe_intr_support: mbx3_doe_intr_support
      mbx3.doe_async_msg_support: mbx3_doe_async_msg_support
      mbx4.doe_intr: mbx4_doe_intr
      mbx4.doe_intr_en: mbx4_doe_intr_en
      mbx4.doe_intr_support: mbx4_doe_intr_support
      mbx4.doe_async_msg_support: mbx4_doe_async_msg_support
      mbx5.doe_intr: mbx5_doe_intr
      mbx5.doe_intr_en: mbx5_doe_intr_en
      mbx5.doe_intr_support: mbx5_doe_intr_support
      mbx5.doe_async_msg_support: mbx5_doe_async_msg_support
      mbx6.doe_intr: mbx6_doe_intr
      mbx6.doe_intr_en: mbx6_doe_intr_en
      mbx6.doe_intr_support: mbx6_doe_intr_support
      mbx6.doe_async_msg_support: mbx6_doe_async_msg_support
      mbx_jtag.doe_intr: mbx_jtag_doe_intr
      mbx_jtag.doe_intr_en: mbx_jtag_doe_intr_en
      mbx_jtag.doe_intr_support: mbx_jtag_doe_intr_support
      mbx_jtag.doe_async_msg_support: mbx_jtag_doe_async_msg_support
      mbx_pcie0.doe_intr: mbx_pcie0_doe_intr
      mbx_pcie0.doe_intr_en: mbx_pcie0_doe_intr_en
      mbx_pcie0.doe_intr_support: mbx_pcie0_doe_intr_support
      mbx_pcie0.doe_async_msg_support: mbx_pcie0_doe_async_msg_support
      mbx_pcie1.doe_intr: mbx_pcie1_doe_intr
      mbx_pcie1.doe_intr_en: mbx_pcie1_doe_intr_en
      mbx_pcie1.doe_intr_support: mbx_pcie1_doe_intr_support
      mbx_pcie1.doe_async_msg_support: mbx_pcie1_doe_async_msg_support
      dbg.tl_dbg: dbg_tl
      rv_dm.next_dm_addr: rv_dm_next_dm_addr
      peri.tl_ast: ast_tl
      pwrmgr_aon.pwr_ast: pwrmgr_ast
      otp_macro.pwr_seq: ""
      otp_macro.pwr_seq_h: ""
      otp_macro.ext_voltage_h: otp_ext_voltage_h
      otp_macro.otp_obs: otp_obs
      otp_macro.cfg: otp_cfg
      otp_macro.cfg_rsp: otp_cfg_rsp
      rstmgr_aon.por_n: por_n
      rv_core_ibex.fpga_info: fpga_info
      soc_proxy.misc_tl_h2d: ctn_misc_tl_h2d
      soc_proxy.misc_tl_d2h: ctn_misc_tl_d2h
      soc_proxy.soc_fatal_alert: soc_fatal_alert
      soc_proxy.soc_recov_alert: soc_recov_alert
      soc_proxy.soc_wkup_async: soc_wkup_async
      soc_proxy.soc_rst_req_async: soc_rst_req_async
      soc_proxy.soc_intr_async: soc_intr_async
      soc_proxy.soc_lsio_trigger: soc_lsio_trigger
      soc_proxy.soc_gpi_async: soc_gpi_async
      soc_proxy.soc_gpo_async: soc_gpo_async
      soc_proxy.integrator_id: integrator_id
      spi_device.sck_monitor: sck_monitor
      soc_dbg_ctrl.soc_dbg_policy_bus: soc_dbg_policy_bus
      soc_dbg_ctrl.halt_cpu_boot: debug_halt_cpu_boot
      racl_ctrl.racl_policies: racl_policies
      racl_ctrl.racl_error_external: racl_error
      ac_range_check.range_check_overwrite: ac_range_check_overwrite
      ac_range_check.ctn_filtered_tl_h2d: ctn_tl_h2d
      ac_range_check.ctn_filtered_tl_d2h: ctn_tl_d2h
    }
  }
  xbar:
  [
    {
      name: main
      clock_srcs:
      {
        clk_main_i: main
        clk_fixed_i: io_div4
      }
      clock_group: infra
      reset: rst_main_ni
      reset_connections:
      {
        rst_main_ni:
        {
          name: lc
          domain: "0"
        }
        rst_fixed_ni:
        {
          name: lc_io_div4
          domain: "0"
        }
      }
      clock_connections:
      {
        clk_main_i: clkmgr_aon_clocks.clk_main_infra
        clk_fixed_i: clkmgr_aon_clocks.clk_io_div4_infra
      }
      domain:
      [
        "0"
      ]
      connections:
      {
        rv_core_ibex.corei:
        [
          rom_ctrl0.rom
          rom_ctrl1.rom
          rv_dm.mem
          sram_ctrl_main.ram
          soc_proxy.ctn
        ]
        rv_core_ibex.cored:
        [
          rom_ctrl0.rom
          rom_ctrl0.regs
          rom_ctrl1.rom
          rom_ctrl1.regs
          rv_dm.mem
          rv_dm.regs
          sram_ctrl_main.ram
          peri
          aes
          csrng
          edn0
          edn1
          hmac
          rv_plic
          otbn
          keymgr_dpe
          kmac
          sram_ctrl_main.regs
          rv_core_ibex.cfg
          sram_ctrl_mbox.ram
          sram_ctrl_mbox.regs
          soc_proxy.ctn
          soc_proxy.core
          dma
          mbx0.core
          mbx1.core
          mbx2.core
          mbx3.core
          mbx4.core
          mbx5.core
          mbx6.core
          mbx_jtag.core
          mbx_pcie0.core
          mbx_pcie1.core
        ]
        rv_dm.sba:
        [
          rom_ctrl0.rom
          rom_ctrl0.regs
          rom_ctrl1.rom
          rom_ctrl1.regs
          rv_dm.mem
          rv_dm.regs
          sram_ctrl_main.ram
          peri
          aes
          csrng
          edn0
          edn1
          hmac
          rv_plic
          otbn
          keymgr_dpe
          kmac
          sram_ctrl_main.regs
          rv_core_ibex.cfg
          sram_ctrl_mbox.ram
          sram_ctrl_mbox.regs
          soc_proxy.ctn
          soc_proxy.core
          dma
          mbx0.core
          mbx1.core
          mbx2.core
          mbx3.core
          mbx4.core
          mbx5.core
          mbx6.core
          mbx_jtag.core
          mbx_pcie0.core
          mbx_pcie1.core
        ]
        dma.host:
        [
          sram_ctrl_main.ram
          sram_ctrl_mbox.ram
          aes
          hmac
          otbn
          keymgr_dpe
          kmac
          soc_proxy.ctn
          peri
        ]
        mbx0.sram:
        [
          sram_ctrl_mbox.ram
        ]
        mbx1.sram:
        [
          sram_ctrl_mbox.ram
        ]
        mbx2.sram:
        [
          sram_ctrl_mbox.ram
        ]
        mbx3.sram:
        [
          sram_ctrl_mbox.ram
        ]
        mbx4.sram:
        [
          sram_ctrl_mbox.ram
        ]
        mbx5.sram:
        [
          sram_ctrl_mbox.ram
        ]
        mbx6.sram:
        [
          sram_ctrl_mbox.ram
        ]
        mbx_jtag.sram:
        [
          sram_ctrl_mbox.ram
        ]
        mbx_pcie0.sram:
        [
          sram_ctrl_mbox.ram
        ]
        mbx_pcie1.sram:
        [
          sram_ctrl_mbox.ram
        ]
      }
      nodes:
      [
        {
          name: rv_core_ibex.corei
          type: host
          addr_space: hart
          clock: clk_main_i
          reset: rst_main_ni
          pipeline: false
          xbar: false
          stub: false
          inst_type: ""
          req_fifo_pass: true
          rsp_fifo_pass: true
        }
        {
          name: rv_core_ibex.cored
          type: host
          addr_space: hart
          clock: clk_main_i
          reset: rst_main_ni
          pipeline: false
          xbar: false
          stub: false
          inst_type: ""
          req_fifo_pass: true
          rsp_fifo_pass: true
        }
        {
          name: rv_dm.sba
          type: host
          addr_space: hart
          clock: clk_main_i
          reset: rst_main_ni
          req_fifo_pass: false
          rsp_fifo_pass: false
          xbar: false
          stub: false
          inst_type: ""
          pipeline: true
        }
        {
          name: rv_dm.regs
          type: device
          clock: clk_main_i
          reset: rst_main_ni
          req_fifo_pass: false
          rsp_fifo_pass: false
          inst_type: rv_dm
          addr_range:
          [
            {
              base_addrs:
              {
                hart: 0x21200000
              }
              size_byte: 0x10
            }
          ]
          xbar: false
          stub: false
          pipeline: true
        }
        {
          name: rv_dm.mem
          type: device
          clock: clk_main_i
          reset: rst_main_ni
          req_fifo_pass: false
          rsp_fifo_pass: false
          inst_type: rv_dm
          addr_range:
          [
            {
              base_addrs:
              {
                hart: 0x40000
              }
              size_byte: 0x1000
            }
          ]
          xbar: false
          stub: false
          pipeline: true
        }
        {
          name: rom_ctrl0.rom
          type: device
          clock: clk_main_i
          reset: rst_main_ni
          req_fifo_pass: true
          rsp_fifo_pass: false
          inst_type: rom_ctrl
          addr_range:
          [
            {
              base_addrs:
              {
                hart: 0x8000
              }
              size_byte: 0x8000
            }
          ]
          xbar: false
          stub: false
          pipeline: true
        }
        {
          name: rom_ctrl0.regs
          type: device
          clock: clk_main_i
          reset: rst_main_ni
          req_fifo_pass: false
          rsp_fifo_pass: false
          inst_type: rom_ctrl
          addr_range:
          [
            {
              base_addrs:
              {
                hart: 0x211e0000
              }
              size_byte: 0x80
            }
          ]
          xbar: false
          stub: false
          pipeline: true
        }
        {
          name: rom_ctrl1.rom
          type: device
          clock: clk_main_i
          reset: rst_main_ni
          req_fifo_pass: true
          rsp_fifo_pass: false
          inst_type: rom_ctrl
          addr_range:
          [
            {
              base_addrs:
              {
                hart: 0x20000
              }
              size_byte: 0x10000
            }
          ]
          xbar: false
          stub: false
          pipeline: true
        }
        {
          name: rom_ctrl1.regs
          type: device
          clock: clk_main_i
          reset: rst_main_ni
          req_fifo_pass: false
          rsp_fifo_pass: false
          inst_type: rom_ctrl
          addr_range:
          [
            {
              base_addrs:
              {
                hart: 0x211e1000
              }
              size_byte: 0x80
            }
          ]
          xbar: false
          stub: false
          pipeline: true
        }
        {
          name: peri
          type: device
          clock: clk_fixed_i
          reset: rst_fixed_ni
          req_fifo_pass: false
          rsp_fifo_pass: false
          xbar: true
          stub: false
          pipeline: true
          addr_space: hart
          addr_range:
          [
            {
              base_addrs:
              {
                hart: 0x30000000
              }
              size_byte: 0x800000
            }
          ]
        }
        {
          name: soc_proxy.core
          type: device
          clock: clk_main_i
          reset: rst_main_ni
          req_fifo_pass: false
          rsp_fifo_pass: false
          inst_type: soc_proxy
          addr_range:
          [
            {
              base_addrs:
              {
                hart: 0x22030000
              }
              size_byte: 0x10
            }
          ]
          xbar: false
          stub: false
          pipeline: true
        }
        {
          name: soc_proxy.ctn
          type: device
          clock: clk_main_i
          reset: rst_main_ni
          pipeline: false
          inst_type: soc_proxy
          addr_range:
          [
            {
              base_addrs:
              {
                hart: 0x40000000
              }
              size_byte: 0x40000000
            }
          ]
          xbar: false
          stub: false
          req_fifo_pass: true
        }
        {
          name: hmac
          type: device
          clock: clk_main_i
          reset: rst_main_ni
          req_fifo_pass: false
          rsp_fifo_pass: false
          inst_type: hmac
          addr_range:
          [
            {
              base_addrs:
              {
                hart: 0x21110000
              }
              size_byte: 0x2000
            }
          ]
          xbar: false
          stub: false
          pipeline: true
        }
        {
          name: kmac
          type: device
          clock: clk_main_i
          reset: rst_main_ni
          req_fifo_pass: false
          rsp_fifo_pass: false
          inst_type: kmac
          addr_range:
          [
            {
              base_addrs:
              {
                hart: 0x21120000
              }
              size_byte: 0x1000
            }
          ]
          xbar: false
          stub: false
          pipeline: true
        }
        {
          name: aes
          type: device
          clock: clk_main_i
          reset: rst_main_ni
          req_fifo_pass: false
          rsp_fifo_pass: false
          inst_type: aes
          addr_range:
          [
            {
              base_addrs:
              {
                hart: 0x21100000
              }
              size_byte: 0x100
            }
          ]
          xbar: false
          stub: false
          pipeline: true
        }
        {
          name: csrng
          type: device
          clock: clk_main_i
          reset: rst_main_ni
          req_fifo_pass: false
          rsp_fifo_pass: false
          inst_type: csrng
          addr_range:
          [
            {
              base_addrs:
              {
                hart: 0x21150000
              }
              size_byte: 0x80
            }
          ]
          xbar: false
          stub: false
          pipeline: true
        }
        {
          name: edn0
          type: device
          clock: clk_main_i
          reset: rst_main_ni
          req_fifo_pass: false
          rsp_fifo_pass: false
          inst_type: edn
          addr_range:
          [
            {
              base_addrs:
              {
                hart: 0x21170000
              }
              size_byte: 0x80
            }
          ]
          xbar: false
          stub: false
          pipeline: true
        }
        {
          name: edn1
          type: device
          clock: clk_main_i
          reset: rst_main_ni
          req_fifo_pass: false
          rsp_fifo_pass: false
          inst_type: edn
          addr_range:
          [
            {
              base_addrs:
              {
                hart: 0x21180000
              }
              size_byte: 0x80
            }
          ]
          xbar: false
          stub: false
          pipeline: true
        }
        {
          name: rv_plic
          type: device
          clock: clk_main_i
          reset: rst_main_ni
          inst_type: rv_plic
          req_fifo_pass: false
          rsp_fifo_pass: false
          addr_range:
          [
            {
              base_addrs:
              {
                hart: 0x28000000
              }
              size_byte: 0x8000000
            }
          ]
          xbar: false
          stub: false
          pipeline: true
        }
        {
          name: otbn
          type: device
          clock: clk_main_i
          reset: rst_main_ni
          req_fifo_pass: false
          rsp_fifo_pass: false
          inst_type: otbn
          addr_range:
          [
            {
              base_addrs:
              {
                hart: 0x21130000
              }
              size_byte: 0x10000
            }
          ]
          xbar: false
          stub: false
          pipeline: true
        }
        {
          name: keymgr_dpe
          type: device
          clock: clk_main_i
          reset: rst_main_ni
          req_fifo_pass: false
          rsp_fifo_pass: false
          inst_type: keymgr_dpe
          addr_range:
          [
            {
              base_addrs:
              {
                hart: 0x21140000
              }
              size_byte: 0x100
            }
          ]
          xbar: false
          stub: false
          pipeline: true
        }
        {
          name: rv_core_ibex.cfg
          type: device
          clock: clk_main_i
          reset: rst_main_ni
          req_fifo_pass: false
          rsp_fifo_pass: false
          inst_type: rv_core_ibex
          addr_range:
          [
            {
              base_addrs:
              {
                hart: 0x211f0000
              }
              size_byte: 0x800
            }
          ]
          xbar: false
          stub: false
          pipeline: true
        }
        {
          name: sram_ctrl_main.regs
          type: device
          clock: clk_main_i
          reset: rst_main_ni
          req_fifo_pass: false
          rsp_fifo_pass: false
          inst_type: sram_ctrl
          addr_range:
          [
            {
              base_addrs:
              {
                hart: 0x211c0000
              }
              size_byte: 0x40
            }
          ]
          xbar: false
          stub: false
          pipeline: true
        }
        {
          name: sram_ctrl_main.ram
          type: device
          clock: clk_main_i
          reset: rst_main_ni
          pipeline: false
          inst_type: sram_ctrl
          addr_range:
          [
            {
              base_addrs:
              {
                hart: 0x10000000
              }
              size_byte: 0x10000
            }
          ]
          xbar: false
          stub: false
          req_fifo_pass: true
        }
        {
          name: sram_ctrl_mbox.regs
          type: device
          clock: clk_main_i
          reset: rst_main_ni
          pipeline: false
          inst_type: sram_ctrl
          addr_range:
          [
            {
              base_addrs:
              {
                hart: 0x211d0000
              }
              size_byte: 0x40
            }
          ]
          xbar: false
          stub: false
          req_fifo_pass: true
        }
        {
          name: sram_ctrl_mbox.ram
          type: device
          clock: clk_main_i
          reset: rst_main_ni
          pipeline: false
          inst_type: sram_ctrl
          addr_range:
          [
            {
              base_addrs:
              {
                hart: 0x11000000
              }
              size_byte: 0x1000
            }
          ]
          xbar: false
          stub: false
          req_fifo_pass: true
        }
        {
          name: dma
          type: device
          clock: clk_main_i
          reset: rst_main_ni
          req_fifo_pass: false
          rsp_fifo_pass: false
          inst_type: dma
          addr_range:
          [
            {
              base_addrs:
              {
                hart: 0x22010000
              }
              size_byte: 0x200
            }
          ]
          xbar: false
          stub: false
          pipeline: true
        }
        {
          name: dma.host
          type: host
          addr_space: hart
          clock: clk_main_i
          reset: rst_main_ni
          pipeline: false
          xbar: false
          stub: false
          inst_type: ""
          req_fifo_pass: true
          rsp_fifo_pass: true
        }
        {
          name: mbx0.core
          type: device
          addr_space: hart
          clock: clk_main_i
          reset: rst_main_ni
          pipeline: false
          inst_type: mbx
          addr_range:
          [
            {
              base_addrs:
              {
                hart: 0x22000000
              }
              size_byte: 0x80
            }
          ]
          xbar: false
          stub: false
          req_fifo_pass: true
        }
        {
          name: mbx0.sram
          type: host
          addr_space: hart
          clock: clk_main_i
          reset: rst_main_ni
          pipeline: false
          xbar: false
          stub: false
          inst_type: ""
          req_fifo_pass: true
          rsp_fifo_pass: true
        }
        {
          name: mbx1.core
          type: device
          addr_space: hart
          clock: clk_main_i
          reset: rst_main_ni
          pipeline: false
          inst_type: mbx
          addr_range:
          [
            {
              base_addrs:
              {
                hart: 0x22000100
              }
              size_byte: 0x80
            }
          ]
          xbar: false
          stub: false
          req_fifo_pass: true
        }
        {
          name: mbx1.sram
          type: host
          addr_space: hart
          clock: clk_main_i
          reset: rst_main_ni
          pipeline: false
          xbar: false
          stub: false
          inst_type: ""
          req_fifo_pass: true
          rsp_fifo_pass: true
        }
        {
          name: mbx2.core
          type: device
          addr_space: hart
          clock: clk_main_i
          reset: rst_main_ni
          pipeline: false
          inst_type: mbx
          addr_range:
          [
            {
              base_addrs:
              {
                hart: 0x22000200
              }
              size_byte: 0x80
            }
          ]
          xbar: false
          stub: false
          req_fifo_pass: true
        }
        {
          name: mbx2.sram
          type: host
          addr_space: hart
          clock: clk_main_i
          reset: rst_main_ni
          pipeline: false
          xbar: false
          stub: false
          inst_type: ""
          req_fifo_pass: true
          rsp_fifo_pass: true
        }
        {
          name: mbx3.core
          type: device
          addr_space: hart
          clock: clk_main_i
          reset: rst_main_ni
          pipeline: false
          inst_type: mbx
          addr_range:
          [
            {
              base_addrs:
              {
                hart: 0x22000300
              }
              size_byte: 0x80
            }
          ]
          xbar: false
          stub: false
          req_fifo_pass: true
        }
        {
          name: mbx3.sram
          type: host
          addr_space: hart
          clock: clk_main_i
          reset: rst_main_ni
          pipeline: false
          xbar: false
          stub: false
          inst_type: ""
          req_fifo_pass: true
          rsp_fifo_pass: true
        }
        {
          name: mbx4.core
          type: device
          addr_space: hart
          clock: clk_main_i
          reset: rst_main_ni
          pipeline: false
          inst_type: mbx
          addr_range:
          [
            {
              base_addrs:
              {
                hart: 0x22000400
              }
              size_byte: 0x80
            }
          ]
          xbar: false
          stub: false
          req_fifo_pass: true
        }
        {
          name: mbx4.sram
          type: host
          addr_space: hart
          clock: clk_main_i
          reset: rst_main_ni
          pipeline: false
          xbar: false
          stub: false
          inst_type: ""
          req_fifo_pass: true
          rsp_fifo_pass: true
        }
        {
          name: mbx5.core
          type: device
          addr_space: hart
          clock: clk_main_i
          reset: rst_main_ni
          pipeline: false
          inst_type: mbx
          addr_range:
          [
            {
              base_addrs:
              {
                hart: 0x22000500
              }
              size_byte: 0x80
            }
          ]
          xbar: false
          stub: false
          req_fifo_pass: true
        }
        {
          name: mbx5.sram
          type: host
          addr_space: hart
          clock: clk_main_i
          reset: rst_main_ni
          pipeline: false
          xbar: false
          stub: false
          inst_type: ""
          req_fifo_pass: true
          rsp_fifo_pass: true
        }
        {
          name: mbx6.core
          type: device
          addr_space: hart
          clock: clk_main_i
          reset: rst_main_ni
          pipeline: false
          inst_type: mbx
          addr_range:
          [
            {
              base_addrs:
              {
                hart: 0x22000600
              }
              size_byte: 0x80
            }
          ]
          xbar: false
          stub: false
          req_fifo_pass: true
        }
        {
          name: mbx6.sram
          type: host
          addr_space: hart
          clock: clk_main_i
          reset: rst_main_ni
          pipeline: false
          xbar: false
          stub: false
          inst_type: ""
          req_fifo_pass: true
          rsp_fifo_pass: true
        }
        {
          name: mbx_jtag.core
          type: device
          addr_space: hart
          clock: clk_main_i
          reset: rst_main_ni
          pipeline: false
          inst_type: mbx
          addr_range:
          [
            {
              base_addrs:
              {
                hart: 0x22000800
              }
              size_byte: 0x80
            }
          ]
          xbar: false
          stub: false
          req_fifo_pass: true
        }
        {
          name: mbx_jtag.sram
          type: host
          addr_space: hart
          clock: clk_main_i
          reset: rst_main_ni
          pipeline: false
          xbar: false
          stub: false
          inst_type: ""
          req_fifo_pass: true
          rsp_fifo_pass: true
        }
        {
          name: mbx_pcie0.core
          type: device
          addr_space: hart
          clock: clk_main_i
          reset: rst_main_ni
          pipeline: false
          inst_type: mbx
          addr_range:
          [
            {
              base_addrs:
              {
                hart: 0x22040000
              }
              size_byte: 0x80
            }
          ]
          xbar: false
          stub: false
          req_fifo_pass: true
        }
        {
          name: mbx_pcie0.sram
          type: host
          addr_space: hart
          clock: clk_main_i
          reset: rst_main_ni
          pipeline: false
          xbar: false
          stub: false
          inst_type: ""
          req_fifo_pass: true
          rsp_fifo_pass: true
        }
        {
          name: mbx_pcie1.core
          type: device
          addr_space: hart
          clock: clk_main_i
          reset: rst_main_ni
          pipeline: false
          inst_type: mbx
          addr_range:
          [
            {
              base_addrs:
              {
                hart: 0x22040100
              }
              size_byte: 0x80
            }
          ]
          xbar: false
          stub: false
          req_fifo_pass: true
        }
        {
          name: mbx_pcie1.sram
          type: host
          addr_space: hart
          clock: clk_main_i
          reset: rst_main_ni
          pipeline: false
          xbar: false
          stub: false
          inst_type: ""
          req_fifo_pass: true
          rsp_fifo_pass: true
        }
      ]
      addr_spaces:
      [
        hart
      ]
      clock: clk_main_i
      type: xbar
      inter_signal_list:
      [
        {
          name: tl_rv_core_ibex__corei
          struct: tl
          package: tlul_pkg
          type: req_rsp
          act: rsp
          inst_name: main
          width: 1
          default: ""
          end_idx: -1
          top_signame: main_tl_rv_core_ibex__corei
          index: -1
        }
        {
          name: tl_rv_core_ibex__cored
          struct: tl
          package: tlul_pkg
          type: req_rsp
          act: rsp
          inst_name: main
          width: 1
          default: ""
          end_idx: -1
          top_signame: main_tl_rv_core_ibex__cored
          index: -1
        }
        {
          name: tl_rv_dm__sba
          struct: tl
          package: tlul_pkg
          type: req_rsp
          act: rsp
          inst_name: main
          width: 1
          default: ""
          end_idx: -1
          top_signame: main_tl_rv_dm__sba
          index: -1
        }
        {
          name: tl_dma__host
          struct: tl
          package: tlul_pkg
          type: req_rsp
          act: rsp
          inst_name: main
          width: 1
          default: ""
          end_idx: -1
          top_signame: main_tl_dma__host
          index: -1
        }
        {
          name: tl_mbx0__sram
          struct: tl
          package: tlul_pkg
          type: req_rsp
          act: rsp
          inst_name: main
          width: 1
          default: ""
          end_idx: -1
          top_signame: main_tl_mbx0__sram
          index: -1
        }
        {
          name: tl_mbx1__sram
          struct: tl
          package: tlul_pkg
          type: req_rsp
          act: rsp
          inst_name: main
          width: 1
          default: ""
          end_idx: -1
          top_signame: main_tl_mbx1__sram
          index: -1
        }
        {
          name: tl_mbx2__sram
          struct: tl
          package: tlul_pkg
          type: req_rsp
          act: rsp
          inst_name: main
          width: 1
          default: ""
          end_idx: -1
          top_signame: main_tl_mbx2__sram
          index: -1
        }
        {
          name: tl_mbx3__sram
          struct: tl
          package: tlul_pkg
          type: req_rsp
          act: rsp
          inst_name: main
          width: 1
          default: ""
          end_idx: -1
          top_signame: main_tl_mbx3__sram
          index: -1
        }
        {
          name: tl_mbx4__sram
          struct: tl
          package: tlul_pkg
          type: req_rsp
          act: rsp
          inst_name: main
          width: 1
          default: ""
          end_idx: -1
          top_signame: main_tl_mbx4__sram
          index: -1
        }
        {
          name: tl_mbx5__sram
          struct: tl
          package: tlul_pkg
          type: req_rsp
          act: rsp
          inst_name: main
          width: 1
          default: ""
          end_idx: -1
          top_signame: main_tl_mbx5__sram
          index: -1
        }
        {
          name: tl_mbx6__sram
          struct: tl
          package: tlul_pkg
          type: req_rsp
          act: rsp
          inst_name: main
          width: 1
          default: ""
          end_idx: -1
          top_signame: main_tl_mbx6__sram
          index: -1
        }
        {
          name: tl_mbx_jtag__sram
          struct: tl
          package: tlul_pkg
          type: req_rsp
          act: rsp
          inst_name: main
          width: 1
          default: ""
          end_idx: -1
          top_signame: main_tl_mbx_jtag__sram
          index: -1
        }
        {
          name: tl_mbx_pcie0__sram
          struct: tl
          package: tlul_pkg
          type: req_rsp
          act: rsp
          inst_name: main
          width: 1
          default: ""
          end_idx: -1
          top_signame: main_tl_mbx_pcie0__sram
          index: -1
        }
        {
          name: tl_mbx_pcie1__sram
          struct: tl
          package: tlul_pkg
          type: req_rsp
          act: rsp
          inst_name: main
          width: 1
          default: ""
          end_idx: -1
          top_signame: main_tl_mbx_pcie1__sram
          index: -1
        }
        {
          name: tl_rv_dm__regs
          struct: tl
          package: tlul_pkg
          type: req_rsp
          act: req
          inst_name: main
          width: 1
          default: ""
          top_signame: rv_dm_regs_tl_d
          index: -1
        }
        {
          name: tl_rv_dm__mem
          struct: tl
          package: tlul_pkg
          type: req_rsp
          act: req
          inst_name: main
          width: 1
          default: ""
          top_signame: rv_dm_mem_tl_d
          index: -1
        }
        {
          name: tl_rom_ctrl0__rom
          struct: tl
          package: tlul_pkg
          type: req_rsp
          act: req
          inst_name: main
          width: 1
          default: ""
          top_signame: rom_ctrl0_rom_tl
          index: -1
        }
        {
          name: tl_rom_ctrl0__regs
          struct: tl
          package: tlul_pkg
          type: req_rsp
          act: req
          inst_name: main
          width: 1
          default: ""
          top_signame: rom_ctrl0_regs_tl
          index: -1
        }
        {
          name: tl_rom_ctrl1__rom
          struct: tl
          package: tlul_pkg
          type: req_rsp
          act: req
          inst_name: main
          width: 1
          default: ""
          top_signame: rom_ctrl1_rom_tl
          index: -1
        }
        {
          name: tl_rom_ctrl1__regs
          struct: tl
          package: tlul_pkg
          type: req_rsp
          act: req
          inst_name: main
          width: 1
          default: ""
          top_signame: rom_ctrl1_regs_tl
          index: -1
        }
        {
          name: tl_peri
          struct: tl
          package: tlul_pkg
          type: req_rsp
          act: req
          inst_name: main
          width: 1
          default: ""
          end_idx: -1
          top_signame: main_tl_peri
          index: -1
        }
        {
          name: tl_soc_proxy__core
          struct: tl
          package: tlul_pkg
          type: req_rsp
          act: req
          inst_name: main
          width: 1
          default: ""
          top_signame: soc_proxy_core_tl
          index: -1
        }
        {
          name: tl_soc_proxy__ctn
          struct: tl
          package: tlul_pkg
          type: req_rsp
          act: req
          inst_name: main
          width: 1
          default: ""
          top_signame: soc_proxy_ctn_tl
          index: -1
        }
        {
          name: tl_hmac
          struct: tl
          package: tlul_pkg
          type: req_rsp
          act: req
          inst_name: main
          width: 1
          default: ""
          top_signame: hmac_tl
          index: -1
        }
        {
          name: tl_kmac
          struct: tl
          package: tlul_pkg
          type: req_rsp
          act: req
          inst_name: main
          width: 1
          default: ""
          top_signame: kmac_tl
          index: -1
        }
        {
          name: tl_aes
          struct: tl
          package: tlul_pkg
          type: req_rsp
          act: req
          inst_name: main
          width: 1
          default: ""
          top_signame: aes_tl
          index: -1
        }
        {
          name: tl_csrng
          struct: tl
          package: tlul_pkg
          type: req_rsp
          act: req
          inst_name: main
          width: 1
          default: ""
          top_signame: csrng_tl
          index: -1
        }
        {
          name: tl_edn0
          struct: tl
          package: tlul_pkg
          type: req_rsp
          act: req
          inst_name: main
          width: 1
          default: ""
          top_signame: edn0_tl
          index: -1
        }
        {
          name: tl_edn1
          struct: tl
          package: tlul_pkg
          type: req_rsp
          act: req
          inst_name: main
          width: 1
          default: ""
          top_signame: edn1_tl
          index: -1
        }
        {
          name: tl_rv_plic
          struct: tl
          package: tlul_pkg
          type: req_rsp
          act: req
          inst_name: main
          width: 1
          default: ""
          top_signame: rv_plic_tl
          index: -1
        }
        {
          name: tl_otbn
          struct: tl
          package: tlul_pkg
          type: req_rsp
          act: req
          inst_name: main
          width: 1
          default: ""
          top_signame: otbn_tl
          index: -1
        }
        {
          name: tl_keymgr_dpe
          struct: tl
          package: tlul_pkg
          type: req_rsp
          act: req
          inst_name: main
          width: 1
          default: ""
          top_signame: keymgr_dpe_tl
          index: -1
        }
        {
          name: tl_rv_core_ibex__cfg
          struct: tl
          package: tlul_pkg
          type: req_rsp
          act: req
          inst_name: main
          width: 1
          default: ""
          top_signame: rv_core_ibex_cfg_tl_d
          index: -1
        }
        {
          name: tl_sram_ctrl_main__regs
          struct: tl
          package: tlul_pkg
          type: req_rsp
          act: req
          inst_name: main
          width: 1
          default: ""
          top_signame: sram_ctrl_main_regs_tl
          index: -1
        }
        {
          name: tl_sram_ctrl_main__ram
          struct: tl
          package: tlul_pkg
          type: req_rsp
          act: req
          inst_name: main
          width: 1
          default: ""
          top_signame: sram_ctrl_main_ram_tl
          index: -1
        }
        {
          name: tl_sram_ctrl_mbox__regs
          struct: tl
          package: tlul_pkg
          type: req_rsp
          act: req
          inst_name: main
          width: 1
          default: ""
          top_signame: sram_ctrl_mbox_regs_tl
          index: -1
        }
        {
          name: tl_sram_ctrl_mbox__ram
          struct: tl
          package: tlul_pkg
          type: req_rsp
          act: req
          inst_name: main
          width: 1
          default: ""
          top_signame: sram_ctrl_mbox_ram_tl
          index: -1
        }
        {
          name: tl_dma
          struct: tl
          package: tlul_pkg
          type: req_rsp
          act: req
          inst_name: main
          width: 1
          default: ""
          top_signame: dma_tl_d
          index: -1
        }
        {
          name: tl_mbx0__core
          struct: tl
          package: tlul_pkg
          type: req_rsp
          act: req
          inst_name: main
          width: 1
          default: ""
          top_signame: mbx0_core_tl_d
          index: -1
        }
        {
          name: tl_mbx1__core
          struct: tl
          package: tlul_pkg
          type: req_rsp
          act: req
          inst_name: main
          width: 1
          default: ""
          top_signame: mbx1_core_tl_d
          index: -1
        }
        {
          name: tl_mbx2__core
          struct: tl
          package: tlul_pkg
          type: req_rsp
          act: req
          inst_name: main
          width: 1
          default: ""
          top_signame: mbx2_core_tl_d
          index: -1
        }
        {
          name: tl_mbx3__core
          struct: tl
          package: tlul_pkg
          type: req_rsp
          act: req
          inst_name: main
          width: 1
          default: ""
          top_signame: mbx3_core_tl_d
          index: -1
        }
        {
          name: tl_mbx4__core
          struct: tl
          package: tlul_pkg
          type: req_rsp
          act: req
          inst_name: main
          width: 1
          default: ""
          top_signame: mbx4_core_tl_d
          index: -1
        }
        {
          name: tl_mbx5__core
          struct: tl
          package: tlul_pkg
          type: req_rsp
          act: req
          inst_name: main
          width: 1
          default: ""
          top_signame: mbx5_core_tl_d
          index: -1
        }
        {
          name: tl_mbx6__core
          struct: tl
          package: tlul_pkg
          type: req_rsp
          act: req
          inst_name: main
          width: 1
          default: ""
          top_signame: mbx6_core_tl_d
          index: -1
        }
        {
          name: tl_mbx_jtag__core
          struct: tl
          package: tlul_pkg
          type: req_rsp
          act: req
          inst_name: main
          width: 1
          default: ""
          top_signame: mbx_jtag_core_tl_d
          index: -1
        }
        {
          name: tl_mbx_pcie0__core
          struct: tl
          package: tlul_pkg
          type: req_rsp
          act: req
          inst_name: main
          width: 1
          default: ""
          top_signame: mbx_pcie0_core_tl_d
          index: -1
        }
        {
          name: tl_mbx_pcie1__core
          struct: tl
          package: tlul_pkg
          type: req_rsp
          act: req
          inst_name: main
          width: 1
          default: ""
          top_signame: mbx_pcie1_core_tl_d
          index: -1
        }
      ]
    }
    {
      name: peri
      clock_srcs:
      {
        clk_peri_i: io_div4
      }
      clock_group: infra
      reset: rst_peri_ni
      reset_connections:
      {
        rst_peri_ni:
        {
          name: lc_io_div4
          domain: "0"
        }
      }
      clock_connections:
      {
        clk_peri_i: clkmgr_aon_clocks.clk_io_div4_infra
      }
      domain:
      [
        "0"
      ]
      connections:
      {
        main:
        [
          uart0
          i2c0
          gpio
          spi_host0
          spi_device
          rv_timer
          pwrmgr_aon
          rstmgr_aon
          clkmgr_aon
          pinmux_aon
          otp_ctrl.core
          otp_macro
          lc_ctrl.regs
          alert_handler
          ast
          sram_ctrl_ret_aon.ram
          sram_ctrl_ret_aon.regs
          aon_timer_aon
          soc_dbg_ctrl.core
        ]
      }
      nodes:
      [
        {
          name: main
          type: host
          addr_space: hart
          clock: clk_peri_i
          reset: rst_peri_ni
          xbar: true
          pipeline: false
          stub: false
          inst_type: ""
          req_fifo_pass: true
          rsp_fifo_pass: true
        }
        {
          name: uart0
          type: device
          clock: clk_peri_i
          reset: rst_peri_ni
          pipeline: false
          inst_type: uart
          addr_range:
          [
            {
              base_addrs:
              {
                hart: 0x30010000
              }
              size_byte: 0x40
            }
          ]
          xbar: false
          stub: false
          req_fifo_pass: true
        }
        {
          name: i2c0
          type: device
          clock: clk_peri_i
          reset: rst_peri_ni
          pipeline: false
          inst_type: i2c
          addr_range:
          [
            {
              base_addrs:
              {
                hart: 0x30080000
              }
              size_byte: 0x80
            }
          ]
          xbar: false
          stub: false
          req_fifo_pass: true
        }
        {
          name: gpio
          type: device
          clock: clk_peri_i
          reset: rst_peri_ni
          pipeline: false
          inst_type: gpio
          addr_range:
          [
            {
              base_addrs:
              {
                hart: 0x30000000
              }
              size_byte: 0x100
            }
          ]
          xbar: false
          stub: false
          req_fifo_pass: true
        }
        {
          name: spi_host0
          type: device
          clock: clk_peri_i
          reset: rst_peri_ni
          pipeline: false
          inst_type: spi_host
          addr_range:
          [
            {
              base_addrs:
              {
                hart: 0x30300000
              }
              size_byte: 0x40
            }
          ]
          xbar: false
          stub: false
          req_fifo_pass: true
        }
        {
          name: spi_device
          type: device
          clock: clk_peri_i
          reset: rst_peri_ni
          pipeline: false
          inst_type: spi_device
          addr_range:
          [
            {
              base_addrs:
              {
                hart: 0x30310000
              }
              size_byte: 0x2000
            }
          ]
          xbar: false
          stub: false
          req_fifo_pass: true
        }
        {
          name: rv_timer
          type: device
          clock: clk_peri_i
          reset: rst_peri_ni
          pipeline: false
          inst_type: rv_timer
          addr_range:
          [
            {
              base_addrs:
              {
                hart: 0x30100000
              }
              size_byte: 0x200
            }
          ]
          xbar: false
          stub: false
          req_fifo_pass: true
        }
        {
          name: pwrmgr_aon
          type: device
          clock: clk_peri_i
          reset: rst_peri_ni
          pipeline: false
          inst_type: pwrmgr
          addr_range:
          [
            {
              base_addrs:
              {
                hart: 0x30400000
              }
              size_byte: 0x80
            }
          ]
          xbar: false
          stub: false
          req_fifo_pass: true
        }
        {
          name: rstmgr_aon
          type: device
          clock: clk_peri_i
          reset: rst_peri_ni
          pipeline: false
          inst_type: rstmgr
          addr_range:
          [
            {
              base_addrs:
              {
                hart: 0x30410000
              }
              size_byte: 0x80
            }
          ]
          xbar: false
          stub: false
          req_fifo_pass: true
        }
        {
          name: clkmgr_aon
          type: device
          clock: clk_peri_i
          reset: rst_peri_ni
          pipeline: false
          inst_type: clkmgr
          addr_range:
          [
            {
              base_addrs:
              {
                hart: 0x30420000
              }
              size_byte: 0x40
            }
          ]
          xbar: false
          stub: false
          req_fifo_pass: true
        }
        {
          name: pinmux_aon
          type: device
          clock: clk_peri_i
          reset: rst_peri_ni
          pipeline: false
          inst_type: pinmux
          addr_range:
          [
            {
              base_addrs:
              {
                hart: 0x30460000
              }
              size_byte: 0x800
            }
          ]
          xbar: false
          stub: false
          req_fifo_pass: true
        }
        {
          name: otp_ctrl.core
          type: device
          clock: clk_peri_i
          reset: rst_peri_ni
          pipeline: false
          inst_type: otp_ctrl
          addr_range:
          [
            {
              base_addrs:
              {
                hart: 0x30130000
              }
              size_byte: 0x8000
            }
          ]
          xbar: false
          stub: false
          req_fifo_pass: true
        }
        {
          name: otp_macro
          type: device
          clock: clk_peri_i
          reset: rst_peri_ni
          pipeline: false
          inst_type: otp_macro
          addr_range:
          [
            {
              base_addrs:
              {
                hart: 0x30140000
              }
              size_byte: 0x20
            }
          ]
          xbar: false
          stub: false
          req_fifo_pass: true
        }
        {
          name: lc_ctrl.regs
          type: device
          clock: clk_peri_i
          reset: rst_peri_ni
          pipeline: false
          inst_type: lc_ctrl
          addr_range:
          [
            {
              base_addrs:
              {
                hart: 0x30150000
              }
              size_byte: 0x100
            }
          ]
          xbar: false
          stub: false
          req_fifo_pass: true
        }
        {
          name: alert_handler
          type: device
          clock: clk_peri_i
          reset: rst_peri_ni
          pipeline: false
          inst_type: alert_handler
          addr_range:
          [
            {
              base_addrs:
              {
                hart: 0x30160000
              }
              size_byte: 0x800
            }
          ]
          xbar: false
          stub: false
          req_fifo_pass: true
        }
        {
          name: sram_ctrl_ret_aon.regs
          type: device
          clock: clk_peri_i
          reset: rst_peri_ni
          pipeline: false
          inst_type: sram_ctrl
          addr_range:
          [
            {
              base_addrs:
              {
                hart: 0x30500000
              }
              size_byte: 0x40
            }
          ]
          xbar: false
          stub: false
          req_fifo_pass: true
        }
        {
          name: sram_ctrl_ret_aon.ram
          type: device
          clock: clk_peri_i
          reset: rst_peri_ni
          pipeline: false
          inst_type: sram_ctrl
          addr_range:
          [
            {
              base_addrs:
              {
                hart: 0x30600000
              }
              size_byte: 0x1000
            }
          ]
          xbar: false
          stub: false
          req_fifo_pass: true
        }
        {
          name: aon_timer_aon
          type: device
          clock: clk_peri_i
          reset: rst_peri_ni
          pipeline: false
          inst_type: aon_timer
          addr_range:
          [
            {
              base_addrs:
              {
                hart: 0x30470000
              }
              size_byte: 0x40
            }
          ]
          xbar: false
          stub: false
          req_fifo_pass: true
        }
        {
          name: ast
          type: device
          clock: clk_peri_i
          reset: rst_peri_ni
          pipeline: false
          inst_type: ast
          addr_range:
          [
            {
              base_addrs:
              {
                hart: 0x30480000
              }
              size_byte: 0x400
            }
          ]
          xbar: false
          stub: true
          req_fifo_pass: true
        }
        {
          name: soc_dbg_ctrl.core
          type: device
          clock: clk_peri_i
          reset: rst_peri_ni
          pipeline: false
          inst_type: soc_dbg_ctrl
          addr_range:
          [
            {
              base_addrs:
              {
                hart: 0x30170000
              }
              size_byte: 0x20
            }
          ]
          xbar: false
          stub: false
          req_fifo_pass: true
        }
      ]
      addr_spaces:
      [
        hart
      ]
      clock: clk_peri_i
      type: xbar
      inter_signal_list:
      [
        {
          name: tl_main
          struct: tl
          package: tlul_pkg
          type: req_rsp
          act: rsp
          inst_name: peri
          width: 1
          default: ""
          top_signame: main_tl_peri
          index: -1
        }
        {
          name: tl_uart0
          struct: tl
          package: tlul_pkg
          type: req_rsp
          act: req
          inst_name: peri
          width: 1
          default: ""
          top_signame: uart0_tl
          index: -1
        }
        {
          name: tl_i2c0
          struct: tl
          package: tlul_pkg
          type: req_rsp
          act: req
          inst_name: peri
          width: 1
          default: ""
          top_signame: i2c0_tl
          index: -1
        }
        {
          name: tl_gpio
          struct: tl
          package: tlul_pkg
          type: req_rsp
          act: req
          inst_name: peri
          width: 1
          default: ""
          top_signame: gpio_tl
          index: -1
        }
        {
          name: tl_spi_host0
          struct: tl
          package: tlul_pkg
          type: req_rsp
          act: req
          inst_name: peri
          width: 1
          default: ""
          top_signame: spi_host0_tl
          index: -1
        }
        {
          name: tl_spi_device
          struct: tl
          package: tlul_pkg
          type: req_rsp
          act: req
          inst_name: peri
          width: 1
          default: ""
          top_signame: spi_device_tl
          index: -1
        }
        {
          name: tl_rv_timer
          struct: tl
          package: tlul_pkg
          type: req_rsp
          act: req
          inst_name: peri
          width: 1
          default: ""
          top_signame: rv_timer_tl
          index: -1
        }
        {
          name: tl_pwrmgr_aon
          struct: tl
          package: tlul_pkg
          type: req_rsp
          act: req
          inst_name: peri
          width: 1
          default: ""
          top_signame: pwrmgr_aon_tl
          index: -1
        }
        {
          name: tl_rstmgr_aon
          struct: tl
          package: tlul_pkg
          type: req_rsp
          act: req
          inst_name: peri
          width: 1
          default: ""
          top_signame: rstmgr_aon_tl
          index: -1
        }
        {
          name: tl_clkmgr_aon
          struct: tl
          package: tlul_pkg
          type: req_rsp
          act: req
          inst_name: peri
          width: 1
          default: ""
          top_signame: clkmgr_aon_tl
          index: -1
        }
        {
          name: tl_pinmux_aon
          struct: tl
          package: tlul_pkg
          type: req_rsp
          act: req
          inst_name: peri
          width: 1
          default: ""
          top_signame: pinmux_aon_tl
          index: -1
        }
        {
          name: tl_otp_ctrl__core
          struct: tl
          package: tlul_pkg
          type: req_rsp
          act: req
          inst_name: peri
          width: 1
          default: ""
          top_signame: otp_ctrl_core_tl
          index: -1
        }
        {
          name: tl_otp_macro
          struct: tl
          package: tlul_pkg
          type: req_rsp
          act: req
          inst_name: peri
          width: 1
          default: ""
          top_signame: otp_macro_tl
          index: -1
        }
        {
          name: tl_lc_ctrl__regs
          struct: tl
          package: tlul_pkg
          type: req_rsp
          act: req
          inst_name: peri
          width: 1
          default: ""
          top_signame: lc_ctrl_regs_tl
          index: -1
        }
        {
          name: tl_alert_handler
          struct: tl
          package: tlul_pkg
          type: req_rsp
          act: req
          inst_name: peri
          width: 1
          default: ""
          top_signame: alert_handler_tl
          index: -1
        }
        {
          name: tl_sram_ctrl_ret_aon__regs
          struct: tl
          package: tlul_pkg
          type: req_rsp
          act: req
          inst_name: peri
          width: 1
          default: ""
          top_signame: sram_ctrl_ret_aon_regs_tl
          index: -1
        }
        {
          name: tl_sram_ctrl_ret_aon__ram
          struct: tl
          package: tlul_pkg
          type: req_rsp
          act: req
          inst_name: peri
          width: 1
          default: ""
          top_signame: sram_ctrl_ret_aon_ram_tl
          index: -1
        }
        {
          name: tl_aon_timer_aon
          struct: tl
          package: tlul_pkg
          type: req_rsp
          act: req
          inst_name: peri
          width: 1
          default: ""
          top_signame: aon_timer_aon_tl
          index: -1
        }
        {
          name: tl_ast
          struct: tl
          package: tlul_pkg
          type: req_rsp
          act: req
          inst_name: peri
          width: 1
          default: ""
          external: true
          top_signame: ast_tl
          conn_type: false
          index: -1
        }
        {
          name: tl_soc_dbg_ctrl__core
          struct: tl
          package: tlul_pkg
          type: req_rsp
          act: req
          inst_name: peri
          width: 1
          default: ""
          top_signame: soc_dbg_ctrl_core_tl
          index: -1
        }
      ]
    }
    {
      name: mbx
      clock_srcs:
      {
        clk_mbx_i: main
      }
      clock_group: infra
      reset: rst_mbx_ni
      reset_connections:
      {
        rst_mbx_ni:
        {
          name: lc
          domain: "0"
        }
      }
      clock_connections:
      {
        clk_mbx_i: clkmgr_aon_clocks.clk_main_infra
      }
      domain:
      [
        "0"
      ]
      connections:
      {
        mbx:
        [
          mbx0.soc
          mbx1.soc
          mbx2.soc
          mbx3.soc
          mbx4.soc
          mbx5.soc
          mbx6.soc
          mbx_pcie0.soc
          mbx_pcie1.soc
          racl_ctrl
          ac_range_check
        ]
      }
      nodes:
      [
        {
          name: mbx
          type: host
          addr_space: soc_mbx
          clock: clk_mbx_i
          reset: rst_mbx_ni
          xbar: true
          pipeline: false
          stub: false
          inst_type: ""
          req_fifo_pass: true
          rsp_fifo_pass: true
        }
        {
          name: mbx0.soc
          type: device
          addr_space: soc_mbx
          clock: clk_mbx_i
          reset: rst_mbx_ni
          pipeline: false
          inst_type: mbx
          addr_range:
          [
            {
              base_addrs:
              {
                soc_mbx: 0x1465000
              }
              size_byte: 0x20
            }
          ]
          xbar: false
          stub: false
          req_fifo_pass: true
        }
        {
          name: mbx1.soc
          type: device
          addr_space: soc_mbx
          clock: clk_mbx_i
          reset: rst_mbx_ni
          pipeline: false
          inst_type: mbx
          addr_range:
          [
            {
              base_addrs:
              {
                soc_mbx: 0x1465100
              }
              size_byte: 0x20
            }
          ]
          xbar: false
          stub: false
          req_fifo_pass: true
        }
        {
          name: mbx2.soc
          type: device
          addr_space: soc_mbx
          clock: clk_mbx_i
          reset: rst_mbx_ni
          pipeline: false
          inst_type: mbx
          addr_range:
          [
            {
              base_addrs:
              {
                soc_mbx: 0x1465200
              }
              size_byte: 0x20
            }
          ]
          xbar: false
          stub: false
          req_fifo_pass: true
        }
        {
          name: mbx3.soc
          type: device
          addr_space: soc_mbx
          clock: clk_mbx_i
          reset: rst_mbx_ni
          pipeline: false
          inst_type: mbx
          addr_range:
          [
            {
              base_addrs:
              {
                soc_mbx: 0x1465300
              }
              size_byte: 0x20
            }
          ]
          xbar: false
          stub: false
          req_fifo_pass: true
        }
        {
          name: mbx4.soc
          type: device
          addr_space: soc_mbx
          clock: clk_mbx_i
          reset: rst_mbx_ni
          pipeline: false
          inst_type: mbx
          addr_range:
          [
            {
              base_addrs:
              {
                soc_mbx: 0x1465400
              }
              size_byte: 0x20
            }
          ]
          xbar: false
          stub: false
          req_fifo_pass: true
        }
        {
          name: mbx5.soc
          type: device
          addr_space: soc_mbx
          clock: clk_mbx_i
          reset: rst_mbx_ni
          pipeline: false
          inst_type: mbx
          addr_range:
          [
            {
              base_addrs:
              {
                soc_mbx: 0x1465500
              }
              size_byte: 0x20
            }
          ]
          xbar: false
          stub: false
          req_fifo_pass: true
        }
        {
          name: mbx6.soc
          type: device
          addr_space: soc_mbx
          clock: clk_mbx_i
          reset: rst_mbx_ni
          pipeline: false
          inst_type: mbx
          addr_range:
          [
            {
              base_addrs:
              {
                soc_mbx: 0x1496000
              }
              size_byte: 0x20
            }
          ]
          xbar: false
          stub: false
          req_fifo_pass: true
        }
        {
          name: mbx_pcie0.soc
          type: device
          addr_space: soc_mbx
          clock: clk_mbx_i
          reset: rst_mbx_ni
          pipeline: false
          inst_type: mbx
          addr_range:
          [
            {
              base_addrs:
              {
                soc_mbx: 0x1460100
              }
              size_byte: 0x20
            }
          ]
          xbar: false
          stub: false
          req_fifo_pass: true
        }
        {
          name: mbx_pcie1.soc
          type: device
          addr_space: soc_mbx
          clock: clk_mbx_i
          reset: rst_mbx_ni
          pipeline: false
          inst_type: mbx
          addr_range:
          [
            {
              base_addrs:
              {
                soc_mbx: 0x1460200
              }
              size_byte: 0x20
            }
          ]
          xbar: false
          stub: false
          req_fifo_pass: true
        }
        {
          name: racl_ctrl
          type: device
          addr_space: soc_mbx
          clock: clk_mbx_i
          reset: rst_mbx_ni
          pipeline: false
          inst_type: racl_ctrl
          addr_range:
          [
            {
              base_addrs:
              {
                soc_mbx: 0x1461f00
              }
              size_byte: 0x100
            }
          ]
          xbar: false
          stub: false
          req_fifo_pass: true
        }
        {
          name: ac_range_check
          type: device
          addr_space: soc_mbx
          clock: clk_mbx_i
          reset: rst_mbx_ni
          pipeline: false
          inst_type: ac_range_check
          addr_range:
          [
            {
              base_addrs:
              {
                soc_mbx: 0x1464000
              }
              size_byte: 0x400
            }
          ]
          xbar: false
          stub: false
          req_fifo_pass: true
        }
      ]
      addr_spaces:
      [
        soc_mbx
      ]
      clock: clk_mbx_i
      type: xbar
      inter_signal_list:
      [
        {
          name: tl_mbx
          struct: tl
          package: tlul_pkg
          type: req_rsp
          act: rsp
          inst_name: mbx
          width: 1
          default: ""
          external: true
          top_signame: mbx_tl
          conn_type: false
          index: -1
        }
        {
          name: tl_mbx0__soc
          struct: tl
          package: tlul_pkg
          type: req_rsp
          act: req
          inst_name: mbx
          width: 1
          default: ""
          top_signame: mbx0_soc_tl_d
          index: -1
        }
        {
          name: tl_mbx1__soc
          struct: tl
          package: tlul_pkg
          type: req_rsp
          act: req
          inst_name: mbx
          width: 1
          default: ""
          top_signame: mbx1_soc_tl_d
          index: -1
        }
        {
          name: tl_mbx2__soc
          struct: tl
          package: tlul_pkg
          type: req_rsp
          act: req
          inst_name: mbx
          width: 1
          default: ""
          top_signame: mbx2_soc_tl_d
          index: -1
        }
        {
          name: tl_mbx3__soc
          struct: tl
          package: tlul_pkg
          type: req_rsp
          act: req
          inst_name: mbx
          width: 1
          default: ""
          top_signame: mbx3_soc_tl_d
          index: -1
        }
        {
          name: tl_mbx4__soc
          struct: tl
          package: tlul_pkg
          type: req_rsp
          act: req
          inst_name: mbx
          width: 1
          default: ""
          top_signame: mbx4_soc_tl_d
          index: -1
        }
        {
          name: tl_mbx5__soc
          struct: tl
          package: tlul_pkg
          type: req_rsp
          act: req
          inst_name: mbx
          width: 1
          default: ""
          top_signame: mbx5_soc_tl_d
          index: -1
        }
        {
          name: tl_mbx6__soc
          struct: tl
          package: tlul_pkg
          type: req_rsp
          act: req
          inst_name: mbx
          width: 1
          default: ""
          top_signame: mbx6_soc_tl_d
          index: -1
        }
        {
          name: tl_mbx_pcie0__soc
          struct: tl
          package: tlul_pkg
          type: req_rsp
          act: req
          inst_name: mbx
          width: 1
          default: ""
          top_signame: mbx_pcie0_soc_tl_d
          index: -1
        }
        {
          name: tl_mbx_pcie1__soc
          struct: tl
          package: tlul_pkg
          type: req_rsp
          act: req
          inst_name: mbx
          width: 1
          default: ""
          top_signame: mbx_pcie1_soc_tl_d
          index: -1
        }
        {
          name: tl_racl_ctrl
          struct: tl
          package: tlul_pkg
          type: req_rsp
          act: req
          inst_name: mbx
          width: 1
          default: ""
          top_signame: racl_ctrl_tl
          index: -1
        }
        {
          name: tl_ac_range_check
          struct: tl
          package: tlul_pkg
          type: req_rsp
          act: req
          inst_name: mbx
          width: 1
          default: ""
          top_signame: ac_range_check_tl
          index: -1
        }
      ]
    }
    {
      name: dbg
      clock_srcs:
      {
        clk_dbg_i: main
        clk_peri_i: io_div4
      }
      clock_group: infra
      reset: rst_dbg_ni
      reset_connections:
      {
        rst_dbg_ni:
        {
          name: lc
          domain: "0"
        }
        rst_peri_ni:
        {
          name: lc_io_div4
          domain: "0"
        }
      }
      clock_connections:
      {
        clk_dbg_i: clkmgr_aon_clocks.clk_main_infra
        clk_peri_i: clkmgr_aon_clocks.clk_io_div4_infra
      }
      domain:
      [
        "0"
      ]
      connections:
      {
        dbg:
        [
          rv_dm.dbg
          mbx_jtag.soc
          lc_ctrl.dmi
          soc_dbg_ctrl.jtag
        ]
      }
      nodes:
      [
        {
          name: dbg
          type: host
          addr_space: soc_dbg
          clock: clk_dbg_i
          reset: rst_dbg_ni
          xbar: true
          pipeline: false
          stub: false
          inst_type: ""
          req_fifo_pass: true
          rsp_fifo_pass: true
        }
        {
          name: rv_dm.dbg
          type: device
          clock: clk_dbg_i
          reset: rst_dbg_ni
          pipeline: false
          inst_type: rv_dm
          addr_range:
          [
            {
              base_addrs:
              {
                soc_dbg: 0x0
              }
              size_byte: 0x200
            }
          ]
          xbar: false
          stub: false
          req_fifo_pass: true
        }
        {
          name: mbx_jtag.soc
          type: device
          clock: clk_dbg_i
          reset: rst_dbg_ni
          pipeline: false
          inst_type: mbx
          addr_range:
          [
            {
              base_addrs:
              {
                soc_dbg: 0x2200
              }
              size_byte: 0x20
            }
          ]
          xbar: false
          stub: false
          req_fifo_pass: true
        }
        {
          name: lc_ctrl.dmi
          type: device
          clock: clk_peri_i
          reset: rst_peri_ni
          pipeline: false
          inst_type: lc_ctrl
          addr_range:
          [
            {
              base_addrs:
              {
                soc_dbg: 0x3000
              }
              size_byte: 0x1000
            }
          ]
          xbar: false
          stub: false
          req_fifo_pass: true
        }
        {
          name: soc_dbg_ctrl.jtag
          type: device
          clock: clk_peri_i
          reset: rst_peri_ni
          pipeline: false
          inst_type: soc_dbg_ctrl
          addr_range:
          [
            {
              base_addrs:
              {
                soc_dbg: 0x2300
              }
              size_byte: 0x20
            }
          ]
          xbar: false
          stub: false
          req_fifo_pass: true
        }
      ]
      addr_spaces:
      [
        soc_dbg
      ]
      clock: clk_dbg_i
      type: xbar
      inter_signal_list:
      [
        {
          name: tl_dbg
          struct: tl
          package: tlul_pkg
          type: req_rsp
          act: rsp
          inst_name: dbg
          width: 1
          default: ""
          external: true
          top_signame: dbg_tl
          conn_type: false
          index: -1
        }
        {
          name: tl_rv_dm__dbg
          struct: tl
          package: tlul_pkg
          type: req_rsp
          act: req
          inst_name: dbg
          width: 1
          default: ""
          top_signame: rv_dm_dbg_tl_d
          index: -1
        }
        {
          name: tl_mbx_jtag__soc
          struct: tl
          package: tlul_pkg
          type: req_rsp
          act: req
          inst_name: dbg
          width: 1
          default: ""
          top_signame: mbx_jtag_soc_tl_d
          index: -1
        }
        {
          name: tl_lc_ctrl__dmi
          struct: tl
          package: tlul_pkg
          type: req_rsp
          act: req
          inst_name: dbg
          width: 1
          default: ""
          top_signame: lc_ctrl_dmi_tl
          index: -1
        }
        {
          name: tl_soc_dbg_ctrl__jtag
          struct: tl
          package: tlul_pkg
          type: req_rsp
          act: req
          inst_name: dbg
          width: 1
          default: ""
          top_signame: soc_dbg_ctrl_jtag_tl
          index: -1
        }
      ]
    }
  ]
  pinout:
  {
    banks:
    [
      VIO
    ]
    pads:
    [
      {
        name: POR_N
        type: InputStd
        bank: VIO
        connection: manual
        desc: System reset
        idx: 0
        port_type: inout
      }
      {
        name: JTAG_TCK
        type: InputStd
        bank: VIO
        connection: manual
        desc: JTAG TCK signal
        idx: 1
        port_type: inout
      }
      {
        name: JTAG_TMS
        type: InputStd
        bank: VIO
        connection: manual
        desc: JTAG TMS signal
        idx: 2
        port_type: inout
      }
      {
        name: JTAG_TDI
        type: InputStd
        bank: VIO
        connection: manual
        desc: JTAG TDI signal
        idx: 3
        port_type: inout
      }
      {
        name: JTAG_TDO
        type: BidirStd
        bank: VIO
        connection: manual
        desc: JTAG TDO signal
        idx: 4
        port_type: inout
      }
      {
        name: JTAG_TRST_N
        type: InputStd
        bank: VIO
        connection: manual
        desc: JTAG TRST_N signal
        idx: 5
        port_type: inout
      }
      {
        name: OTP_EXT_VOLT
        type: AnalogIn1
        bank: VIO
        connection: manual
        desc: OTP external voltage input
        idx: 6
        port_type: inout
      }
      {
        name: SPI_HOST_D0
        type: BidirStd
        bank: VIO
        connection: direct
        desc: SPI host data
        idx: 7
        port_type: inout
      }
      {
        name: SPI_HOST_D1
        type: BidirStd
        bank: VIO
        connection: direct
        desc: SPI host data
        idx: 8
        port_type: inout
      }
      {
        name: SPI_HOST_D2
        type: BidirStd
        bank: VIO
        connection: direct
        desc: SPI host data
        idx: 9
        port_type: inout
      }
      {
        name: SPI_HOST_D3
        type: BidirStd
        bank: VIO
        connection: direct
        desc: SPI host data
        idx: 10
        port_type: inout
      }
      {
        name: SPI_HOST_CLK
        type: BidirStd
        bank: VIO
        connection: direct
        desc: SPI host clock
        idx: 11
        port_type: inout
      }
      {
        name: SPI_HOST_CS_L
        type: BidirStd
        bank: VIO
        connection: direct
        desc: SPI host chip select
        idx: 12
        port_type: inout
      }
      {
        name: SPI_DEV_D0
        type: BidirStd
        bank: VIO
        connection: direct
        desc: SPI device data
        idx: 13
        port_type: inout
      }
      {
        name: SPI_DEV_D1
        type: BidirStd
        bank: VIO
        connection: direct
        desc: SPI device data
        idx: 14
        port_type: inout
      }
      {
        name: SPI_DEV_D2
        type: BidirStd
        bank: VIO
        connection: direct
        desc: SPI device data
        idx: 15
        port_type: inout
      }
      {
        name: SPI_DEV_D3
        type: BidirStd
        bank: VIO
        connection: direct
        desc: SPI device data
        idx: 16
        port_type: inout
      }
      {
        name: SPI_DEV_CLK
        type: InputStd
        bank: VIO
        connection: direct
        desc: SPI device clock
        idx: 17
        port_type: inout
      }
      {
        name: SPI_DEV_CS_L
        type: InputStd
        bank: VIO
        connection: direct
        desc: SPI device chip select
        idx: 18
        port_type: inout
      }
      {
        name: SPI_DEV_TPM_CS_L
        type: InputStd
        bank: VIO
        connection: direct
        desc: SPI device TPM chip select
        idx: 19
        port_type: inout
      }
      {
        name: UART_RX
        type: InputStd
        bank: VIO
        connection: direct
        desc: UART receive
        idx: 20
        port_type: inout
      }
      {
        name: UART_TX
        type: BidirStd
        bank: VIO
        connection: direct
        desc: UART transmit
        idx: 21
        port_type: inout
      }
      {
        name: I2C_SCL
        type: BidirStd
        bank: VIO
        connection: direct
        desc: I2C clock
        idx: 22
        port_type: inout
      }
      {
        name: I2C_SDA
        type: BidirStd
        bank: VIO
        connection: direct
        desc: I2C data
        idx: 23
        port_type: inout
      }
      {
        name: GPIO0
        type: BidirStd
        bank: VIO
        connection: direct
        desc: GPIO pad
        idx: 24
        port_type: inout
      }
      {
        name: GPIO1
        type: BidirStd
        bank: VIO
        connection: direct
        desc: GPIO pad
        idx: 25
        port_type: inout
      }
      {
        name: GPIO2
        type: BidirStd
        bank: VIO
        connection: direct
        desc: GPIO pad
        idx: 26
        port_type: inout
      }
      {
        name: GPIO3
        type: BidirStd
        bank: VIO
        connection: direct
        desc: GPIO pad
        idx: 27
        port_type: inout
      }
      {
        name: GPIO4
        type: BidirStd
        bank: VIO
        connection: direct
        desc: GPIO pad
        idx: 28
        port_type: inout
      }
      {
        name: GPIO5
        type: BidirStd
        bank: VIO
        connection: direct
        desc: GPIO pad
        idx: 29
        port_type: inout
      }
      {
        name: GPIO6
        type: BidirStd
        bank: VIO
        connection: direct
        desc: GPIO pad
        idx: 30
        port_type: inout
      }
      {
        name: GPIO7
        type: BidirStd
        bank: VIO
        connection: direct
        desc: GPIO pad
        idx: 31
        port_type: inout
      }
      {
        name: GPIO8
        type: BidirStd
        bank: VIO
        connection: direct
        desc: GPIO pad
        idx: 32
        port_type: inout
      }
      {
        name: GPIO9
        type: BidirStd
        bank: VIO
        connection: direct
        desc: GPIO pad
        idx: 33
        port_type: inout
      }
      {
        name: GPIO10
        type: BidirStd
        bank: VIO
        connection: direct
        desc: GPIO pad
        idx: 34
        port_type: inout
      }
      {
        name: GPIO11
        type: BidirStd
        bank: VIO
        connection: direct
        desc: GPIO pad
        idx: 35
        port_type: inout
      }
      {
        name: GPIO12
        type: BidirStd
        bank: VIO
        connection: direct
        desc: GPIO pad
        idx: 36
        port_type: inout
      }
      {
        name: GPIO13
        type: BidirStd
        bank: VIO
        connection: direct
        desc: GPIO pad
        idx: 37
        port_type: inout
      }
      {
        name: GPIO14
        type: BidirStd
        bank: VIO
        connection: direct
        desc: GPIO pad
        idx: 38
        port_type: inout
      }
      {
        name: GPIO15
        type: BidirStd
        bank: VIO
        connection: direct
        desc: GPIO pad
        idx: 39
        port_type: inout
      }
      {
        name: GPIO16
        type: BidirStd
        bank: VIO
        connection: direct
        desc: GPIO pad
        idx: 40
        port_type: inout
      }
      {
        name: GPIO17
        type: BidirStd
        bank: VIO
        connection: direct
        desc: GPIO pad
        idx: 41
        port_type: inout
      }
      {
        name: GPIO18
        type: BidirStd
        bank: VIO
        connection: direct
        desc: GPIO pad
        idx: 42
        port_type: inout
      }
      {
        name: GPIO19
        type: BidirStd
        bank: VIO
        connection: direct
        desc: GPIO pad
        idx: 43
        port_type: inout
      }
      {
        name: GPIO20
        type: BidirStd
        bank: VIO
        connection: direct
        desc: GPIO pad
        idx: 44
        port_type: inout
      }
      {
        name: GPIO21
        type: BidirStd
        bank: VIO
        connection: direct
        desc: GPIO pad
        idx: 45
        port_type: inout
      }
      {
        name: GPIO22
        type: BidirStd
        bank: VIO
        connection: direct
        desc: GPIO pad
        idx: 46
        port_type: inout
      }
      {
        name: GPIO23
        type: BidirStd
        bank: VIO
        connection: direct
        desc: GPIO pad
        idx: 47
        port_type: inout
      }
      {
        name: GPIO24
        type: BidirStd
        bank: VIO
        connection: direct
        desc: GPIO pad
        idx: 48
        port_type: inout
      }
      {
        name: GPIO25
        type: BidirStd
        bank: VIO
        connection: direct
        desc: GPIO pad
        idx: 49
        port_type: inout
      }
      {
        name: GPIO26
        type: BidirStd
        bank: VIO
        connection: direct
        desc: GPIO pad
        idx: 50
        port_type: inout
      }
      {
        name: GPIO27
        type: BidirStd
        bank: VIO
        connection: direct
        desc: GPIO pad
        idx: 51
        port_type: inout
      }
      {
        name: GPIO28
        type: BidirStd
        bank: VIO
        connection: direct
        desc: GPIO pad
        idx: 52
        port_type: inout
      }
      {
        name: GPIO29
        type: BidirStd
        bank: VIO
        connection: direct
        desc: GPIO pad
        idx: 53
        port_type: inout
      }
      {
        name: GPIO30
        type: BidirStd
        bank: VIO
        connection: direct
        desc: GPIO pad
        idx: 54
        port_type: inout
      }
      {
        name: GPIO31
        type: BidirStd
        bank: VIO
        connection: direct
        desc: GPIO pad
        idx: 55
        port_type: inout
      }
      {
        name: SOC_GPI0
        type: InputStd
        bank: VIO
        connection: direct
        desc: SoC general purpose input
        idx: 56
        port_type: inout
      }
      {
        name: SOC_GPI1
        type: InputStd
        bank: VIO
        connection: direct
        desc: SoC general purpose input
        idx: 57
        port_type: inout
      }
      {
        name: SOC_GPI2
        type: InputStd
        bank: VIO
        connection: direct
        desc: SoC general purpose input
        idx: 58
        port_type: inout
      }
      {
        name: SOC_GPI3
        type: InputStd
        bank: VIO
        connection: direct
        desc: SoC general purpose input
        idx: 59
        port_type: inout
      }
      {
        name: SOC_GPI4
        type: InputStd
        bank: VIO
        connection: direct
        desc: SoC general purpose input
        idx: 60
        port_type: inout
      }
      {
        name: SOC_GPI5
        type: InputStd
        bank: VIO
        connection: direct
        desc: SoC general purpose input
        idx: 61
        port_type: inout
      }
      {
        name: SOC_GPI6
        type: InputStd
        bank: VIO
        connection: direct
        desc: SoC general purpose input
        idx: 62
        port_type: inout
      }
      {
        name: SOC_GPI7
        type: InputStd
        bank: VIO
        connection: direct
        desc: SoC general purpose input
        idx: 63
        port_type: inout
      }
      {
        name: SOC_GPI8
        type: InputStd
        bank: VIO
        connection: direct
        desc: SoC general purpose input
        idx: 64
        port_type: inout
      }
      {
        name: SOC_GPI9
        type: InputStd
        bank: VIO
        connection: direct
        desc: SoC general purpose input
        idx: 65
        port_type: inout
      }
      {
        name: SOC_GPI10
        type: InputStd
        bank: VIO
        connection: direct
        desc: SoC general purpose input
        idx: 66
        port_type: inout
      }
      {
        name: SOC_GPI11
        type: InputStd
        bank: VIO
        connection: direct
        desc: SoC general purpose input
        idx: 67
        port_type: inout
      }
      {
        name: SOC_GPO0
        type: BidirStd
        bank: VIO
        connection: direct
        desc: SoC general purpose output
        idx: 68
        port_type: inout
      }
      {
        name: SOC_GPO1
        type: BidirStd
        bank: VIO
        connection: direct
        desc: SoC general purpose output
        idx: 69
        port_type: inout
      }
      {
        name: SOC_GPO2
        type: BidirStd
        bank: VIO
        connection: direct
        desc: SoC general purpose output
        idx: 70
        port_type: inout
      }
      {
        name: SOC_GPO3
        type: BidirStd
        bank: VIO
        connection: direct
        desc: SoC general purpose output
        idx: 71
        port_type: inout
      }
      {
        name: SOC_GPO4
        type: BidirStd
        bank: VIO
        connection: direct
        desc: SoC general purpose output
        idx: 72
        port_type: inout
      }
      {
        name: SOC_GPO5
        type: BidirStd
        bank: VIO
        connection: direct
        desc: SoC general purpose output
        idx: 73
        port_type: inout
      }
      {
        name: SOC_GPO6
        type: BidirStd
        bank: VIO
        connection: direct
        desc: SoC general purpose output
        idx: 74
        port_type: inout
      }
      {
        name: SOC_GPO7
        type: BidirStd
        bank: VIO
        connection: direct
        desc: SoC general purpose output
        idx: 75
        port_type: inout
      }
      {
        name: SOC_GPO8
        type: BidirStd
        bank: VIO
        connection: direct
        desc: SoC general purpose output
        idx: 76
        port_type: inout
      }
      {
        name: SOC_GPO9
        type: BidirStd
        bank: VIO
        connection: direct
        desc: SoC general purpose output
        idx: 77
        port_type: inout
      }
      {
        name: SOC_GPO10
        type: BidirStd
        bank: VIO
        connection: direct
        desc: SoC general purpose output
        idx: 78
        port_type: inout
      }
      {
        name: SOC_GPO11
        type: BidirStd
        bank: VIO
        connection: direct
        desc: SoC general purpose output
        idx: 79
        port_type: inout
      }
      {
        name: MIO0
        type: BidirStd
        bank: VIO
        connection: muxed
        desc: Muxed IO pad
        idx: 0
        port_type: inout
      }
      {
        name: MIO1
        type: BidirStd
        bank: VIO
        connection: muxed
        desc: Muxed IO pad
        idx: 1
        port_type: inout
      }
      {
        name: MIO2
        type: BidirStd
        bank: VIO
        connection: muxed
        desc: Muxed IO pad
        idx: 2
        port_type: inout
      }
      {
        name: MIO3
        type: BidirStd
        bank: VIO
        connection: muxed
        desc: Muxed IO pad
        idx: 3
        port_type: inout
      }
      {
        name: MIO4
        type: BidirStd
        bank: VIO
        connection: muxed
        desc: Muxed IO pad
        idx: 4
        port_type: inout
      }
      {
        name: MIO5
        type: BidirStd
        bank: VIO
        connection: muxed
        desc: Muxed IO pad
        idx: 5
        port_type: inout
      }
      {
        name: MIO6
        type: BidirStd
        bank: VIO
        connection: muxed
        desc: Muxed IO pad
        idx: 6
        port_type: inout
      }
      {
        name: MIO7
        type: BidirStd
        bank: VIO
        connection: muxed
        desc: Muxed IO pad
        idx: 7
        port_type: inout
      }
      {
        name: MIO8
        type: BidirStd
        bank: VIO
        connection: muxed
        desc: Muxed IO pad
        idx: 8
        port_type: inout
      }
      {
        name: MIO9
        type: BidirStd
        bank: VIO
        connection: muxed
        desc: Muxed IO pad
        idx: 9
        port_type: inout
      }
      {
        name: MIO10
        type: BidirStd
        bank: VIO
        connection: muxed
        desc: Muxed IO pad
        idx: 10
        port_type: inout
      }
      {
        name: MIO11
        type: BidirStd
        bank: VIO
        connection: muxed
        desc: Muxed IO pad
        idx: 11
        port_type: inout
      }
    ]
  }
  pinmux:
  {
    signals:
    [
      {
        instance: spi_host0
        port: sck
        connection: direct
        pad: SPI_HOST_CLK
        desc: ""
        attr: BidirStd
      }
      {
        instance: spi_host0
        port: csb
        connection: direct
        pad: SPI_HOST_CS_L
        desc: ""
        attr: BidirStd
      }
      {
        instance: spi_host0
        port: sd[0]
        connection: direct
        pad: SPI_HOST_D0
        desc: ""
        attr: BidirStd
      }
      {
        instance: spi_host0
        port: sd[1]
        connection: direct
        pad: SPI_HOST_D1
        desc: ""
        attr: BidirStd
      }
      {
        instance: spi_host0
        port: sd[2]
        connection: direct
        pad: SPI_HOST_D2
        desc: ""
        attr: BidirStd
      }
      {
        instance: spi_host0
        port: sd[3]
        connection: direct
        pad: SPI_HOST_D3
        desc: ""
        attr: BidirStd
      }
      {
        instance: spi_device
        port: sck
        connection: direct
        pad: SPI_DEV_CLK
        desc: ""
        attr: InputStd
      }
      {
        instance: spi_device
        port: csb
        connection: direct
        pad: SPI_DEV_CS_L
        desc: ""
        attr: InputStd
      }
      {
        instance: spi_device
        port: sd[0]
        connection: direct
        pad: SPI_DEV_D0
        desc: ""
        attr: BidirStd
      }
      {
        instance: spi_device
        port: sd[1]
        connection: direct
        pad: SPI_DEV_D1
        desc: ""
        attr: BidirStd
      }
      {
        instance: spi_device
        port: sd[2]
        connection: direct
        pad: SPI_DEV_D2
        desc: ""
        attr: BidirStd
      }
      {
        instance: spi_device
        port: sd[3]
        connection: direct
        pad: SPI_DEV_D3
        desc: ""
        attr: BidirStd
      }
      {
        instance: spi_device
        port: tpm_csb
        connection: direct
        pad: SPI_DEV_TPM_CS_L
        desc: ""
        attr: InputStd
      }
      {
        instance: uart0
        port: rx
        connection: direct
        pad: UART_RX
        desc: ""
        attr: InputStd
      }
      {
        instance: uart0
        port: tx
        connection: direct
        pad: UART_TX
        desc: ""
        attr: BidirStd
      }
      {
        instance: i2c0
        port: scl
        connection: direct
        pad: I2C_SCL
        desc: ""
        attr: BidirStd
      }
      {
        instance: i2c0
        port: sda
        connection: direct
        pad: I2C_SDA
        desc: ""
        attr: BidirStd
      }
      {
        instance: gpio
        port: gpio[0]
        connection: direct
        pad: GPIO0
        desc: ""
        attr: BidirStd
      }
      {
        instance: gpio
        port: gpio[1]
        connection: direct
        pad: GPIO1
        desc: ""
        attr: BidirStd
      }
      {
        instance: gpio
        port: gpio[2]
        connection: direct
        pad: GPIO2
        desc: ""
        attr: BidirStd
      }
      {
        instance: gpio
        port: gpio[3]
        connection: direct
        pad: GPIO3
        desc: ""
        attr: BidirStd
      }
      {
        instance: gpio
        port: gpio[4]
        connection: direct
        pad: GPIO4
        desc: ""
        attr: BidirStd
      }
      {
        instance: gpio
        port: gpio[5]
        connection: direct
        pad: GPIO5
        desc: ""
        attr: BidirStd
      }
      {
        instance: gpio
        port: gpio[6]
        connection: direct
        pad: GPIO6
        desc: ""
        attr: BidirStd
      }
      {
        instance: gpio
        port: gpio[7]
        connection: direct
        pad: GPIO7
        desc: ""
        attr: BidirStd
      }
      {
        instance: gpio
        port: gpio[8]
        connection: direct
        pad: GPIO8
        desc: ""
        attr: BidirStd
      }
      {
        instance: gpio
        port: gpio[9]
        connection: direct
        pad: GPIO9
        desc: ""
        attr: BidirStd
      }
      {
        instance: gpio
        port: gpio[10]
        connection: direct
        pad: GPIO10
        desc: ""
        attr: BidirStd
      }
      {
        instance: gpio
        port: gpio[11]
        connection: direct
        pad: GPIO11
        desc: ""
        attr: BidirStd
      }
      {
        instance: gpio
        port: gpio[12]
        connection: direct
        pad: GPIO12
        desc: ""
        attr: BidirStd
      }
      {
        instance: gpio
        port: gpio[13]
        connection: direct
        pad: GPIO13
        desc: ""
        attr: BidirStd
      }
      {
        instance: gpio
        port: gpio[14]
        connection: direct
        pad: GPIO14
        desc: ""
        attr: BidirStd
      }
      {
        instance: gpio
        port: gpio[15]
        connection: direct
        pad: GPIO15
        desc: ""
        attr: BidirStd
      }
      {
        instance: gpio
        port: gpio[16]
        connection: direct
        pad: GPIO16
        desc: ""
        attr: BidirStd
      }
      {
        instance: gpio
        port: gpio[17]
        connection: direct
        pad: GPIO17
        desc: ""
        attr: BidirStd
      }
      {
        instance: gpio
        port: gpio[18]
        connection: direct
        pad: GPIO18
        desc: ""
        attr: BidirStd
      }
      {
        instance: gpio
        port: gpio[19]
        connection: direct
        pad: GPIO19
        desc: ""
        attr: BidirStd
      }
      {
        instance: gpio
        port: gpio[20]
        connection: direct
        pad: GPIO20
        desc: ""
        attr: BidirStd
      }
      {
        instance: gpio
        port: gpio[21]
        connection: direct
        pad: GPIO21
        desc: ""
        attr: BidirStd
      }
      {
        instance: gpio
        port: gpio[22]
        connection: direct
        pad: GPIO22
        desc: ""
        attr: BidirStd
      }
      {
        instance: gpio
        port: gpio[23]
        connection: direct
        pad: GPIO23
        desc: ""
        attr: BidirStd
      }
      {
        instance: gpio
        port: gpio[24]
        connection: direct
        pad: GPIO24
        desc: ""
        attr: BidirStd
      }
      {
        instance: gpio
        port: gpio[25]
        connection: direct
        pad: GPIO25
        desc: ""
        attr: BidirStd
      }
      {
        instance: gpio
        port: gpio[26]
        connection: direct
        pad: GPIO26
        desc: ""
        attr: BidirStd
      }
      {
        instance: gpio
        port: gpio[27]
        connection: direct
        pad: GPIO27
        desc: ""
        attr: BidirStd
      }
      {
        instance: gpio
        port: gpio[28]
        connection: direct
        pad: GPIO28
        desc: ""
        attr: BidirStd
      }
      {
        instance: gpio
        port: gpio[29]
        connection: direct
        pad: GPIO29
        desc: ""
        attr: BidirStd
      }
      {
        instance: gpio
        port: gpio[30]
        connection: direct
        pad: GPIO30
        desc: ""
        attr: BidirStd
      }
      {
        instance: gpio
        port: gpio[31]
        connection: direct
        pad: GPIO31
        desc: ""
        attr: BidirStd
      }
      {
        instance: soc_proxy
        port: soc_gpi[0]
        connection: direct
        pad: SOC_GPI0
        desc: ""
        attr: InputStd
      }
      {
        instance: soc_proxy
        port: soc_gpi[1]
        connection: direct
        pad: SOC_GPI1
        desc: ""
        attr: InputStd
      }
      {
        instance: soc_proxy
        port: soc_gpi[2]
        connection: direct
        pad: SOC_GPI2
        desc: ""
        attr: InputStd
      }
      {
        instance: soc_proxy
        port: soc_gpi[3]
        connection: direct
        pad: SOC_GPI3
        desc: ""
        attr: InputStd
      }
      {
        instance: soc_proxy
        port: soc_gpi[4]
        connection: direct
        pad: SOC_GPI4
        desc: ""
        attr: InputStd
      }
      {
        instance: soc_proxy
        port: soc_gpi[5]
        connection: direct
        pad: SOC_GPI5
        desc: ""
        attr: InputStd
      }
      {
        instance: soc_proxy
        port: soc_gpi[6]
        connection: direct
        pad: SOC_GPI6
        desc: ""
        attr: InputStd
      }
      {
        instance: soc_proxy
        port: soc_gpi[7]
        connection: direct
        pad: SOC_GPI7
        desc: ""
        attr: InputStd
      }
      {
        instance: soc_proxy
        port: soc_gpi[8]
        connection: direct
        pad: SOC_GPI8
        desc: ""
        attr: InputStd
      }
      {
        instance: soc_proxy
        port: soc_gpi[9]
        connection: direct
        pad: SOC_GPI9
        desc: ""
        attr: InputStd
      }
      {
        instance: soc_proxy
        port: soc_gpi[10]
        connection: direct
        pad: SOC_GPI10
        desc: ""
        attr: InputStd
      }
      {
        instance: soc_proxy
        port: soc_gpi[11]
        connection: direct
        pad: SOC_GPI11
        desc: ""
        attr: InputStd
      }
      {
        instance: soc_proxy
        port: soc_gpi[12]
        connection: muxed
        pad: ""
        desc: ""
        attr: ""
      }
      {
        instance: soc_proxy
        port: soc_gpi[13]
        connection: muxed
        pad: ""
        desc: ""
        attr: ""
      }
      {
        instance: soc_proxy
        port: soc_gpi[14]
        connection: muxed
        pad: ""
        desc: ""
        attr: ""
      }
      {
        instance: soc_proxy
        port: soc_gpi[15]
        connection: muxed
        pad: ""
        desc: ""
        attr: ""
      }
      {
        instance: soc_proxy
        port: soc_gpo[0]
        connection: direct
        pad: SOC_GPO0
        desc: ""
        attr: BidirStd
      }
      {
        instance: soc_proxy
        port: soc_gpo[1]
        connection: direct
        pad: SOC_GPO1
        desc: ""
        attr: BidirStd
      }
      {
        instance: soc_proxy
        port: soc_gpo[2]
        connection: direct
        pad: SOC_GPO2
        desc: ""
        attr: BidirStd
      }
      {
        instance: soc_proxy
        port: soc_gpo[3]
        connection: direct
        pad: SOC_GPO3
        desc: ""
        attr: BidirStd
      }
      {
        instance: soc_proxy
        port: soc_gpo[4]
        connection: direct
        pad: SOC_GPO4
        desc: ""
        attr: BidirStd
      }
      {
        instance: soc_proxy
        port: soc_gpo[5]
        connection: direct
        pad: SOC_GPO5
        desc: ""
        attr: BidirStd
      }
      {
        instance: soc_proxy
        port: soc_gpo[6]
        connection: direct
        pad: SOC_GPO6
        desc: ""
        attr: BidirStd
      }
      {
        instance: soc_proxy
        port: soc_gpo[7]
        connection: direct
        pad: SOC_GPO7
        desc: ""
        attr: BidirStd
      }
      {
        instance: soc_proxy
        port: soc_gpo[8]
        connection: direct
        pad: SOC_GPO8
        desc: ""
        attr: BidirStd
      }
      {
        instance: soc_proxy
        port: soc_gpo[9]
        connection: direct
        pad: SOC_GPO9
        desc: ""
        attr: BidirStd
      }
      {
        instance: soc_proxy
        port: soc_gpo[10]
        connection: direct
        pad: SOC_GPO10
        desc: ""
        attr: BidirStd
      }
      {
        instance: soc_proxy
        port: soc_gpo[11]
        connection: direct
        pad: SOC_GPO11
        desc: ""
        attr: BidirStd
      }
      {
        instance: soc_proxy
        port: soc_gpo[12]
        connection: muxed
        pad: ""
        desc: ""
        attr: ""
      }
      {
        instance: soc_proxy
        port: soc_gpo[13]
        connection: muxed
        pad: ""
        desc: ""
        attr: ""
      }
      {
        instance: soc_proxy
        port: soc_gpo[14]
        connection: muxed
        pad: ""
        desc: ""
        attr: ""
      }
      {
        instance: soc_proxy
        port: soc_gpo[15]
        connection: muxed
        pad: ""
        desc: ""
        attr: ""
      }
      {
        instance: otp_macro
        port: test[0]
        connection: muxed
        pad: ""
        desc: ""
        attr: ""
      }
    ]
    num_wkup_detect: 8
    wkup_cnt_width: 8
    enable_usb_wakeup: false
    enable_strap_sampling: false
    ios:
    [
      {
        name: spi_host0_sd
        width: 4
        type: inout
        idx: 0
        pad: SPI_HOST_D0
        attr: BidirStd
        connection: direct
        desc: ""
        glob_idx: 0
      }
      {
        name: spi_host0_sd
        width: 4
        type: inout
        idx: 1
        pad: SPI_HOST_D1
        attr: BidirStd
        connection: direct
        desc: ""
        glob_idx: 1
      }
      {
        name: spi_host0_sd
        width: 4
        type: inout
        idx: 2
        pad: SPI_HOST_D2
        attr: BidirStd
        connection: direct
        desc: ""
        glob_idx: 2
      }
      {
        name: spi_host0_sd
        width: 4
        type: inout
        idx: 3
        pad: SPI_HOST_D3
        attr: BidirStd
        connection: direct
        desc: ""
        glob_idx: 3
      }
      {
        name: spi_device_sd
        width: 4
        type: inout
        idx: 0
        pad: SPI_DEV_D0
        attr: BidirStd
        connection: direct
        desc: ""
        glob_idx: 4
      }
      {
        name: spi_device_sd
        width: 4
        type: inout
        idx: 1
        pad: SPI_DEV_D1
        attr: BidirStd
        connection: direct
        desc: ""
        glob_idx: 5
      }
      {
        name: spi_device_sd
        width: 4
        type: inout
        idx: 2
        pad: SPI_DEV_D2
        attr: BidirStd
        connection: direct
        desc: ""
        glob_idx: 6
      }
      {
        name: spi_device_sd
        width: 4
        type: inout
        idx: 3
        pad: SPI_DEV_D3
        attr: BidirStd
        connection: direct
        desc: ""
        glob_idx: 7
      }
      {
        name: i2c0_scl
        width: 1
        type: inout
        idx: -1
        pad: I2C_SCL
        attr: BidirStd
        connection: direct
        desc: ""
        glob_idx: 8
      }
      {
        name: i2c0_sda
        width: 1
        type: inout
        idx: -1
        pad: I2C_SDA
        attr: BidirStd
        connection: direct
        desc: ""
        glob_idx: 9
      }
      {
        name: gpio_gpio
        width: 32
        type: inout
        idx: 0
        pad: GPIO0
        attr: BidirStd
        connection: direct
        desc: ""
        glob_idx: 10
      }
      {
        name: gpio_gpio
        width: 32
        type: inout
        idx: 1
        pad: GPIO1
        attr: BidirStd
        connection: direct
        desc: ""
        glob_idx: 11
      }
      {
        name: gpio_gpio
        width: 32
        type: inout
        idx: 2
        pad: GPIO2
        attr: BidirStd
        connection: direct
        desc: ""
        glob_idx: 12
      }
      {
        name: gpio_gpio
        width: 32
        type: inout
        idx: 3
        pad: GPIO3
        attr: BidirStd
        connection: direct
        desc: ""
        glob_idx: 13
      }
      {
        name: gpio_gpio
        width: 32
        type: inout
        idx: 4
        pad: GPIO4
        attr: BidirStd
        connection: direct
        desc: ""
        glob_idx: 14
      }
      {
        name: gpio_gpio
        width: 32
        type: inout
        idx: 5
        pad: GPIO5
        attr: BidirStd
        connection: direct
        desc: ""
        glob_idx: 15
      }
      {
        name: gpio_gpio
        width: 32
        type: inout
        idx: 6
        pad: GPIO6
        attr: BidirStd
        connection: direct
        desc: ""
        glob_idx: 16
      }
      {
        name: gpio_gpio
        width: 32
        type: inout
        idx: 7
        pad: GPIO7
        attr: BidirStd
        connection: direct
        desc: ""
        glob_idx: 17
      }
      {
        name: gpio_gpio
        width: 32
        type: inout
        idx: 8
        pad: GPIO8
        attr: BidirStd
        connection: direct
        desc: ""
        glob_idx: 18
      }
      {
        name: gpio_gpio
        width: 32
        type: inout
        idx: 9
        pad: GPIO9
        attr: BidirStd
        connection: direct
        desc: ""
        glob_idx: 19
      }
      {
        name: gpio_gpio
        width: 32
        type: inout
        idx: 10
        pad: GPIO10
        attr: BidirStd
        connection: direct
        desc: ""
        glob_idx: 20
      }
      {
        name: gpio_gpio
        width: 32
        type: inout
        idx: 11
        pad: GPIO11
        attr: BidirStd
        connection: direct
        desc: ""
        glob_idx: 21
      }
      {
        name: gpio_gpio
        width: 32
        type: inout
        idx: 12
        pad: GPIO12
        attr: BidirStd
        connection: direct
        desc: ""
        glob_idx: 22
      }
      {
        name: gpio_gpio
        width: 32
        type: inout
        idx: 13
        pad: GPIO13
        attr: BidirStd
        connection: direct
        desc: ""
        glob_idx: 23
      }
      {
        name: gpio_gpio
        width: 32
        type: inout
        idx: 14
        pad: GPIO14
        attr: BidirStd
        connection: direct
        desc: ""
        glob_idx: 24
      }
      {
        name: gpio_gpio
        width: 32
        type: inout
        idx: 15
        pad: GPIO15
        attr: BidirStd
        connection: direct
        desc: ""
        glob_idx: 25
      }
      {
        name: gpio_gpio
        width: 32
        type: inout
        idx: 16
        pad: GPIO16
        attr: BidirStd
        connection: direct
        desc: ""
        glob_idx: 26
      }
      {
        name: gpio_gpio
        width: 32
        type: inout
        idx: 17
        pad: GPIO17
        attr: BidirStd
        connection: direct
        desc: ""
        glob_idx: 27
      }
      {
        name: gpio_gpio
        width: 32
        type: inout
        idx: 18
        pad: GPIO18
        attr: BidirStd
        connection: direct
        desc: ""
        glob_idx: 28
      }
      {
        name: gpio_gpio
        width: 32
        type: inout
        idx: 19
        pad: GPIO19
        attr: BidirStd
        connection: direct
        desc: ""
        glob_idx: 29
      }
      {
        name: gpio_gpio
        width: 32
        type: inout
        idx: 20
        pad: GPIO20
        attr: BidirStd
        connection: direct
        desc: ""
        glob_idx: 30
      }
      {
        name: gpio_gpio
        width: 32
        type: inout
        idx: 21
        pad: GPIO21
        attr: BidirStd
        connection: direct
        desc: ""
        glob_idx: 31
      }
      {
        name: gpio_gpio
        width: 32
        type: inout
        idx: 22
        pad: GPIO22
        attr: BidirStd
        connection: direct
        desc: ""
        glob_idx: 32
      }
      {
        name: gpio_gpio
        width: 32
        type: inout
        idx: 23
        pad: GPIO23
        attr: BidirStd
        connection: direct
        desc: ""
        glob_idx: 33
      }
      {
        name: gpio_gpio
        width: 32
        type: inout
        idx: 24
        pad: GPIO24
        attr: BidirStd
        connection: direct
        desc: ""
        glob_idx: 34
      }
      {
        name: gpio_gpio
        width: 32
        type: inout
        idx: 25
        pad: GPIO25
        attr: BidirStd
        connection: direct
        desc: ""
        glob_idx: 35
      }
      {
        name: gpio_gpio
        width: 32
        type: inout
        idx: 26
        pad: GPIO26
        attr: BidirStd
        connection: direct
        desc: ""
        glob_idx: 36
      }
      {
        name: gpio_gpio
        width: 32
        type: inout
        idx: 27
        pad: GPIO27
        attr: BidirStd
        connection: direct
        desc: ""
        glob_idx: 37
      }
      {
        name: gpio_gpio
        width: 32
        type: inout
        idx: 28
        pad: GPIO28
        attr: BidirStd
        connection: direct
        desc: ""
        glob_idx: 38
      }
      {
        name: gpio_gpio
        width: 32
        type: inout
        idx: 29
        pad: GPIO29
        attr: BidirStd
        connection: direct
        desc: ""
        glob_idx: 39
      }
      {
        name: gpio_gpio
        width: 32
        type: inout
        idx: 30
        pad: GPIO30
        attr: BidirStd
        connection: direct
        desc: ""
        glob_idx: 40
      }
      {
        name: gpio_gpio
        width: 32
        type: inout
        idx: 31
        pad: GPIO31
        attr: BidirStd
        connection: direct
        desc: ""
        glob_idx: 41
      }
      {
        name: spi_device_sck
        width: 1
        type: input
        idx: -1
        pad: SPI_DEV_CLK
        attr: InputStd
        connection: direct
        desc: ""
        glob_idx: 42
      }
      {
        name: spi_device_csb
        width: 1
        type: input
        idx: -1
        pad: SPI_DEV_CS_L
        attr: InputStd
        connection: direct
        desc: ""
        glob_idx: 43
      }
      {
        name: spi_device_tpm_csb
        width: 1
        type: input
        idx: -1
        pad: SPI_DEV_TPM_CS_L
        attr: InputStd
        connection: direct
        desc: ""
        glob_idx: 44
      }
      {
        name: uart0_rx
        width: 1
        type: input
        idx: -1
        pad: UART_RX
        attr: InputStd
        connection: direct
        desc: ""
        glob_idx: 45
      }
      {
        name: soc_proxy_soc_gpi
        width: 16
        type: input
        idx: 0
        pad: SOC_GPI0
        attr: InputStd
        connection: direct
        desc: ""
        glob_idx: 46
      }
      {
        name: soc_proxy_soc_gpi
        width: 16
        type: input
        idx: 1
        pad: SOC_GPI1
        attr: InputStd
        connection: direct
        desc: ""
        glob_idx: 47
      }
      {
        name: soc_proxy_soc_gpi
        width: 16
        type: input
        idx: 2
        pad: SOC_GPI2
        attr: InputStd
        connection: direct
        desc: ""
        glob_idx: 48
      }
      {
        name: soc_proxy_soc_gpi
        width: 16
        type: input
        idx: 3
        pad: SOC_GPI3
        attr: InputStd
        connection: direct
        desc: ""
        glob_idx: 49
      }
      {
        name: soc_proxy_soc_gpi
        width: 16
        type: input
        idx: 4
        pad: SOC_GPI4
        attr: InputStd
        connection: direct
        desc: ""
        glob_idx: 50
      }
      {
        name: soc_proxy_soc_gpi
        width: 16
        type: input
        idx: 5
        pad: SOC_GPI5
        attr: InputStd
        connection: direct
        desc: ""
        glob_idx: 51
      }
      {
        name: soc_proxy_soc_gpi
        width: 16
        type: input
        idx: 6
        pad: SOC_GPI6
        attr: InputStd
        connection: direct
        desc: ""
        glob_idx: 52
      }
      {
        name: soc_proxy_soc_gpi
        width: 16
        type: input
        idx: 7
        pad: SOC_GPI7
        attr: InputStd
        connection: direct
        desc: ""
        glob_idx: 53
      }
      {
        name: soc_proxy_soc_gpi
        width: 16
        type: input
        idx: 8
        pad: SOC_GPI8
        attr: InputStd
        connection: direct
        desc: ""
        glob_idx: 54
      }
      {
        name: soc_proxy_soc_gpi
        width: 16
        type: input
        idx: 9
        pad: SOC_GPI9
        attr: InputStd
        connection: direct
        desc: ""
        glob_idx: 55
      }
      {
        name: soc_proxy_soc_gpi
        width: 16
        type: input
        idx: 10
        pad: SOC_GPI10
        attr: InputStd
        connection: direct
        desc: ""
        glob_idx: 56
      }
      {
        name: soc_proxy_soc_gpi
        width: 16
        type: input
        idx: 11
        pad: SOC_GPI11
        attr: InputStd
        connection: direct
        desc: ""
        glob_idx: 57
      }
      {
        name: soc_proxy_soc_gpi
        width: 16
        type: input
        idx: 12
        pad: ""
        attr: ""
        connection: muxed
        desc: ""
        glob_idx: 0
      }
      {
        name: soc_proxy_soc_gpi
        width: 16
        type: input
        idx: 13
        pad: ""
        attr: ""
        connection: muxed
        desc: ""
        glob_idx: 1
      }
      {
        name: soc_proxy_soc_gpi
        width: 16
        type: input
        idx: 14
        pad: ""
        attr: ""
        connection: muxed
        desc: ""
        glob_idx: 2
      }
      {
        name: soc_proxy_soc_gpi
        width: 16
        type: input
        idx: 15
        pad: ""
        attr: ""
        connection: muxed
        desc: ""
        glob_idx: 3
      }
      {
        name: spi_host0_sck
        width: 1
        type: output
        idx: -1
        pad: SPI_HOST_CLK
        attr: BidirStd
        connection: direct
        desc: ""
        glob_idx: 58
      }
      {
        name: spi_host0_csb
        width: 1
        type: output
        idx: -1
        pad: SPI_HOST_CS_L
        attr: BidirStd
        connection: direct
        desc: ""
        glob_idx: 59
      }
      {
        name: uart0_tx
        width: 1
        type: output
        idx: -1
        pad: UART_TX
        attr: BidirStd
        connection: direct
        desc: ""
        glob_idx: 60
      }
      {
        name: soc_proxy_soc_gpo
        width: 16
        type: output
        idx: 0
        pad: SOC_GPO0
        attr: BidirStd
        connection: direct
        desc: ""
        glob_idx: 61
      }
      {
        name: soc_proxy_soc_gpo
        width: 16
        type: output
        idx: 1
        pad: SOC_GPO1
        attr: BidirStd
        connection: direct
        desc: ""
        glob_idx: 62
      }
      {
        name: soc_proxy_soc_gpo
        width: 16
        type: output
        idx: 2
        pad: SOC_GPO2
        attr: BidirStd
        connection: direct
        desc: ""
        glob_idx: 63
      }
      {
        name: soc_proxy_soc_gpo
        width: 16
        type: output
        idx: 3
        pad: SOC_GPO3
        attr: BidirStd
        connection: direct
        desc: ""
        glob_idx: 64
      }
      {
        name: soc_proxy_soc_gpo
        width: 16
        type: output
        idx: 4
        pad: SOC_GPO4
        attr: BidirStd
        connection: direct
        desc: ""
        glob_idx: 65
      }
      {
        name: soc_proxy_soc_gpo
        width: 16
        type: output
        idx: 5
        pad: SOC_GPO5
        attr: BidirStd
        connection: direct
        desc: ""
        glob_idx: 66
      }
      {
        name: soc_proxy_soc_gpo
        width: 16
        type: output
        idx: 6
        pad: SOC_GPO6
        attr: BidirStd
        connection: direct
        desc: ""
        glob_idx: 67
      }
      {
        name: soc_proxy_soc_gpo
        width: 16
        type: output
        idx: 7
        pad: SOC_GPO7
        attr: BidirStd
        connection: direct
        desc: ""
        glob_idx: 68
      }
      {
        name: soc_proxy_soc_gpo
        width: 16
        type: output
        idx: 8
        pad: SOC_GPO8
        attr: BidirStd
        connection: direct
        desc: ""
        glob_idx: 69
      }
      {
        name: soc_proxy_soc_gpo
        width: 16
        type: output
        idx: 9
        pad: SOC_GPO9
        attr: BidirStd
        connection: direct
        desc: ""
        glob_idx: 70
      }
      {
        name: soc_proxy_soc_gpo
        width: 16
        type: output
        idx: 10
        pad: SOC_GPO10
        attr: BidirStd
        connection: direct
        desc: ""
        glob_idx: 71
      }
      {
        name: soc_proxy_soc_gpo
        width: 16
        type: output
        idx: 11
        pad: SOC_GPO11
        attr: BidirStd
        connection: direct
        desc: ""
        glob_idx: 72
      }
      {
        name: soc_proxy_soc_gpo
        width: 16
        type: output
        idx: 12
        pad: ""
        attr: ""
        connection: muxed
        desc: ""
        glob_idx: 0
      }
      {
        name: soc_proxy_soc_gpo
        width: 16
        type: output
        idx: 13
        pad: ""
        attr: ""
        connection: muxed
        desc: ""
        glob_idx: 1
      }
      {
        name: soc_proxy_soc_gpo
        width: 16
        type: output
        idx: 14
        pad: ""
        attr: ""
        connection: muxed
        desc: ""
        glob_idx: 2
      }
      {
        name: soc_proxy_soc_gpo
        width: 16
        type: output
        idx: 15
        pad: ""
        attr: ""
        connection: muxed
        desc: ""
        glob_idx: 3
      }
      {
        name: otp_macro_test
        width: 8
        type: output
        idx: 0
        pad: ""
        attr: ""
        connection: muxed
        desc: ""
        glob_idx: 4
      }
    ]
    io_counts:
    {
      dedicated:
      {
        inouts: 42
        inputs: 16
        outputs: 15
        pads: 80
      }
      muxed:
      {
        inouts: 0
        inputs: 4
        outputs: 5
        pads: 12
      }
    }
  }
  targets:
  [
    {
      name: asic
      pinout:
      {
        remove_ports: []
        remove_pads: []
        add_pads: []
      }
      pinmux:
      {
        special_signals:
        [
          {
            name: tap0
            pad: MIO0
            desc: TAP strap signal.
            idx: 0
          }
          {
            name: tap1
            pad: MIO1
            desc: TAP strap signal.
            idx: 1
          }
          {
            name: dft0
            pad: MIO2
            desc: DFT strap signal.
            idx: 2
          }
          {
            name: dft1
            pad: MIO3
            desc: DFT strap signal.
            idx: 3
          }
          {
            name: tck
            pad: MIO4
            desc: JTAG tck signal.
            idx: 4
          }
          {
            name: tms
            pad: MIO5
            desc: JTAG tms signal.
            idx: 5
          }
          {
            name: trst_n
            pad: MIO6
            desc: JTAG trst_n signal.
            idx: 6
          }
          {
            name: tdi
            pad: MIO7
            desc: JTAG tdi signal.
            idx: 7
          }
          {
            name: tdo
            pad: MIO8
            desc: JTAG tdo signal.
            idx: 8
          }
        ]
      }
    }
    {
      name: cw310
      pinout:
      {
        remove_ports: []
        remove_pads:
        [
          OTP_EXT_VOLT
        ]
        add_pads:
        [
          {
            name: IO_CLK
            type: InputStd
            bank: VIO
            connection: manual
            desc: Extra clock input for FPGA target
            port_type: inout
          }
          {
            name: POR_BUTTON_N
            type: InputStd
            bank: VIO
            connection: manual
            desc: Power-on reset button input
            port_type: inout
          }
          {
            name: IO_CLKOUT
            type: BidirStd
            bank: VIO
            connection: manual
            desc: Manual clock output for SCA setup
            port_type: inout
          }
          {
            name: IO_TRIGGER
            type: BidirStd
            bank: VIO
            connection: manual
            desc: Manual trigger output for SCA setup
            port_type: inout
          }
        ]
      }
      pinmux:
      {
        special_signals:
        [
          {
            name: tap0
            pad: MIO0
            desc: TAP strap signal.
            idx: 0
          }
          {
            name: tap1
            pad: MIO1
            desc: TAP strap signal.
            idx: 1
          }
          {
            name: dft0
            pad: MIO2
            desc: DFT strap signal.
            idx: 2
          }
          {
            name: dft1
            pad: MIO3
            desc: DFT strap signal.
            idx: 3
          }
          {
            name: tck
            pad: MIO4
            desc: JTAG tck signal.
            idx: 4
          }
          {
            name: tms
            pad: MIO5
            desc: JTAG tms signal.
            idx: 5
          }
          {
            name: trst_n
            pad: MIO6
            desc: JTAG trst_n signal.
            idx: 6
          }
          {
            name: tdi
            pad: MIO7
            desc: JTAG tdi signal.
            idx: 7
          }
          {
            name: tdo
            pad: MIO8
            desc: JTAG tdo signal.
            idx: 8
          }
        ]
      }
    }
  ]
  incoming_alert: {}
  incoming_interrupt: {}
  exported_clks: {}
  racl:
  {
    error_response: true
    ctn_uid_bit_lsb: 0
    ctn_uid_bit_msb: 4
    role_bit_lsb: 5
    role_bit_msb: 8
    roles:
    {
      ROT:
      {
        role_id: 0
      }
      ROLE1:
      {
        role_id: 1
      }
      SOC:
      {
        role_id: 2
      }
    }
    policies:
    {
      Null:
      [
        {
          name: ALL_RD_WR
          desc: Standard policies allowing all roles to access a register
          allowed_rd:
          [
            ROT
            ROLE1
            SOC
          ]
          allowed_wr:
          [
            ROT
            ROLE1
            SOC
          ]
          rd_default: 7
          wr_default: 7
        }
        {
          name: ROT_PRIVATE
          rot_private: true
          desc: Standard policies allowing only the ROT role to access a register
          allowed_rd:
          [
            ROT
          ]
          allowed_wr:
          [
            ROT
          ]
          rd_default: 1
          wr_default: 1
        }
        {
          name: SOC_ROT
          desc: Custom policy
          allowed_rd:
          [
            ROT
            SOC
          ]
          allowed_wr:
          [
            ROT
            SOC
          ]
          rd_default: 5
          wr_default: 5
        }
      ]
    }
    nr_role_bits: 4
    nr_ctn_uid_bits: 5
    nr_policies: 3
    rot_private_policy_rd: 1
    rot_private_policy_wr: 1
  }
  wakeups:
  [
    {
      name: pin_wkup_req
      width: "1"
      module: pinmux_aon
    }
    {
      name: wkup_req
      width: "1"
      module: aon_timer_aon
    }
    {
      name: wkup_internal_req
      width: "1"
      module: soc_proxy
    }
    {
      name: wkup_external_req
      width: "1"
      module: soc_proxy
    }
  ]
  unmanaged_resets: {}
  exported_rsts: {}
  alert:
  [
    {
      name: uart0_fatal_fault
      width: 1
      type: alert
      async: "1"
      module_name: uart0
      desc: uart0 fatal_fault alert
      lpg_name: peri_lc_io_div4_0
      lpg_idx: 0
    }
    {
      name: gpio_fatal_fault
      width: 1
      type: alert
      async: "1"
      module_name: gpio
      desc: gpio fatal_fault alert
      lpg_name: peri_lc_io_div4_0
      lpg_idx: 0
    }
    {
      name: spi_device_fatal_fault
      width: 1
      type: alert
      async: "1"
      module_name: spi_device
      desc: spi_device fatal_fault alert
      lpg_name: peri_spi_device_0
      lpg_idx: 1
    }
    {
      name: i2c0_fatal_fault
      width: 1
      type: alert
      async: "1"
      module_name: i2c0
      desc: i2c0 fatal_fault alert
      lpg_name: peri_i2c0_0
      lpg_idx: 2
    }
    {
      name: rv_timer_fatal_fault
      width: 1
      type: alert
      async: "1"
      module_name: rv_timer
      desc: rv_timer fatal_fault alert
      lpg_name: timers_lc_io_div4_0
      lpg_idx: 3
    }
    {
      name: otp_ctrl_fatal_macro_error
      width: 1
      type: alert
      async: "1"
      module_name: otp_ctrl
      desc: otp_ctrl fatal_macro_error alert
      lpg_name: secure_lc_io_div4_0
      lpg_idx: 4
    }
    {
      name: otp_ctrl_fatal_check_error
      width: 1
      type: alert
      async: "1"
      module_name: otp_ctrl
      desc: otp_ctrl fatal_check_error alert
      lpg_name: secure_lc_io_div4_0
      lpg_idx: 4
    }
    {
      name: otp_ctrl_fatal_bus_integ_error
      width: 1
      type: alert
      async: "1"
      module_name: otp_ctrl
      desc: otp_ctrl fatal_bus_integ_error alert
      lpg_name: secure_lc_io_div4_0
      lpg_idx: 4
    }
    {
      name: otp_ctrl_fatal_prim_otp_alert
      width: 1
      type: alert
      async: "1"
      module_name: otp_ctrl
      desc: otp_ctrl fatal_prim_otp_alert alert
      lpg_name: secure_lc_io_div4_0
      lpg_idx: 4
    }
    {
      name: otp_ctrl_recov_prim_otp_alert
      width: 1
      type: alert
      async: "1"
      module_name: otp_ctrl
      desc: otp_ctrl recov_prim_otp_alert alert
      lpg_name: secure_lc_io_div4_0
      lpg_idx: 4
    }
    {
      name: lc_ctrl_fatal_prog_error
      width: 1
      type: alert
      async: "1"
      module_name: lc_ctrl
      desc: lc_ctrl fatal_prog_error alert
      lpg_name: secure_lc_io_div4_0
      lpg_idx: 4
    }
    {
      name: lc_ctrl_fatal_state_error
      width: 1
      type: alert
      async: "1"
      module_name: lc_ctrl
      desc: lc_ctrl fatal_state_error alert
      lpg_name: secure_lc_io_div4_0
      lpg_idx: 4
    }
    {
      name: lc_ctrl_fatal_bus_integ_error
      width: 1
      type: alert
      async: "1"
      module_name: lc_ctrl
      desc: lc_ctrl fatal_bus_integ_error alert
      lpg_name: secure_lc_io_div4_0
      lpg_idx: 4
    }
    {
      name: spi_host0_fatal_fault
      width: 1
      type: alert
      async: "1"
      module_name: spi_host0
      desc: spi_host0 fatal_fault alert
      lpg_name: peri_spi_host0_0
      lpg_idx: 5
    }
    {
      name: pwrmgr_aon_fatal_fault
      width: 1
      type: alert
      async: "1"
      module_name: pwrmgr_aon
      desc: pwrmgr_aon fatal_fault alert
      lpg_name: powerup_por_io_div4_Aon
      lpg_idx: 6
    }
    {
      name: rstmgr_aon_fatal_fault
      width: 1
      type: alert
      async: "1"
      module_name: rstmgr_aon
      desc: rstmgr_aon fatal_fault alert
      lpg_name: powerup_lc_io_div4_Aon
      lpg_idx: 7
    }
    {
      name: rstmgr_aon_fatal_cnsty_fault
      width: 1
      type: alert
      async: "1"
      module_name: rstmgr_aon
      desc: rstmgr_aon fatal_cnsty_fault alert
      lpg_name: powerup_lc_io_div4_Aon
      lpg_idx: 7
    }
    {
      name: clkmgr_aon_recov_fault
      width: 1
      type: alert
      async: "1"
      module_name: clkmgr_aon
      desc: clkmgr_aon recov_fault alert
      lpg_name: powerup_lc_io_div4_Aon
      lpg_idx: 7
    }
    {
      name: clkmgr_aon_fatal_fault
      width: 1
      type: alert
      async: "1"
      module_name: clkmgr_aon
      desc: clkmgr_aon fatal_fault alert
      lpg_name: powerup_lc_io_div4_Aon
      lpg_idx: 7
    }
    {
      name: pinmux_aon_fatal_fault
      width: 1
      type: alert
      async: "1"
      module_name: pinmux_aon
      desc: pinmux_aon fatal_fault alert
      lpg_name: powerup_lc_io_div4_Aon
      lpg_idx: 7
    }
    {
      name: aon_timer_aon_fatal_fault
      width: 1
      type: alert
      async: "1"
      module_name: aon_timer_aon
      desc: aon_timer_aon fatal_fault alert
      lpg_name: timers_lc_io_div4_Aon
      lpg_idx: 8
    }
    {
      name: soc_proxy_fatal_alert_intg
      width: 1
      type: alert
      async: "1"
      module_name: soc_proxy
      desc: soc_proxy fatal_alert_intg alert
      lpg_name: infra_lc_0
      lpg_idx: 10
    }
    {
      name: soc_proxy_fatal_alert_external_0
      width: 1
      type: alert
      async: "1"
      module_name: soc_proxy
      desc: soc_proxy fatal_alert_external_0 alert
      lpg_name: infra_lc_0
      lpg_idx: 10
    }
    {
      name: soc_proxy_fatal_alert_external_1
      width: 1
      type: alert
      async: "1"
      module_name: soc_proxy
      desc: soc_proxy fatal_alert_external_1 alert
      lpg_name: infra_lc_0
      lpg_idx: 10
    }
    {
      name: soc_proxy_fatal_alert_external_2
      width: 1
      type: alert
      async: "1"
      module_name: soc_proxy
      desc: soc_proxy fatal_alert_external_2 alert
      lpg_name: infra_lc_0
      lpg_idx: 10
    }
    {
      name: soc_proxy_fatal_alert_external_3
      width: 1
      type: alert
      async: "1"
      module_name: soc_proxy
      desc: soc_proxy fatal_alert_external_3 alert
      lpg_name: infra_lc_0
      lpg_idx: 10
    }
    {
      name: soc_proxy_fatal_alert_external_4
      width: 1
      type: alert
      async: "1"
      module_name: soc_proxy
      desc: soc_proxy fatal_alert_external_4 alert
      lpg_name: infra_lc_0
      lpg_idx: 10
    }
    {
      name: soc_proxy_fatal_alert_external_5
      width: 1
      type: alert
      async: "1"
      module_name: soc_proxy
      desc: soc_proxy fatal_alert_external_5 alert
      lpg_name: infra_lc_0
      lpg_idx: 10
    }
    {
      name: soc_proxy_fatal_alert_external_6
      width: 1
      type: alert
      async: "1"
      module_name: soc_proxy
      desc: soc_proxy fatal_alert_external_6 alert
      lpg_name: infra_lc_0
      lpg_idx: 10
    }
    {
      name: soc_proxy_fatal_alert_external_7
      width: 1
      type: alert
      async: "1"
      module_name: soc_proxy
      desc: soc_proxy fatal_alert_external_7 alert
      lpg_name: infra_lc_0
      lpg_idx: 10
    }
    {
      name: soc_proxy_fatal_alert_external_8
      width: 1
      type: alert
      async: "1"
      module_name: soc_proxy
      desc: soc_proxy fatal_alert_external_8 alert
      lpg_name: infra_lc_0
      lpg_idx: 10
    }
    {
      name: soc_proxy_fatal_alert_external_9
      width: 1
      type: alert
      async: "1"
      module_name: soc_proxy
      desc: soc_proxy fatal_alert_external_9 alert
      lpg_name: infra_lc_0
      lpg_idx: 10
    }
    {
      name: soc_proxy_fatal_alert_external_10
      width: 1
      type: alert
      async: "1"
      module_name: soc_proxy
      desc: soc_proxy fatal_alert_external_10 alert
      lpg_name: infra_lc_0
      lpg_idx: 10
    }
    {
      name: soc_proxy_fatal_alert_external_11
      width: 1
      type: alert
      async: "1"
      module_name: soc_proxy
      desc: soc_proxy fatal_alert_external_11 alert
      lpg_name: infra_lc_0
      lpg_idx: 10
    }
    {
      name: soc_proxy_fatal_alert_external_12
      width: 1
      type: alert
      async: "1"
      module_name: soc_proxy
      desc: soc_proxy fatal_alert_external_12 alert
      lpg_name: infra_lc_0
      lpg_idx: 10
    }
    {
      name: soc_proxy_fatal_alert_external_13
      width: 1
      type: alert
      async: "1"
      module_name: soc_proxy
      desc: soc_proxy fatal_alert_external_13 alert
      lpg_name: infra_lc_0
      lpg_idx: 10
    }
    {
      name: soc_proxy_fatal_alert_external_14
      width: 1
      type: alert
      async: "1"
      module_name: soc_proxy
      desc: soc_proxy fatal_alert_external_14 alert
      lpg_name: infra_lc_0
      lpg_idx: 10
    }
    {
      name: soc_proxy_fatal_alert_external_15
      width: 1
      type: alert
      async: "1"
      module_name: soc_proxy
      desc: soc_proxy fatal_alert_external_15 alert
      lpg_name: infra_lc_0
      lpg_idx: 10
    }
    {
      name: soc_proxy_fatal_alert_external_16
      width: 1
      type: alert
      async: "1"
      module_name: soc_proxy
      desc: soc_proxy fatal_alert_external_16 alert
      lpg_name: infra_lc_0
      lpg_idx: 10
    }
    {
      name: soc_proxy_fatal_alert_external_17
      width: 1
      type: alert
      async: "1"
      module_name: soc_proxy
      desc: soc_proxy fatal_alert_external_17 alert
      lpg_name: infra_lc_0
      lpg_idx: 10
    }
    {
      name: soc_proxy_fatal_alert_external_18
      width: 1
      type: alert
      async: "1"
      module_name: soc_proxy
      desc: soc_proxy fatal_alert_external_18 alert
      lpg_name: infra_lc_0
      lpg_idx: 10
    }
    {
      name: soc_proxy_fatal_alert_external_19
      width: 1
      type: alert
      async: "1"
      module_name: soc_proxy
      desc: soc_proxy fatal_alert_external_19 alert
      lpg_name: infra_lc_0
      lpg_idx: 10
    }
    {
      name: soc_proxy_fatal_alert_external_20
      width: 1
      type: alert
      async: "1"
      module_name: soc_proxy
      desc: soc_proxy fatal_alert_external_20 alert
      lpg_name: infra_lc_0
      lpg_idx: 10
    }
    {
      name: soc_proxy_fatal_alert_external_21
      width: 1
      type: alert
      async: "1"
      module_name: soc_proxy
      desc: soc_proxy fatal_alert_external_21 alert
      lpg_name: infra_lc_0
      lpg_idx: 10
    }
    {
      name: soc_proxy_fatal_alert_external_22
      width: 1
      type: alert
      async: "1"
      module_name: soc_proxy
      desc: soc_proxy fatal_alert_external_22 alert
      lpg_name: infra_lc_0
      lpg_idx: 10
    }
    {
      name: soc_proxy_fatal_alert_external_23
      width: 1
      type: alert
      async: "1"
      module_name: soc_proxy
      desc: soc_proxy fatal_alert_external_23 alert
      lpg_name: infra_lc_0
      lpg_idx: 10
    }
    {
      name: soc_proxy_recov_alert_external_0
      width: 1
      type: alert
      async: "1"
      module_name: soc_proxy
      desc: soc_proxy recov_alert_external_0 alert
      lpg_name: infra_lc_0
      lpg_idx: 10
    }
    {
      name: soc_proxy_recov_alert_external_1
      width: 1
      type: alert
      async: "1"
      module_name: soc_proxy
      desc: soc_proxy recov_alert_external_1 alert
      lpg_name: infra_lc_0
      lpg_idx: 10
    }
    {
      name: soc_proxy_recov_alert_external_2
      width: 1
      type: alert
      async: "1"
      module_name: soc_proxy
      desc: soc_proxy recov_alert_external_2 alert
      lpg_name: infra_lc_0
      lpg_idx: 10
    }
    {
      name: soc_proxy_recov_alert_external_3
      width: 1
      type: alert
      async: "1"
      module_name: soc_proxy
      desc: soc_proxy recov_alert_external_3 alert
      lpg_name: infra_lc_0
      lpg_idx: 10
    }
    {
      name: sram_ctrl_ret_aon_fatal_error
      width: 1
      type: alert
      async: "1"
      module_name: sram_ctrl_ret_aon
      desc: sram_ctrl_ret_aon fatal_error alert
      lpg_name: infra_lc_io_div4_Aon
      lpg_idx: 11
    }
    {
      name: rv_dm_fatal_fault
      width: 1
      type: alert
      async: "1"
      module_name: rv_dm
      desc: rv_dm fatal_fault alert
      lpg_name: infra_sys_0
      lpg_idx: 12
    }
    {
      name: rv_plic_fatal_fault
      width: 1
      type: alert
      async: "1"
      module_name: rv_plic
      desc: rv_plic fatal_fault alert
      lpg_name: secure_lc_0
      lpg_idx: 13
    }
    {
      name: aes_recov_ctrl_update_err
      width: 1
      type: alert
      async: "1"
      module_name: aes
      desc: aes recov_ctrl_update_err alert
      lpg_name: aes_trans_lc_0
      lpg_idx: 14
    }
    {
      name: aes_fatal_fault
      width: 1
      type: alert
      async: "1"
      module_name: aes
      desc: aes fatal_fault alert
      lpg_name: aes_trans_lc_0
      lpg_idx: 14
    }
    {
      name: hmac_fatal_fault
      width: 1
      type: alert
      async: "1"
      module_name: hmac
      desc: hmac fatal_fault alert
      lpg_name: hmac_trans_lc_0
      lpg_idx: 15
    }
    {
      name: kmac_recov_operation_err
      width: 1
      type: alert
      async: "1"
      module_name: kmac
      desc: kmac recov_operation_err alert
      lpg_name: kmac_trans_lc_0
      lpg_idx: 16
    }
    {
      name: kmac_fatal_fault_err
      width: 1
      type: alert
      async: "1"
      module_name: kmac
      desc: kmac fatal_fault_err alert
      lpg_name: kmac_trans_lc_0
      lpg_idx: 16
    }
    {
      name: otbn_fatal
      width: 1
      type: alert
      async: "1"
      module_name: otbn
      desc: otbn fatal alert
      lpg_name: otbn_trans_lc_0
      lpg_idx: 17
    }
    {
      name: otbn_recov
      width: 1
      type: alert
      async: "1"
      module_name: otbn
      desc: otbn recov alert
      lpg_name: otbn_trans_lc_0
      lpg_idx: 17
    }
    {
      name: keymgr_dpe_recov_operation_err
      width: 1
      type: alert
      async: "1"
      module_name: keymgr_dpe
      desc: keymgr_dpe recov_operation_err alert
      lpg_name: secure_lc_0
      lpg_idx: 13
    }
    {
      name: keymgr_dpe_fatal_fault_err
      width: 1
      type: alert
      async: "1"
      module_name: keymgr_dpe
      desc: keymgr_dpe fatal_fault_err alert
      lpg_name: secure_lc_0
      lpg_idx: 13
    }
    {
      name: csrng_recov_alert
      width: 1
      type: alert
      async: "1"
      module_name: csrng
      desc: csrng recov_alert alert
      lpg_name: secure_lc_0
      lpg_idx: 13
    }
    {
      name: csrng_fatal_alert
      width: 1
      type: alert
      async: "1"
      module_name: csrng
      desc: csrng fatal_alert alert
      lpg_name: secure_lc_0
      lpg_idx: 13
    }
    {
      name: edn0_recov_alert
      width: 1
      type: alert
      async: "1"
      module_name: edn0
      desc: edn0 recov_alert alert
      lpg_name: secure_lc_0
      lpg_idx: 13
    }
    {
      name: edn0_fatal_alert
      width: 1
      type: alert
      async: "1"
      module_name: edn0
      desc: edn0 fatal_alert alert
      lpg_name: secure_lc_0
      lpg_idx: 13
    }
    {
      name: edn1_recov_alert
      width: 1
      type: alert
      async: "1"
      module_name: edn1
      desc: edn1 recov_alert alert
      lpg_name: secure_lc_0
      lpg_idx: 13
    }
    {
      name: edn1_fatal_alert
      width: 1
      type: alert
      async: "1"
      module_name: edn1
      desc: edn1 fatal_alert alert
      lpg_name: secure_lc_0
      lpg_idx: 13
    }
    {
      name: sram_ctrl_main_fatal_error
      width: 1
      type: alert
      async: "1"
      module_name: sram_ctrl_main
      desc: sram_ctrl_main fatal_error alert
      lpg_name: infra_lc_0
      lpg_idx: 10
    }
    {
      name: sram_ctrl_mbox_fatal_error
      width: 1
      type: alert
      async: "1"
      module_name: sram_ctrl_mbox
      desc: sram_ctrl_mbox fatal_error alert
      lpg_name: infra_lc_0
      lpg_idx: 10
    }
    {
      name: rom_ctrl0_fatal
      width: 1
      type: alert
      async: "1"
      module_name: rom_ctrl0
      desc: rom_ctrl0 fatal alert
      lpg_name: infra_lc_0
      lpg_idx: 10
    }
    {
      name: rom_ctrl1_fatal
      width: 1
      type: alert
      async: "1"
      module_name: rom_ctrl1
      desc: rom_ctrl1 fatal alert
      lpg_name: infra_lc_0
      lpg_idx: 10
    }
    {
      name: dma_fatal_fault
      width: 1
      type: alert
      async: "1"
      module_name: dma
      desc: dma fatal_fault alert
      lpg_name: infra_lc_0
      lpg_idx: 10
    }
    {
      name: mbx0_fatal_fault
      width: 1
      type: alert
      async: "1"
      module_name: mbx0
      desc: mbx0 fatal_fault alert
      lpg_name: infra_lc_0
      lpg_idx: 10
    }
    {
      name: mbx0_recov_fault
      width: 1
      type: alert
      async: "1"
      module_name: mbx0
      desc: mbx0 recov_fault alert
      lpg_name: infra_lc_0
      lpg_idx: 10
    }
    {
      name: mbx1_fatal_fault
      width: 1
      type: alert
      async: "1"
      module_name: mbx1
      desc: mbx1 fatal_fault alert
      lpg_name: infra_lc_0
      lpg_idx: 10
    }
    {
      name: mbx1_recov_fault
      width: 1
      type: alert
      async: "1"
      module_name: mbx1
      desc: mbx1 recov_fault alert
      lpg_name: infra_lc_0
      lpg_idx: 10
    }
    {
      name: mbx2_fatal_fault
      width: 1
      type: alert
      async: "1"
      module_name: mbx2
      desc: mbx2 fatal_fault alert
      lpg_name: infra_lc_0
      lpg_idx: 10
    }
    {
      name: mbx2_recov_fault
      width: 1
      type: alert
      async: "1"
      module_name: mbx2
      desc: mbx2 recov_fault alert
      lpg_name: infra_lc_0
      lpg_idx: 10
    }
    {
      name: mbx3_fatal_fault
      width: 1
      type: alert
      async: "1"
      module_name: mbx3
      desc: mbx3 fatal_fault alert
      lpg_name: infra_lc_0
      lpg_idx: 10
    }
    {
      name: mbx3_recov_fault
      width: 1
      type: alert
      async: "1"
      module_name: mbx3
      desc: mbx3 recov_fault alert
      lpg_name: infra_lc_0
      lpg_idx: 10
    }
    {
      name: mbx4_fatal_fault
      width: 1
      type: alert
      async: "1"
      module_name: mbx4
      desc: mbx4 fatal_fault alert
      lpg_name: infra_lc_0
      lpg_idx: 10
    }
    {
      name: mbx4_recov_fault
      width: 1
      type: alert
      async: "1"
      module_name: mbx4
      desc: mbx4 recov_fault alert
      lpg_name: infra_lc_0
      lpg_idx: 10
    }
    {
      name: mbx5_fatal_fault
      width: 1
      type: alert
      async: "1"
      module_name: mbx5
      desc: mbx5 fatal_fault alert
      lpg_name: infra_lc_0
      lpg_idx: 10
    }
    {
      name: mbx5_recov_fault
      width: 1
      type: alert
      async: "1"
      module_name: mbx5
      desc: mbx5 recov_fault alert
      lpg_name: infra_lc_0
      lpg_idx: 10
    }
    {
      name: mbx6_fatal_fault
      width: 1
      type: alert
      async: "1"
      module_name: mbx6
      desc: mbx6 fatal_fault alert
      lpg_name: infra_lc_0
      lpg_idx: 10
    }
    {
      name: mbx6_recov_fault
      width: 1
      type: alert
      async: "1"
      module_name: mbx6
      desc: mbx6 recov_fault alert
      lpg_name: infra_lc_0
      lpg_idx: 10
    }
    {
      name: mbx_jtag_fatal_fault
      width: 1
      type: alert
      async: "1"
      module_name: mbx_jtag
      desc: mbx_jtag fatal_fault alert
      lpg_name: infra_lc_0
      lpg_idx: 10
    }
    {
      name: mbx_jtag_recov_fault
      width: 1
      type: alert
      async: "1"
      module_name: mbx_jtag
      desc: mbx_jtag recov_fault alert
      lpg_name: infra_lc_0
      lpg_idx: 10
    }
    {
      name: mbx_pcie0_fatal_fault
      width: 1
      type: alert
      async: "1"
      module_name: mbx_pcie0
      desc: mbx_pcie0 fatal_fault alert
      lpg_name: infra_lc_0
      lpg_idx: 10
    }
    {
      name: mbx_pcie0_recov_fault
      width: 1
      type: alert
      async: "1"
      module_name: mbx_pcie0
      desc: mbx_pcie0 recov_fault alert
      lpg_name: infra_lc_0
      lpg_idx: 10
    }
    {
      name: mbx_pcie1_fatal_fault
      width: 1
      type: alert
      async: "1"
      module_name: mbx_pcie1
      desc: mbx_pcie1 fatal_fault alert
      lpg_name: infra_lc_0
      lpg_idx: 10
    }
    {
      name: mbx_pcie1_recov_fault
      width: 1
      type: alert
      async: "1"
      module_name: mbx_pcie1
      desc: mbx_pcie1 recov_fault alert
      lpg_name: infra_lc_0
      lpg_idx: 10
    }
    {
      name: soc_dbg_ctrl_fatal_fault
      width: 1
      type: alert
      async: "1"
      module_name: soc_dbg_ctrl
      desc: soc_dbg_ctrl fatal_fault alert
      lpg_name: secure_lc_io_div4_0
      lpg_idx: 4
    }
    {
      name: soc_dbg_ctrl_recov_ctrl_update_err
      width: 1
      type: alert
      async: "1"
      module_name: soc_dbg_ctrl
      desc: soc_dbg_ctrl recov_ctrl_update_err alert
      lpg_name: secure_lc_io_div4_0
      lpg_idx: 4
    }
    {
      name: racl_ctrl_fatal_fault
      width: 1
      type: alert
      async: "1"
      module_name: racl_ctrl
      desc: racl_ctrl fatal_fault alert
      lpg_name: infra_lc_0
      lpg_idx: 10
    }
    {
      name: racl_ctrl_recov_ctrl_update_err
      width: 1
      type: alert
      async: "1"
      module_name: racl_ctrl
      desc: racl_ctrl recov_ctrl_update_err alert
      lpg_name: infra_lc_0
      lpg_idx: 10
    }
    {
      name: ac_range_check_recov_ctrl_update_err
      width: 1
      type: alert
      async: "1"
      module_name: ac_range_check
      desc: ac_range_check recov_ctrl_update_err alert
      lpg_name: secure_lc_0
      lpg_idx: 13
    }
    {
      name: ac_range_check_fatal_fault
      width: 1
      type: alert
      async: "1"
      module_name: ac_range_check
      desc: ac_range_check fatal_fault alert
      lpg_name: secure_lc_0
      lpg_idx: 13
    }
    {
      name: rv_core_ibex_fatal_sw_err
      width: 1
      type: alert
      async: "1"
      module_name: rv_core_ibex
      desc: rv_core_ibex fatal_sw_err alert
      lpg_name: infra_lc_0
      lpg_idx: 10
    }
    {
      name: rv_core_ibex_recov_sw_err
      width: 1
      type: alert
      async: "1"
      module_name: rv_core_ibex
      desc: rv_core_ibex recov_sw_err alert
      lpg_name: infra_lc_0
      lpg_idx: 10
    }
    {
      name: rv_core_ibex_fatal_hw_err
      width: 1
      type: alert
      async: "1"
      module_name: rv_core_ibex
      desc: rv_core_ibex fatal_hw_err alert
      lpg_name: infra_lc_0
      lpg_idx: 10
    }
    {
      name: rv_core_ibex_recov_hw_err
      width: 1
      type: alert
      async: "1"
      module_name: rv_core_ibex
      desc: rv_core_ibex recov_hw_err alert
      lpg_name: infra_lc_0
      lpg_idx: 10
    }
  ]
  outgoing_alert: {}
  interrupt:
  [
    {
      name: uart0_tx_watermark
      width: 1
      type: interrupt
      module_name: uart0
      desc: uart0 tx_watermark interrupt
      intr_type: IntrType.Status
      default_val: true
      incoming: false
    }
    {
      name: uart0_rx_watermark
      width: 1
      type: interrupt
      module_name: uart0
      desc: uart0 rx_watermark interrupt
      intr_type: IntrType.Status
      default_val: false
      incoming: false
    }
    {
      name: uart0_tx_done
      width: 1
      type: interrupt
      module_name: uart0
      desc: uart0 tx_done interrupt
      intr_type: IntrType.Event
      default_val: false
      incoming: false
    }
    {
      name: uart0_rx_overflow
      width: 1
      type: interrupt
      module_name: uart0
      desc: uart0 rx_overflow interrupt
      intr_type: IntrType.Event
      default_val: false
      incoming: false
    }
    {
      name: uart0_rx_frame_err
      width: 1
      type: interrupt
      module_name: uart0
      desc: uart0 rx_frame_err interrupt
      intr_type: IntrType.Event
      default_val: false
      incoming: false
    }
    {
      name: uart0_rx_break_err
      width: 1
      type: interrupt
      module_name: uart0
      desc: uart0 rx_break_err interrupt
      intr_type: IntrType.Event
      default_val: false
      incoming: false
    }
    {
      name: uart0_rx_timeout
      width: 1
      type: interrupt
      module_name: uart0
      desc: uart0 rx_timeout interrupt
      intr_type: IntrType.Event
      default_val: false
      incoming: false
    }
    {
      name: uart0_rx_parity_err
      width: 1
      type: interrupt
      module_name: uart0
      desc: uart0 rx_parity_err interrupt
      intr_type: IntrType.Event
      default_val: false
      incoming: false
    }
    {
      name: uart0_tx_empty
      width: 1
      type: interrupt
      module_name: uart0
      desc: uart0 tx_empty interrupt
      intr_type: IntrType.Status
      default_val: true
      incoming: false
    }
    {
      name: gpio_gpio
      width: 32
      type: interrupt
      module_name: gpio
      desc: gpio gpio interrupt
      intr_type: IntrType.Event
      default_val: false
      incoming: false
    }
    {
      name: spi_device_upload_cmdfifo_not_empty
      width: 1
      type: interrupt
      module_name: spi_device
      desc: spi_device upload_cmdfifo_not_empty interrupt
      intr_type: IntrType.Event
      default_val: false
      incoming: false
    }
    {
      name: spi_device_upload_payload_not_empty
      width: 1
      type: interrupt
      module_name: spi_device
      desc: spi_device upload_payload_not_empty interrupt
      intr_type: IntrType.Event
      default_val: false
      incoming: false
    }
    {
      name: spi_device_upload_payload_overflow
      width: 1
      type: interrupt
      module_name: spi_device
      desc: spi_device upload_payload_overflow interrupt
      intr_type: IntrType.Event
      default_val: false
      incoming: false
    }
    {
      name: spi_device_readbuf_watermark
      width: 1
      type: interrupt
      module_name: spi_device
      desc: spi_device readbuf_watermark interrupt
      intr_type: IntrType.Event
      default_val: false
      incoming: false
    }
    {
      name: spi_device_readbuf_flip
      width: 1
      type: interrupt
      module_name: spi_device
      desc: spi_device readbuf_flip interrupt
      intr_type: IntrType.Event
      default_val: false
      incoming: false
    }
    {
      name: spi_device_tpm_header_not_empty
      width: 1
      type: interrupt
      module_name: spi_device
      desc: spi_device tpm_header_not_empty interrupt
      intr_type: IntrType.Status
      default_val: false
      incoming: false
    }
    {
      name: spi_device_tpm_rdfifo_cmd_end
      width: 1
      type: interrupt
      module_name: spi_device
      desc: spi_device tpm_rdfifo_cmd_end interrupt
      intr_type: IntrType.Event
      default_val: false
      incoming: false
    }
    {
      name: spi_device_tpm_rdfifo_drop
      width: 1
      type: interrupt
      module_name: spi_device
      desc: spi_device tpm_rdfifo_drop interrupt
      intr_type: IntrType.Event
      default_val: false
      incoming: false
    }
    {
      name: i2c0_fmt_threshold
      width: 1
      type: interrupt
      module_name: i2c0
      desc: i2c0 fmt_threshold interrupt
      intr_type: IntrType.Status
      default_val: false
      incoming: false
    }
    {
      name: i2c0_rx_threshold
      width: 1
      type: interrupt
      module_name: i2c0
      desc: i2c0 rx_threshold interrupt
      intr_type: IntrType.Status
      default_val: false
      incoming: false
    }
    {
      name: i2c0_acq_threshold
      width: 1
      type: interrupt
      module_name: i2c0
      desc: i2c0 acq_threshold interrupt
      intr_type: IntrType.Status
      default_val: false
      incoming: false
    }
    {
      name: i2c0_rx_overflow
      width: 1
      type: interrupt
      module_name: i2c0
      desc: i2c0 rx_overflow interrupt
      intr_type: IntrType.Event
      default_val: false
      incoming: false
    }
    {
      name: i2c0_controller_halt
      width: 1
      type: interrupt
      module_name: i2c0
      desc: i2c0 controller_halt interrupt
      intr_type: IntrType.Status
      default_val: false
      incoming: false
    }
    {
      name: i2c0_scl_interference
      width: 1
      type: interrupt
      module_name: i2c0
      desc: i2c0 scl_interference interrupt
      intr_type: IntrType.Event
      default_val: false
      incoming: false
    }
    {
      name: i2c0_sda_interference
      width: 1
      type: interrupt
      module_name: i2c0
      desc: i2c0 sda_interference interrupt
      intr_type: IntrType.Event
      default_val: false
      incoming: false
    }
    {
      name: i2c0_stretch_timeout
      width: 1
      type: interrupt
      module_name: i2c0
      desc: i2c0 stretch_timeout interrupt
      intr_type: IntrType.Event
      default_val: false
      incoming: false
    }
    {
      name: i2c0_sda_unstable
      width: 1
      type: interrupt
      module_name: i2c0
      desc: i2c0 sda_unstable interrupt
      intr_type: IntrType.Event
      default_val: false
      incoming: false
    }
    {
      name: i2c0_cmd_complete
      width: 1
      type: interrupt
      module_name: i2c0
      desc: i2c0 cmd_complete interrupt
      intr_type: IntrType.Event
      default_val: false
      incoming: false
    }
    {
      name: i2c0_tx_stretch
      width: 1
      type: interrupt
      module_name: i2c0
      desc: i2c0 tx_stretch interrupt
      intr_type: IntrType.Status
      default_val: false
      incoming: false
    }
    {
      name: i2c0_tx_threshold
      width: 1
      type: interrupt
      module_name: i2c0
      desc: i2c0 tx_threshold interrupt
      intr_type: IntrType.Status
      default_val: false
      incoming: false
    }
    {
      name: i2c0_acq_stretch
      width: 1
      type: interrupt
      module_name: i2c0
      desc: i2c0 acq_stretch interrupt
      intr_type: IntrType.Status
      default_val: false
      incoming: false
    }
    {
      name: i2c0_unexp_stop
      width: 1
      type: interrupt
      module_name: i2c0
      desc: i2c0 unexp_stop interrupt
      intr_type: IntrType.Event
      default_val: false
      incoming: false
    }
    {
      name: i2c0_host_timeout
      width: 1
      type: interrupt
      module_name: i2c0
      desc: i2c0 host_timeout interrupt
      intr_type: IntrType.Event
      default_val: false
      incoming: false
    }
    {
      name: rv_timer_timer_expired_hart0_timer0
      width: 1
      type: interrupt
      module_name: rv_timer
      desc: rv_timer timer_expired_hart0_timer0 interrupt
      intr_type: IntrType.Event
      default_val: false
      incoming: false
    }
    {
      name: otp_ctrl_otp_operation_done
      width: 1
      type: interrupt
      module_name: otp_ctrl
      desc: otp_ctrl otp_operation_done interrupt
      intr_type: IntrType.Event
      default_val: false
      incoming: false
    }
    {
      name: otp_ctrl_otp_error
      width: 1
      type: interrupt
      module_name: otp_ctrl
      desc: otp_ctrl otp_error interrupt
      intr_type: IntrType.Event
      default_val: false
      incoming: false
    }
    {
      name: alert_handler_classa
      width: 1
      type: interrupt
      module_name: alert_handler
      desc: alert_handler classa interrupt
      intr_type: IntrType.Event
      default_val: false
      incoming: false
    }
    {
      name: alert_handler_classb
      width: 1
      type: interrupt
      module_name: alert_handler
      desc: alert_handler classb interrupt
      intr_type: IntrType.Event
      default_val: false
      incoming: false
    }
    {
      name: alert_handler_classc
      width: 1
      type: interrupt
      module_name: alert_handler
      desc: alert_handler classc interrupt
      intr_type: IntrType.Event
      default_val: false
      incoming: false
    }
    {
      name: alert_handler_classd
      width: 1
      type: interrupt
      module_name: alert_handler
      desc: alert_handler classd interrupt
      intr_type: IntrType.Event
      default_val: false
      incoming: false
    }
    {
      name: spi_host0_error
      width: 1
      type: interrupt
      module_name: spi_host0
      desc: spi_host0 error interrupt
      intr_type: IntrType.Event
      default_val: false
      incoming: false
    }
    {
      name: spi_host0_spi_event
      width: 1
      type: interrupt
      module_name: spi_host0
      desc: spi_host0 spi_event interrupt
      intr_type: IntrType.Status
      default_val: false
      incoming: false
    }
    {
      name: pwrmgr_aon_wakeup
      width: 1
      type: interrupt
      module_name: pwrmgr_aon
      desc: pwrmgr_aon wakeup interrupt
      intr_type: IntrType.Event
      default_val: false
      incoming: false
    }
    {
      name: aon_timer_aon_wkup_timer_expired
      width: 1
      type: interrupt
      module_name: aon_timer_aon
      desc: aon_timer_aon wkup_timer_expired interrupt
      intr_type: IntrType.Event
      default_val: false
      incoming: false
    }
    {
      name: aon_timer_aon_wdog_timer_bark
      width: 1
      type: interrupt
      module_name: aon_timer_aon
      desc: aon_timer_aon wdog_timer_bark interrupt
      intr_type: IntrType.Event
      default_val: false
      incoming: false
    }
    {
      name: soc_proxy_external
      width: 32
      type: interrupt
      module_name: soc_proxy
      desc: soc_proxy external interrupt
      intr_type: IntrType.Event
      default_val: false
      incoming: false
    }
    {
      name: hmac_hmac_done
      width: 1
      type: interrupt
      module_name: hmac
      desc: hmac hmac_done interrupt
      intr_type: IntrType.Event
      default_val: false
      incoming: false
    }
    {
      name: hmac_fifo_empty
      width: 1
      type: interrupt
      module_name: hmac
      desc: hmac fifo_empty interrupt
      intr_type: IntrType.Status
      default_val: false
      incoming: false
    }
    {
      name: hmac_hmac_err
      width: 1
      type: interrupt
      module_name: hmac
      desc: hmac hmac_err interrupt
      intr_type: IntrType.Event
      default_val: false
      incoming: false
    }
    {
      name: kmac_kmac_done
      width: 1
      type: interrupt
      module_name: kmac
      desc: kmac kmac_done interrupt
      intr_type: IntrType.Event
      default_val: false
      incoming: false
    }
    {
      name: kmac_fifo_empty
      width: 1
      type: interrupt
      module_name: kmac
      desc: kmac fifo_empty interrupt
      intr_type: IntrType.Status
      default_val: false
      incoming: false
    }
    {
      name: kmac_kmac_err
      width: 1
      type: interrupt
      module_name: kmac
      desc: kmac kmac_err interrupt
      intr_type: IntrType.Event
      default_val: false
      incoming: false
    }
    {
      name: otbn_done
      width: 1
      type: interrupt
      module_name: otbn
      desc: otbn done interrupt
      intr_type: IntrType.Event
      default_val: false
      incoming: false
    }
    {
      name: keymgr_dpe_op_done
      width: 1
      type: interrupt
      module_name: keymgr_dpe
      desc: keymgr_dpe op_done interrupt
      intr_type: IntrType.Event
      default_val: false
      incoming: false
    }
    {
      name: csrng_cs_cmd_req_done
      width: 1
      type: interrupt
      module_name: csrng
      desc: csrng cs_cmd_req_done interrupt
      intr_type: IntrType.Event
      default_val: false
      incoming: false
    }
    {
      name: csrng_cs_entropy_req
      width: 1
      type: interrupt
      module_name: csrng
      desc: csrng cs_entropy_req interrupt
      intr_type: IntrType.Event
      default_val: false
      incoming: false
    }
    {
      name: csrng_cs_hw_inst_exc
      width: 1
      type: interrupt
      module_name: csrng
      desc: csrng cs_hw_inst_exc interrupt
      intr_type: IntrType.Event
      default_val: false
      incoming: false
    }
    {
      name: csrng_cs_fatal_err
      width: 1
      type: interrupt
      module_name: csrng
      desc: csrng cs_fatal_err interrupt
      intr_type: IntrType.Event
      default_val: false
      incoming: false
    }
    {
      name: edn0_edn_cmd_req_done
      width: 1
      type: interrupt
      module_name: edn0
      desc: edn0 edn_cmd_req_done interrupt
      intr_type: IntrType.Event
      default_val: false
      incoming: false
    }
    {
      name: edn0_edn_fatal_err
      width: 1
      type: interrupt
      module_name: edn0
      desc: edn0 edn_fatal_err interrupt
      intr_type: IntrType.Event
      default_val: false
      incoming: false
    }
    {
      name: edn1_edn_cmd_req_done
      width: 1
      type: interrupt
      module_name: edn1
      desc: edn1 edn_cmd_req_done interrupt
      intr_type: IntrType.Event
      default_val: false
      incoming: false
    }
    {
      name: edn1_edn_fatal_err
      width: 1
      type: interrupt
      module_name: edn1
      desc: edn1 edn_fatal_err interrupt
      intr_type: IntrType.Event
      default_val: false
      incoming: false
    }
    {
      name: dma_dma_done
      width: 1
      type: interrupt
      module_name: dma
      desc: dma dma_done interrupt
      intr_type: IntrType.Status
      default_val: false
      incoming: false
    }
    {
      name: dma_dma_chunk_done
      width: 1
      type: interrupt
      module_name: dma
      desc: dma dma_chunk_done interrupt
      intr_type: IntrType.Status
      default_val: false
      incoming: false
    }
    {
      name: dma_dma_error
      width: 1
      type: interrupt
      module_name: dma
      desc: dma dma_error interrupt
      intr_type: IntrType.Status
      default_val: false
      incoming: false
    }
    {
      name: mbx0_mbx_ready
      width: 1
      type: interrupt
      module_name: mbx0
      desc: mbx0 mbx_ready interrupt
      intr_type: IntrType.Event
      default_val: false
      incoming: false
    }
    {
      name: mbx0_mbx_abort
      width: 1
      type: interrupt
      module_name: mbx0
      desc: mbx0 mbx_abort interrupt
      intr_type: IntrType.Event
      default_val: false
      incoming: false
    }
    {
      name: mbx0_mbx_error
      width: 1
      type: interrupt
      module_name: mbx0
      desc: mbx0 mbx_error interrupt
      intr_type: IntrType.Event
      default_val: false
      incoming: false
    }
    {
      name: mbx1_mbx_ready
      width: 1
      type: interrupt
      module_name: mbx1
      desc: mbx1 mbx_ready interrupt
      intr_type: IntrType.Event
      default_val: false
      incoming: false
    }
    {
      name: mbx1_mbx_abort
      width: 1
      type: interrupt
      module_name: mbx1
      desc: mbx1 mbx_abort interrupt
      intr_type: IntrType.Event
      default_val: false
      incoming: false
    }
    {
      name: mbx1_mbx_error
      width: 1
      type: interrupt
      module_name: mbx1
      desc: mbx1 mbx_error interrupt
      intr_type: IntrType.Event
      default_val: false
      incoming: false
    }
    {
      name: mbx2_mbx_ready
      width: 1
      type: interrupt
      module_name: mbx2
      desc: mbx2 mbx_ready interrupt
      intr_type: IntrType.Event
      default_val: false
      incoming: false
    }
    {
      name: mbx2_mbx_abort
      width: 1
      type: interrupt
      module_name: mbx2
      desc: mbx2 mbx_abort interrupt
      intr_type: IntrType.Event
      default_val: false
      incoming: false
    }
    {
      name: mbx2_mbx_error
      width: 1
      type: interrupt
      module_name: mbx2
      desc: mbx2 mbx_error interrupt
      intr_type: IntrType.Event
      default_val: false
      incoming: false
    }
    {
      name: mbx3_mbx_ready
      width: 1
      type: interrupt
      module_name: mbx3
      desc: mbx3 mbx_ready interrupt
      intr_type: IntrType.Event
      default_val: false
      incoming: false
    }
    {
      name: mbx3_mbx_abort
      width: 1
      type: interrupt
      module_name: mbx3
      desc: mbx3 mbx_abort interrupt
      intr_type: IntrType.Event
      default_val: false
      incoming: false
    }
    {
      name: mbx3_mbx_error
      width: 1
      type: interrupt
      module_name: mbx3
      desc: mbx3 mbx_error interrupt
      intr_type: IntrType.Event
      default_val: false
      incoming: false
    }
    {
      name: mbx4_mbx_ready
      width: 1
      type: interrupt
      module_name: mbx4
      desc: mbx4 mbx_ready interrupt
      intr_type: IntrType.Event
      default_val: false
      incoming: false
    }
    {
      name: mbx4_mbx_abort
      width: 1
      type: interrupt
      module_name: mbx4
      desc: mbx4 mbx_abort interrupt
      intr_type: IntrType.Event
      default_val: false
      incoming: false
    }
    {
      name: mbx4_mbx_error
      width: 1
      type: interrupt
      module_name: mbx4
      desc: mbx4 mbx_error interrupt
      intr_type: IntrType.Event
      default_val: false
      incoming: false
    }
    {
      name: mbx5_mbx_ready
      width: 1
      type: interrupt
      module_name: mbx5
      desc: mbx5 mbx_ready interrupt
      intr_type: IntrType.Event
      default_val: false
      incoming: false
    }
    {
      name: mbx5_mbx_abort
      width: 1
      type: interrupt
      module_name: mbx5
      desc: mbx5 mbx_abort interrupt
      intr_type: IntrType.Event
      default_val: false
      incoming: false
    }
    {
      name: mbx5_mbx_error
      width: 1
      type: interrupt
      module_name: mbx5
      desc: mbx5 mbx_error interrupt
      intr_type: IntrType.Event
      default_val: false
      incoming: false
    }
    {
      name: mbx6_mbx_ready
      width: 1
      type: interrupt
      module_name: mbx6
      desc: mbx6 mbx_ready interrupt
      intr_type: IntrType.Event
      default_val: false
      incoming: false
    }
    {
      name: mbx6_mbx_abort
      width: 1
      type: interrupt
      module_name: mbx6
      desc: mbx6 mbx_abort interrupt
      intr_type: IntrType.Event
      default_val: false
      incoming: false
    }
    {
      name: mbx6_mbx_error
      width: 1
      type: interrupt
      module_name: mbx6
      desc: mbx6 mbx_error interrupt
      intr_type: IntrType.Event
      default_val: false
      incoming: false
    }
    {
      name: mbx_jtag_mbx_ready
      width: 1
      type: interrupt
      module_name: mbx_jtag
      desc: mbx_jtag mbx_ready interrupt
      intr_type: IntrType.Event
      default_val: false
      incoming: false
    }
    {
      name: mbx_jtag_mbx_abort
      width: 1
      type: interrupt
      module_name: mbx_jtag
      desc: mbx_jtag mbx_abort interrupt
      intr_type: IntrType.Event
      default_val: false
      incoming: false
    }
    {
      name: mbx_jtag_mbx_error
      width: 1
      type: interrupt
      module_name: mbx_jtag
      desc: mbx_jtag mbx_error interrupt
      intr_type: IntrType.Event
      default_val: false
      incoming: false
    }
    {
      name: mbx_pcie0_mbx_ready
      width: 1
      type: interrupt
      module_name: mbx_pcie0
      desc: mbx_pcie0 mbx_ready interrupt
      intr_type: IntrType.Event
      default_val: false
      incoming: false
    }
    {
      name: mbx_pcie0_mbx_abort
      width: 1
      type: interrupt
      module_name: mbx_pcie0
      desc: mbx_pcie0 mbx_abort interrupt
      intr_type: IntrType.Event
      default_val: false
      incoming: false
    }
    {
      name: mbx_pcie0_mbx_error
      width: 1
      type: interrupt
      module_name: mbx_pcie0
      desc: mbx_pcie0 mbx_error interrupt
      intr_type: IntrType.Event
      default_val: false
      incoming: false
    }
    {
      name: mbx_pcie1_mbx_ready
      width: 1
      type: interrupt
      module_name: mbx_pcie1
      desc: mbx_pcie1 mbx_ready interrupt
      intr_type: IntrType.Event
      default_val: false
      incoming: false
    }
    {
      name: mbx_pcie1_mbx_abort
      width: 1
      type: interrupt
      module_name: mbx_pcie1
      desc: mbx_pcie1 mbx_abort interrupt
      intr_type: IntrType.Event
      default_val: false
      incoming: false
    }
    {
      name: mbx_pcie1_mbx_error
      width: 1
      type: interrupt
      module_name: mbx_pcie1
      desc: mbx_pcie1 mbx_error interrupt
      intr_type: IntrType.Event
      default_val: false
      incoming: false
    }
    {
      name: racl_ctrl_racl_error
      width: 1
      type: interrupt
      module_name: racl_ctrl
      desc: racl_ctrl racl_error interrupt
      intr_type: IntrType.Status
      default_val: false
      incoming: false
    }
    {
      name: ac_range_check_deny_cnt_reached
      width: 1
      type: interrupt
      module_name: ac_range_check
      desc: ac_range_check deny_cnt_reached interrupt
      intr_type: IntrType.Event
      default_val: false
      incoming: false
    }
  ]
  outgoing_interrupt: {}
  alert_module:
  [
    uart0
    gpio
    spi_device
    i2c0
    rv_timer
    otp_ctrl
    lc_ctrl
    spi_host0
    pwrmgr_aon
    rstmgr_aon
    clkmgr_aon
    pinmux_aon
    aon_timer_aon
    soc_proxy
    sram_ctrl_ret_aon
    rv_dm
    rv_plic
    aes
    hmac
    kmac
    otbn
    keymgr_dpe
    csrng
    edn0
    edn1
    sram_ctrl_main
    sram_ctrl_mbox
    rom_ctrl0
    rom_ctrl1
    dma
    mbx0
    mbx1
    mbx2
    mbx3
    mbx4
    mbx5
    mbx6
    mbx_jtag
    mbx_pcie0
    mbx_pcie1
    soc_dbg_ctrl
    racl_ctrl
    ac_range_check
    rv_core_ibex
  ]
  interrupt_module:
  [
    uart0
    gpio
    spi_device
    i2c0
    rv_timer
    otp_ctrl
    alert_handler
    spi_host0
    pwrmgr_aon
    aon_timer_aon
    soc_proxy
    hmac
    kmac
    otbn
    keymgr_dpe
    csrng
    edn0
    edn1
    dma
    mbx0
    mbx1
    mbx2
    mbx3
    mbx4
    mbx5
    mbx6
    mbx_jtag
    mbx_pcie0
    mbx_pcie1
    racl_ctrl
    ac_range_check
  ]
  outgoing_alert_module: {}
  outgoing_interrupt_module: {}
  alert_lpgs:
  [
    {
      name: peri_lc_io_div4_0
      clock_group:
      {
        name: peri
        src: top
        sw_cg: yes
        unique: no
        clocks:
        {
          clk_io_div4_peri: io_div4
          clk_io_div2_peri: io_div2
          clk_aon_peri: aon
        }
      }
      clock_connection: clkmgr_aon_clocks.clk_io_div4_peri
      unmanaged_clock: false
      unmanaged_reset: false
      reset_connection:
      {
        name: lc_io_div4
        domain: "0"
      }
    }
    {
      name: peri_spi_device_0
      clock_group:
      {
        name: peri
        src: top
        sw_cg: yes
        unique: no
        clocks:
        {
          clk_io_div4_peri: io_div4
          clk_io_div2_peri: io_div2
          clk_aon_peri: aon
        }
      }
      clock_connection: clkmgr_aon_clocks.clk_io_div4_peri
      unmanaged_clock: false
      unmanaged_reset: false
      reset_connection:
      {
        name: spi_device
        domain: "0"
      }
    }
    {
      name: peri_i2c0_0
      clock_group:
      {
        name: peri
        src: top
        sw_cg: yes
        unique: no
        clocks:
        {
          clk_io_div4_peri: io_div4
          clk_io_div2_peri: io_div2
          clk_aon_peri: aon
        }
      }
      clock_connection: clkmgr_aon_clocks.clk_io_div4_peri
      unmanaged_clock: false
      unmanaged_reset: false
      reset_connection:
      {
        name: i2c0
        domain: "0"
      }
    }
    {
      name: timers_lc_io_div4_0
      clock_group:
      {
        name: timers
        src: top
        sw_cg: no
        unique: no
        clocks:
        {
          clk_io_div4_timers: io_div4
          clk_aon_timers: aon
        }
      }
      clock_connection: clkmgr_aon_clocks.clk_io_div4_timers
      unmanaged_clock: false
      unmanaged_reset: false
      reset_connection:
      {
        name: lc_io_div4
        domain: "0"
      }
    }
    {
      name: secure_lc_io_div4_0
      clock_group:
      {
        name: secure
        src: top
        sw_cg: no
        unique: no
        clocks:
        {
          clk_io_div4_secure: io_div4
          clk_main_secure: main
        }
      }
      clock_connection: clkmgr_aon_clocks.clk_io_div4_secure
      unmanaged_clock: false
      unmanaged_reset: false
      reset_connection:
      {
        name: lc_io_div4
        domain: "0"
      }
    }
    {
      name: peri_spi_host0_0
      clock_group:
      {
        name: peri
        src: top
        sw_cg: yes
        unique: no
        clocks:
        {
          clk_io_div4_peri: io_div4
          clk_io_div2_peri: io_div2
          clk_aon_peri: aon
        }
      }
      clock_connection: clkmgr_aon_clocks.clk_io_div4_peri
      unmanaged_clock: false
      unmanaged_reset: false
      reset_connection:
      {
        name: spi_host0
        domain: "0"
      }
    }
    {
      name: powerup_por_io_div4_Aon
      clock_group:
      {
        name: powerup
        src: top
        sw_cg: no
        unique: no
        clocks:
        {
          clk_io_div4_powerup: io_div4
          clk_aon_powerup: aon
          clk_main_powerup: main
          clk_io_powerup: io
          clk_io_div2_powerup: io_div2
        }
      }
      clock_connection: clkmgr_aon_clocks.clk_io_div4_powerup
      unmanaged_clock: false
      unmanaged_reset: false
      reset_connection:
      {
        name: por_io_div4
        domain: Aon
      }
    }
    {
      name: powerup_lc_io_div4_Aon
      clock_group:
      {
        name: powerup
        src: top
        sw_cg: no
        unique: no
        clocks:
        {
          clk_io_div4_powerup: io_div4
          clk_aon_powerup: aon
          clk_main_powerup: main
          clk_io_powerup: io
          clk_io_div2_powerup: io_div2
        }
      }
      clock_connection: clkmgr_aon_clocks.clk_io_div4_powerup
      unmanaged_clock: false
      unmanaged_reset: false
      reset_connection:
      {
        name: lc_io_div4
        domain: Aon
      }
    }
    {
      name: timers_lc_io_div4_Aon
      clock_group:
      {
        name: timers
        src: top
        sw_cg: no
        unique: no
        clocks:
        {
          clk_io_div4_timers: io_div4
          clk_aon_timers: aon
        }
      }
      clock_connection: clkmgr_aon_clocks.clk_io_div4_timers
      unmanaged_clock: false
      unmanaged_reset: false
      reset_connection:
      {
        name: lc_io_div4
        domain: Aon
      }
    }
    {
      name: infra_lc_io_div4_0
      clock_group:
      {
        name: infra
        src: top
        sw_cg: no
        unique: no
        clocks:
        {
          clk_io_div4_infra: io_div4
          clk_main_infra: main
          clk_aon_infra: aon
        }
      }
      clock_connection: clkmgr_aon_clocks.clk_io_div4_infra
      unmanaged_clock: false
      unmanaged_reset: false
      reset_connection:
      {
        name: lc_io_div4
        domain: "0"
      }
    }
    {
      name: infra_lc_0
      clock_group:
      {
        name: infra
        src: top
        sw_cg: no
        unique: no
        clocks:
        {
          clk_io_div4_infra: io_div4
          clk_main_infra: main
          clk_aon_infra: aon
        }
      }
      clock_connection: clkmgr_aon_clocks.clk_main_infra
      unmanaged_clock: false
      unmanaged_reset: false
      reset_connection:
      {
        name: lc
        domain: "0"
      }
    }
    {
      name: infra_lc_io_div4_Aon
      clock_group:
      {
        name: infra
        src: top
        sw_cg: no
        unique: no
        clocks:
        {
          clk_io_div4_infra: io_div4
          clk_main_infra: main
          clk_aon_infra: aon
        }
      }
      clock_connection: clkmgr_aon_clocks.clk_io_div4_infra
      unmanaged_clock: false
      unmanaged_reset: false
      reset_connection:
      {
        name: lc_io_div4
        domain: Aon
      }
    }
    {
      name: infra_sys_0
      clock_group:
      {
        name: infra
        src: top
        sw_cg: no
        unique: no
        clocks:
        {
          clk_io_div4_infra: io_div4
          clk_main_infra: main
          clk_aon_infra: aon
        }
      }
      clock_connection: clkmgr_aon_clocks.clk_main_infra
      unmanaged_clock: false
      unmanaged_reset: false
      reset_connection:
      {
        name: sys
        domain: "0"
      }
    }
    {
      name: secure_lc_0
      clock_group:
      {
        name: secure
        src: top
        sw_cg: no
        unique: no
        clocks:
        {
          clk_io_div4_secure: io_div4
          clk_main_secure: main
        }
      }
      clock_connection: clkmgr_aon_clocks.clk_main_secure
      unmanaged_clock: false
      unmanaged_reset: false
      reset_connection:
      {
        name: lc
        domain: "0"
      }
    }
    {
      name: aes_trans_lc_0
      clock_group:
      {
        name: trans
        src: top
        sw_cg: hint
        unique: yes
        clocks:
        {
          clk_main_aes: main
          clk_main_hmac: main
          clk_main_kmac: main
          clk_main_otbn: main
        }
      }
      clock_connection: clkmgr_aon_clocks.clk_main_aes
      unmanaged_clock: false
      unmanaged_reset: false
      reset_connection:
      {
        name: lc
        domain: "0"
      }
    }
    {
      name: hmac_trans_lc_0
      clock_group:
      {
        name: trans
        src: top
        sw_cg: hint
        unique: yes
        clocks:
        {
          clk_main_aes: main
          clk_main_hmac: main
          clk_main_kmac: main
          clk_main_otbn: main
        }
      }
      clock_connection: clkmgr_aon_clocks.clk_main_hmac
      unmanaged_clock: false
      unmanaged_reset: false
      reset_connection:
      {
        name: lc
        domain: "0"
      }
    }
    {
      name: kmac_trans_lc_0
      clock_group:
      {
        name: trans
        src: top
        sw_cg: hint
        unique: yes
        clocks:
        {
          clk_main_aes: main
          clk_main_hmac: main
          clk_main_kmac: main
          clk_main_otbn: main
        }
      }
      clock_connection: clkmgr_aon_clocks.clk_main_kmac
      unmanaged_clock: false
      unmanaged_reset: false
      reset_connection:
      {
        name: lc
        domain: "0"
      }
    }
    {
      name: otbn_trans_lc_0
      clock_group:
      {
        name: trans
        src: top
        sw_cg: hint
        unique: yes
        clocks:
        {
          clk_main_aes: main
          clk_main_hmac: main
          clk_main_kmac: main
          clk_main_otbn: main
        }
      }
      clock_connection: clkmgr_aon_clocks.clk_main_otbn
      unmanaged_clock: false
      unmanaged_reset: false
      reset_connection:
      {
        name: lc
        domain: "0"
      }
    }
  ]
  outgoing_alert_lpgs: {}
  inter_signal:
  {
    signals:
    [
      {
        name: lsio_trigger
        desc:
          '''
          Self-clearing status trigger for the DMA.
          Set when RX or TX FIFOs are past their configured watermarks matching watermark interrupt behaviour.
          '''
        struct: logic
        type: uni
        act: req
        width: 1
        inst_name: uart0
        default: ""
        package: ""
        end_idx: -1
        top_type: broadcast
        top_signame: uart0_lsio_trigger
        index: -1
      }
      {
        name: racl_policies
        desc:
          '''
          Incoming RACL policy vector from a racl_ctrl instance.
          The policy selection vector (parameter) selects the policy for each register.
          '''
        struct: racl_policy_vec
        package: top_racl_pkg
        type: uni
        act: rcv
        width: 1
        inst_name: uart0
        index: -1
      }
      {
        name: racl_error
        desc: RACL error log information of this module.
        struct: racl_error_log
        package: top_racl_pkg
        type: uni
        act: req
        width: 1
        inst_name: uart0
        index: -1
      }
      {
        name: tl
        struct: tl
        package: tlul_pkg
        type: req_rsp
        act: rsp
        width: 1
        inst_name: uart0
        default: ""
        end_idx: -1
        top_signame: uart0_tl
        index: -1
      }
      {
        name: strap_en
        desc:
          '''
          The strap enable signal tells gpio to take a snapshot of the input pins.
          The behaviour of this signal after that event will have no effect.
          '''
        struct: logic
        type: uni
        act: rcv
        width: 1
        default: 1'b0
        inst_name: gpio
        package: ""
        top_signame: pwrmgr_aon_strap
        index: -1
      }
      {
        name: sampled_straps
        desc: This vector contains the sampled strap values.
        struct: gpio_straps
        package: gpio_pkg
        type: uni
        act: req
        width: 1
        default: "'0"
        inst_name: gpio
        index: -1
      }
      {
        name: racl_policies
        desc:
          '''
          Incoming RACL policy vector from a racl_ctrl instance.
          The policy selection vector (parameter) selects the policy for each register.
          '''
        struct: racl_policy_vec
        package: top_racl_pkg
        type: uni
        act: rcv
        width: 1
        inst_name: gpio
        index: -1
      }
      {
        name: racl_error
        desc: RACL error log information of this module.
        struct: racl_error_log
        package: top_racl_pkg
        type: uni
        act: req
        width: 1
        inst_name: gpio
        index: -1
      }
      {
        name: tl
        struct: tl
        package: tlul_pkg
        type: req_rsp
        act: rsp
        width: 1
        inst_name: gpio
        default: ""
        end_idx: -1
        top_signame: gpio_tl
        index: -1
      }
      {
        name: ram_cfg_sys2spi
        struct: ram_2p_cfg
        package: prim_ram_2p_pkg
        type: uni
        act: rcv
        width: 1
        inst_name: spi_device
        default: ""
        external: true
        top_signame: spi_device_ram_2p_cfg_sys2spi
        conn_type: false
        index: -1
      }
      {
        name: ram_cfg_rsp_sys2spi
        struct: ram_2p_cfg_rsp
        package: prim_ram_2p_pkg
        type: uni
        act: req
        width: 1
        inst_name: spi_device
        default: ""
        external: true
        top_signame: spi_device_ram_2p_cfg_rsp_sys2spi
        conn_type: false
        index: -1
      }
      {
        name: ram_cfg_spi2sys
        struct: ram_2p_cfg
        package: prim_ram_2p_pkg
        type: uni
        act: rcv
        width: 1
        inst_name: spi_device
        default: ""
        external: true
        top_signame: spi_device_ram_2p_cfg_spi2sys
        conn_type: false
        index: -1
      }
      {
        name: ram_cfg_rsp_spi2sys
        struct: ram_2p_cfg_rsp
        package: prim_ram_2p_pkg
        type: uni
        act: req
        width: 1
        inst_name: spi_device
        default: ""
        external: true
        top_signame: spi_device_ram_2p_cfg_rsp_spi2sys
        conn_type: false
        index: -1
      }
      {
        name: passthrough
        struct: passthrough
        package: spi_device_pkg
        type: req_rsp
        act: req
        width: 1
        inst_name: spi_device
        default: ""
        end_idx: -1
        top_signame: spi_device_passthrough
        index: -1
      }
      {
        name: mbist_en
        struct: logic
        type: uni
        act: rcv
        width: 1
        inst_name: spi_device
        index: -1
      }
      {
        name: sck_monitor
        struct: logic
        type: uni
        act: req
        width: 1
        inst_name: spi_device
        default: ""
        package: ""
        external: true
        top_signame: sck_monitor
        conn_type: false
        index: -1
      }
      {
        name: racl_policies
        desc:
          '''
          Incoming RACL policy vector from a racl_ctrl instance.
          The policy selection vector (parameter) selects the policy for each register.
          '''
        struct: racl_policy_vec
        package: top_racl_pkg
        type: uni
        act: rcv
        width: 1
        inst_name: spi_device
        index: -1
      }
      {
        name: racl_error
        desc: RACL error log information of this module.
        struct: racl_error_log
        package: top_racl_pkg
        type: uni
        act: req
        width: 1
        inst_name: spi_device
        index: -1
      }
      {
        name: tl
        struct: tl
        package: tlul_pkg
        type: req_rsp
        act: rsp
        width: 1
        inst_name: spi_device
        default: ""
        end_idx: -1
        top_signame: spi_device_tl
        index: -1
      }
      {
        name: ram_cfg
        struct: ram_1p_cfg
        package: prim_ram_1p_pkg
        type: uni
        act: rcv
        width: 1
        inst_name: i2c0
        default: ""
        external: true
        top_signame: i2c_ram_1p_cfg
        conn_type: false
        index: -1
      }
      {
        name: ram_cfg_rsp
        struct: ram_1p_cfg_rsp
        package: prim_ram_1p_pkg
        type: uni
        act: req
        width: 1
        inst_name: i2c0
        default: ""
        external: true
        top_signame: i2c_ram_1p_cfg_rsp
        conn_type: false
        index: -1
      }
      {
        name: lsio_trigger
        desc:
          '''
          Self-clearing status trigger for the DMA.
          Set when RX TX FIFO is past their configured watermark matching watermark interrupt behaviour.
          '''
        struct: logic
        type: uni
        act: req
        width: 1
        inst_name: i2c0
        default: ""
        package: ""
        end_idx: -1
        top_type: broadcast
        top_signame: i2c0_lsio_trigger
        index: -1
      }
      {
        name: racl_policies
        desc:
          '''
          Incoming RACL policy vector from a racl_ctrl instance.
          The policy selection vector (parameter) selects the policy for each register.
          '''
        struct: racl_policy_vec
        package: top_racl_pkg
        type: uni
        act: rcv
        width: 1
        inst_name: i2c0
        index: -1
      }
      {
        name: racl_error
        desc: RACL error log information of this module.
        struct: racl_error_log
        package: top_racl_pkg
        type: uni
        act: req
        width: 1
        inst_name: i2c0
        index: -1
      }
      {
        name: tl
        struct: tl
        package: tlul_pkg
        type: req_rsp
        act: rsp
        width: 1
        inst_name: i2c0
        default: ""
        end_idx: -1
        top_signame: i2c0_tl
        index: -1
      }
      {
        name: racl_policies
        desc:
          '''
          Incoming RACL policy vector from a racl_ctrl instance.
          The policy selection vector (parameter) selects the policy for each register.
          '''
        struct: racl_policy_vec
        package: top_racl_pkg
        type: uni
        act: rcv
        width: 1
        inst_name: rv_timer
        index: -1
      }
      {
        name: racl_error
        desc: RACL error log information of this module.
        struct: racl_error_log
        package: top_racl_pkg
        type: uni
        act: req
        width: 1
        inst_name: rv_timer
        index: -1
      }
      {
        name: tl
        struct: tl
        package: tlul_pkg
        type: req_rsp
        act: rsp
        width: 1
        inst_name: rv_timer
        default: ""
        end_idx: -1
        top_signame: rv_timer_tl
        index: -1
      }
      {
        name: edn
        desc: Entropy request to the entropy distribution network for LFSR reseeding and ephemeral key derivation.
        struct: edn
        package: edn_pkg
        type: req_rsp
        act: req
        width: 1
        inst_name: otp_ctrl
        default: ""
        top_signame: edn0_edn
        index: 1
      }
      {
        name: pwr_otp
        desc: Initialization request/acknowledge from/to power manager.
        struct: pwr_otp
        package: pwrmgr_pkg
        type: req_rsp
        act: rsp
        width: 1
        default: "'0"
        inst_name: otp_ctrl
        top_signame: pwrmgr_aon_pwr_otp
        index: -1
      }
      {
        name: lc_otp_program
        desc: Life cycle state transition interface.
        struct: lc_otp_program
        package: otp_ctrl_pkg
        type: req_rsp
        act: rsp
        width: 1
        default: "'0"
        inst_name: otp_ctrl
        top_signame: lc_ctrl_lc_otp_program
        index: -1
      }
      {
        name: otp_lc_data
        desc:
          '''
          Life cycle state output holding the current life cycle state,
          the value of the transition counter and the tokens needed for life cycle transitions.
          '''
        struct: otp_lc_data
        package: otp_ctrl_pkg
        type: uni
        act: req
        width: 1
        default: "'0"
        inst_name: otp_ctrl
        end_idx: -1
        top_type: broadcast
        top_signame: otp_ctrl_otp_lc_data
        index: -1
      }
      {
        name: lc_escalate_en
        desc:
          '''
          Life cycle escalation enable coming from life cycle controller.
          This signal moves all FSMs within OTP into the error state.
          '''
        struct: lc_tx
        package: lc_ctrl_pkg
        type: uni
        act: rcv
        width: 1
        default: lc_ctrl_pkg::Off
        inst_name: otp_ctrl
        top_signame: lc_ctrl_lc_escalate_en
        index: -1
      }
      {
        name: lc_creator_seed_sw_rw_en
        desc:
          '''
          Provision enable qualifier coming from life cycle controller.
          This signal enables SW read / write access to the RMA_TOKEN and CREATOR_ROOT_KEY_SHARE0 and CREATOR_ROOT_KEY_SHARE1.
          '''
        struct: lc_tx
        package: lc_ctrl_pkg
        type: uni
        act: rcv
        width: 1
        default: lc_ctrl_pkg::Off
        inst_name: otp_ctrl
        top_signame: lc_ctrl_lc_creator_seed_sw_rw_en
        index: -1
      }
      {
        name: lc_owner_seed_sw_rw_en
        desc:
          '''
          Provision enable qualifier coming from life cycle controller.
          This signal enables SW read / write access to the OWNER_SEED.
          '''
        struct: lc_tx
        package: lc_ctrl_pkg
        type: uni
        act: rcv
        width: 1
        default: lc_ctrl_pkg::Off
        inst_name: otp_ctrl
        top_signame: lc_ctrl_lc_owner_seed_sw_rw_en
        index: -1
      }
      {
        name: lc_seed_hw_rd_en
        desc:
          '''
          Seed read enable coming from life cycle controller.
          This signal enables HW read access to the CREATOR_ROOT_KEY_SHARE0 and CREATOR_ROOT_KEY_SHARE1.
          '''
        struct: lc_tx
        package: lc_ctrl_pkg
        type: uni
        act: rcv
        width: 1
        default: lc_ctrl_pkg::Off
        inst_name: otp_ctrl
        top_signame: lc_ctrl_lc_seed_hw_rd_en
        index: -1
      }
      {
        name: lc_check_byp_en
        desc:
          '''
          Life cycle partition check bypass signal.
          This signal causes the life cycle partition to bypass consistency checks during life cycle state transitions in order to prevent spurious consistency check failures.
          '''
        struct: lc_tx
        package: lc_ctrl_pkg
        type: uni
        act: rcv
        width: 1
        default: lc_ctrl_pkg::Off
        inst_name: otp_ctrl
        top_signame: lc_ctrl_lc_check_byp_en
        index: -1
      }
      {
        name: otp_keymgr_key
        desc: Key output to the key manager holding CREATOR_ROOT_KEY_SHARE0 and CREATOR_ROOT_KEY_SHARE1.
        struct: otp_keymgr_key
        package: otp_ctrl_pkg
        type: uni
        act: req
        width: 1
        default: "'0"
        inst_name: otp_ctrl
        end_idx: -1
        top_type: broadcast
        top_signame: otp_ctrl_otp_keymgr_key
        index: -1
      }
      {
        name: sram_otp_key
        desc: Array with key derivation interfaces for SRAM scrambling devices.
        struct: sram_otp_key
        package: otp_ctrl_pkg
        type: req_rsp
        act: rsp
        width: 4
        default: "'0"
        inst_name: otp_ctrl
        end_idx: -1
        top_type: one-to-N
        top_signame: otp_ctrl_sram_otp_key
        index: -1
      }
      {
        name: otbn_otp_key
        desc: Key derivation interface for OTBN scrambling devices.
        struct: otbn_otp_key
        package: otp_ctrl_pkg
        type: req_rsp
        act: rsp
        width: 1
        default: "'0"
        inst_name: otp_ctrl
        end_idx: -1
        top_signame: otp_ctrl_otbn_otp_key
        index: -1
      }
      {
        name: otp_broadcast
        desc: Output of the HW partitions with breakout data types.
        struct: otp_broadcast
        package: otp_ctrl_part_pkg
        type: uni
        act: req
        width: 1
        default: "'0"
        inst_name: otp_ctrl
        top_signame: otp_ctrl_otp_broadcast
        index: -1
      }
      {
        name: otp_macro
        desc: Data interface for the OTP macro.
        struct: otp_ctrl_macro
        package: otp_ctrl_macro_pkg
        type: req_rsp
        act: req
        width: 1
        default: "'0"
        inst_name: otp_ctrl
        end_idx: -1
        top_signame: otp_ctrl_otp_macro
        index: -1
      }
      {
        name: core_tl
        struct: tl
        package: tlul_pkg
        type: req_rsp
        act: rsp
        width: 1
        inst_name: otp_ctrl
        default: ""
        end_idx: -1
        top_signame: otp_ctrl_core_tl
        index: -1
      }
      {
        name: obs_ctrl
        desc: AST observability control signals.
        struct: ast_obs_ctrl
        package: ast_pkg
        type: uni
        act: rcv
        width: 1
        inst_name: otp_macro
        default: ""
        top_signame: ast_obs_ctrl
        index: -1
      }
      {
        name: otp_obs
        desc: AST observability bus.
        struct: logic
        type: uni
        act: req
        width: 8
        inst_name: otp_macro
        default: ""
        package: ""
        external: true
        top_signame: otp_obs
        conn_type: false
        index: -1
      }
      {
        name: pwr_seq
        desc: Power sequencing signals to AST (VDD domain).
        struct: pwr_seq
        package: otp_macro_pkg
        type: uni
        act: req
        width: 1
        default: "'0"
        inst_name: otp_macro
        external: true
        top_signame: otp_macro_pwr_seq
        conn_type: false
        index: -1
      }
      {
        name: pwr_seq_h
        desc: Power sequencing signals coming from AST (VCC domain).
        struct: pwr_seq
        package: otp_macro_pkg
        type: uni
        act: rcv
        width: 1
        default: "'0"
        inst_name: otp_macro
        external: true
        top_signame: otp_macro_pwr_seq_h
        conn_type: false
        index: -1
      }
      {
        name: ext_voltage_h
        struct: ""
        type: io
        act: none
        width: 1
        default: "'0"
        inst_name: otp_macro
        package: ""
        external: true
        top_signame: otp_ext_voltage_h
        conn_type: false
        index: -1
      }
      {
        name: lc_dft_en
        desc:
          '''
          Test enable qualifier coming from life cycle controller.
          This signals enables the TL-UL access port.
          '''
        struct: lc_tx
        package: lc_ctrl_pkg
        type: uni
        act: rcv
        width: 1
        default: lc_ctrl_pkg::Off
        inst_name: otp_macro
        top_signame: lc_ctrl_lc_dft_en
        index: -1
      }
      {
        name: test
        desc: Vendor test control signals from/to the life cycle TAP.
        struct: otp_test
        package: otp_macro_pkg
        type: req_rsp
        act: rsp
        width: 1
        default: "'0"
        inst_name: otp_macro
        top_signame: lc_ctrl_lc_otp_vendor_test
        index: -1
      }
      {
        name: otp
        desc: Data interface for the OTP macro.
        struct: otp_ctrl_macro
        package: otp_ctrl_macro_pkg
        type: req_rsp
        act: rsp
        width: 1
        default: "'0"
        inst_name: otp_macro
        top_signame: otp_ctrl_otp_macro
        index: -1
      }
      {
        name: cfg
        struct: otp_cfg
        package: otp_macro_pkg
        type: uni
        act: rcv
        width: 1
        default: "'0"
        inst_name: otp_macro
        external: true
        top_signame: otp_cfg
        conn_type: false
        index: -1
      }
      {
        name: cfg_rsp
        struct: otp_cfg_rsp
        package: otp_macro_pkg
        type: uni
        act: req
        width: 1
        default: "'0"
        inst_name: otp_macro
        external: true
        top_signame: otp_cfg_rsp
        conn_type: false
        index: -1
      }
      {
        name: tl
        struct: tl
        package: tlul_pkg
        type: req_rsp
        act: rsp
        width: 1
        inst_name: otp_macro
        default: ""
        end_idx: -1
        top_signame: otp_macro_tl
        index: -1
      }
      {
        name: jtag
        struct: jtag
        package: jtag_pkg
        type: req_rsp
        act: rsp
        width: 1
        inst_name: lc_ctrl
        index: -1
      }
      {
        name: esc_scrap_state0_tx
        struct: esc_tx
        package: prim_esc_pkg
        type: uni
        act: rcv
        width: 1
        inst_name: lc_ctrl
        default: ""
        top_signame: alert_handler_esc_tx
        index: 1
      }
      {
        name: esc_scrap_state0_rx
        struct: esc_rx
        package: prim_esc_pkg
        type: uni
        act: req
        width: 1
        inst_name: lc_ctrl
        default: ""
        top_signame: alert_handler_esc_rx
        index: 1
      }
      {
        name: esc_scrap_state1_tx
        struct: esc_tx
        package: prim_esc_pkg
        type: uni
        act: rcv
        width: 1
        inst_name: lc_ctrl
        default: ""
        top_signame: alert_handler_esc_tx
        index: 2
      }
      {
        name: esc_scrap_state1_rx
        struct: esc_rx
        package: prim_esc_pkg
        type: uni
        act: req
        width: 1
        inst_name: lc_ctrl
        default: ""
        top_signame: alert_handler_esc_rx
        index: 2
      }
      {
        name: pwr_lc
        struct: pwr_lc
        package: lc_ctrl_pkg
        type: req_rsp
        act: rsp
        width: 1
        inst_name: lc_ctrl
        default: ""
        top_signame: pwrmgr_aon_pwr_lc
        index: -1
      }
      {
        name: lc_otp_vendor_test
        struct: otp_test
        package: otp_macro_pkg
        type: req_rsp
        act: req
        width: 1
        default: "'0"
        inst_name: lc_ctrl
        end_idx: -1
        top_signame: lc_ctrl_lc_otp_vendor_test
        index: -1
      }
      {
        name: otp_lc_data
        struct: otp_lc_data
        package: otp_ctrl_pkg
        type: uni
        act: rcv
        width: 1
        default: otp_ctrl_pkg::OTP_LC_DATA_DEFAULT
        inst_name: lc_ctrl
        top_signame: otp_ctrl_otp_lc_data
        index: -1
      }
      {
        name: lc_otp_program
        struct: lc_otp_program
        package: otp_ctrl_pkg
        type: req_rsp
        act: req
        width: 1
        default: "'0"
        inst_name: lc_ctrl
        end_idx: -1
        top_signame: lc_ctrl_lc_otp_program
        index: -1
      }
      {
        name: kmac_data
        struct: app
        package: kmac_pkg
        type: req_rsp
        act: req
        width: 1
        default: "'0"
        inst_name: lc_ctrl
        top_signame: kmac_app
        index: 1
      }
      {
        name: lc_raw_test_rma
        struct: lc_tx
        package: lc_ctrl_pkg
        type: uni
        act: req
        width: 1
        default: lc_ctrl_pkg::Off
        inst_name: lc_ctrl
        end_idx: -1
        top_type: broadcast
        top_signame: lc_ctrl_lc_raw_test_rma
        index: -1
      }
      {
        name: lc_dft_en
        struct: lc_tx
        package: lc_ctrl_pkg
        type: uni
        act: req
        width: 1
        default: lc_ctrl_pkg::Off
        inst_name: lc_ctrl
        end_idx: -1
        top_type: broadcast
        top_signame: lc_ctrl_lc_dft_en
        index: -1
      }
      {
        name: lc_nvm_debug_en
        struct: lc_tx
        package: lc_ctrl_pkg
        type: uni
        act: req
        width: 1
        default: lc_ctrl_pkg::Off
        inst_name: lc_ctrl
        index: -1
      }
      {
        name: lc_hw_debug_en
        struct: lc_tx
        package: lc_ctrl_pkg
        type: uni
        act: req
        width: 1
        default: lc_ctrl_pkg::Off
        inst_name: lc_ctrl
        end_idx: -1
        top_type: broadcast
        top_signame: lc_ctrl_lc_hw_debug_en
        index: -1
      }
      {
        name: lc_cpu_en
        struct: lc_tx
        package: lc_ctrl_pkg
        type: uni
        act: req
        width: 1
        default: lc_ctrl_pkg::Off
        inst_name: lc_ctrl
        end_idx: -1
        top_type: broadcast
        top_signame: lc_ctrl_lc_cpu_en
        index: -1
      }
      {
        name: lc_keymgr_en
        struct: lc_tx
        package: lc_ctrl_pkg
        type: uni
        act: req
        width: 1
        default: lc_ctrl_pkg::Off
        inst_name: lc_ctrl
        end_idx: -1
        top_type: broadcast
        top_signame: lc_ctrl_lc_keymgr_en
        index: -1
      }
      {
        name: lc_escalate_en
        struct: lc_tx
        package: lc_ctrl_pkg
        type: uni
        act: req
        width: 1
        default: lc_ctrl_pkg::Off
        inst_name: lc_ctrl
        end_idx: -1
        top_type: broadcast
        top_signame: lc_ctrl_lc_escalate_en
        index: -1
      }
      {
        name: lc_clk_byp_req
        struct: lc_tx
        package: lc_ctrl_pkg
        type: uni
        act: req
        width: 1
        default: lc_ctrl_pkg::Off
        inst_name: lc_ctrl
        end_idx: -1
        top_type: broadcast
        top_signame: lc_ctrl_lc_clk_byp_req
        index: -1
      }
      {
        name: lc_clk_byp_ack
        struct: lc_tx
        package: lc_ctrl_pkg
        type: uni
        act: rcv
        width: 1
        default: lc_ctrl_pkg::Off
        inst_name: lc_ctrl
        end_idx: -1
        top_type: broadcast
        top_signame: lc_ctrl_lc_clk_byp_ack
        index: -1
      }
      {
        name: lc_flash_rma_req
        struct: lc_tx
        package: lc_ctrl_pkg
        type: uni
        act: req
        width: 1
        default: lc_ctrl_pkg::Off
        inst_name: lc_ctrl
        end_idx: -1
        top_type: broadcast
        top_signame: lc_ctrl_lc_flash_rma_req
        index: -1
      }
      {
        name: lc_flash_rma_ack
        struct: lc_tx
        package: lc_ctrl_pkg
        type: uni
        act: rcv
        width: 2
        default: lc_ctrl_pkg::On
        inst_name: lc_ctrl
        top_signame: otbn_lc_rma_ack
        index: -1
      }
      {
        name: lc_flash_rma_seed
        struct: lc_flash_rma_seed
        package: lc_ctrl_pkg
        type: uni
        act: req
        width: 1
        default: "'0"
        inst_name: lc_ctrl
        index: -1
      }
      {
        name: lc_check_byp_en
        struct: lc_tx
        package: lc_ctrl_pkg
        type: uni
        act: req
        width: 1
        default: lc_ctrl_pkg::Off
        inst_name: lc_ctrl
        end_idx: -1
        top_type: broadcast
        top_signame: lc_ctrl_lc_check_byp_en
        index: -1
      }
      {
        name: lc_creator_seed_sw_rw_en
        struct: lc_tx
        package: lc_ctrl_pkg
        type: uni
        act: req
        width: 1
        default: lc_ctrl_pkg::Off
        inst_name: lc_ctrl
        end_idx: -1
        top_type: broadcast
        top_signame: lc_ctrl_lc_creator_seed_sw_rw_en
        index: -1
      }
      {
        name: lc_owner_seed_sw_rw_en
        struct: lc_tx
        package: lc_ctrl_pkg
        type: uni
        act: req
        width: 1
        default: lc_ctrl_pkg::Off
        inst_name: lc_ctrl
        end_idx: -1
        top_type: broadcast
        top_signame: lc_ctrl_lc_owner_seed_sw_rw_en
        index: -1
      }
      {
        name: lc_iso_part_sw_rd_en
        struct: lc_tx
        package: lc_ctrl_pkg
        type: uni
        act: req
        width: 1
        default: lc_ctrl_pkg::Off
        inst_name: lc_ctrl
        index: -1
      }
      {
        name: lc_iso_part_sw_wr_en
        struct: lc_tx
        package: lc_ctrl_pkg
        type: uni
        act: req
        width: 1
        default: lc_ctrl_pkg::Off
        inst_name: lc_ctrl
        index: -1
      }
      {
        name: lc_seed_hw_rd_en
        struct: lc_tx
        package: lc_ctrl_pkg
        type: uni
        act: req
        width: 1
        default: lc_ctrl_pkg::Off
        inst_name: lc_ctrl
        end_idx: -1
        top_type: broadcast
        top_signame: lc_ctrl_lc_seed_hw_rd_en
        index: -1
      }
      {
        name: lc_keymgr_div
        struct: lc_keymgr_div
        package: lc_ctrl_pkg
        type: uni
        act: req
        width: 1
        default: "'0"
        inst_name: lc_ctrl
        end_idx: -1
        top_type: broadcast
        top_signame: lc_ctrl_lc_keymgr_div
        index: -1
      }
      {
        name: otp_device_id
        struct: otp_device_id
        package: otp_ctrl_pkg
        type: uni
        act: rcv
        width: 1
        default: "'0"
        inst_name: lc_ctrl
        top_signame: lc_ctrl_otp_device_id
        index: -1
      }
      {
        name: otp_manuf_state
        struct: otp_manuf_state
        package: otp_ctrl_pkg
        type: uni
        act: rcv
        width: 1
        default: "'0"
        inst_name: lc_ctrl
        top_signame: lc_ctrl_otp_manuf_state
        index: -1
      }
      {
        name: hw_rev
        struct: lc_hw_rev
        package: lc_ctrl_pkg
        type: uni
        act: req
        width: 1
        default: "'0"
        inst_name: lc_ctrl
        index: -1
      }
      {
        name: strap_en_override
        desc:
          '''
          This signal transitions from 0 -> 1 by the lc_ctrl manager after volatile RAW_UNLOCK in order to re-sample the HW straps.
          The signal stays at 1 until reset.
          Note that this is only used in test chips when SecVolatileRawUnlockEn = 1.
          Otherwise this signal is tied off to 0.
          '''
        struct: logic
        type: uni
        act: req
        width: 1
        default: 1'b0
        inst_name: lc_ctrl
        package: ""
        end_idx: -1
        top_type: broadcast
        top_signame: lc_ctrl_strap_en_override
        index: -1
      }
      {
        name: regs_tl
        struct: tl
        package: tlul_pkg
        type: req_rsp
        act: rsp
        width: 1
        inst_name: lc_ctrl
        default: ""
        end_idx: -1
        top_signame: lc_ctrl_regs_tl
        index: -1
      }
      {
        name: dmi_tl
        struct: tl
        package: tlul_pkg
        type: req_rsp
        act: rsp
        width: 1
        inst_name: lc_ctrl
        default: ""
        end_idx: -1
        top_signame: lc_ctrl_dmi_tl
        index: -1
      }
      {
        name: crashdump
        struct: alert_crashdump
        package: alert_handler_pkg
        type: uni
        act: req
        width: 1
        inst_name: alert_handler
        default: ""
        end_idx: -1
        top_type: broadcast
        top_signame: alert_handler_crashdump
        index: -1
      }
      {
        name: edn
        struct: edn
        package: edn_pkg
        type: req_rsp
        act: req
        width: 1
        inst_name: alert_handler
        default: ""
        top_signame: edn0_edn
        index: 4
      }
      {
        name: esc_rx
        struct: esc_rx
        package: prim_esc_pkg
        type: uni
        act: rcv
        width: 4
        inst_name: alert_handler
        default: ""
        end_idx: -1
        top_type: one-to-N
        top_signame: alert_handler_esc_rx
        index: -1
      }
      {
        name: esc_tx
        struct: esc_tx
        package: prim_esc_pkg
        type: uni
        act: req
        width: 4
        inst_name: alert_handler
        default: ""
        end_idx: -1
        top_type: one-to-N
        top_signame: alert_handler_esc_tx
        index: -1
      }
      {
        name: tl
        struct: tl
        package: tlul_pkg
        type: req_rsp
        act: rsp
        width: 1
        inst_name: alert_handler
        default: ""
        end_idx: -1
        top_signame: alert_handler_tl
        index: -1
      }
      {
        name: passthrough
        struct: passthrough
        package: spi_device_pkg
        type: req_rsp
        act: rsp
        width: 1
        inst_name: spi_host0
        default: ""
        top_signame: spi_device_passthrough
        index: -1
      }
      {
        name: lsio_trigger
        desc:
          '''
          Self-clearing status trigger for the DMA.
          Set when RX or TX FIFOs are past their configured watermarks matching watermark interrupt behaviour.
          '''
        struct: logic
        type: uni
        act: req
        width: 1
        inst_name: spi_host0
        default: ""
        package: ""
        end_idx: -1
        top_type: broadcast
        top_signame: spi_host0_lsio_trigger
        index: -1
      }
      {
        name: racl_policies
        desc:
          '''
          Incoming RACL policy vector from a racl_ctrl instance.
          The policy selection vector (parameter) selects the policy for each register.
          '''
        struct: racl_policy_vec
        package: top_racl_pkg
        type: uni
        act: rcv
        width: 1
        inst_name: spi_host0
        index: -1
      }
      {
        name: racl_error
        desc: RACL error log information of this module.
        struct: racl_error_log
        package: top_racl_pkg
        type: uni
        act: req
        width: 1
        inst_name: spi_host0
        index: -1
      }
      {
        name: tl
        struct: tl
        package: tlul_pkg
        type: req_rsp
        act: rsp
        width: 1
        inst_name: spi_host0
        default: ""
        end_idx: -1
        top_signame: spi_host0_tl
        index: -1
      }
      {
        name: boot_status
        struct: pwr_boot_status
        package: pwrmgr_pkg
        type: uni
        act: req
        width: 1
        inst_name: pwrmgr_aon
        default: ""
        end_idx: -1
        top_type: broadcast
        top_signame: pwrmgr_aon_boot_status
        index: -1
        external: true
        conn_type: true
      }
      {
        name: pwr_ast
        struct: pwr_ast
        package: pwrmgr_pkg
        type: req_rsp
        act: req
        width: 1
        inst_name: pwrmgr_aon
        default: ""
        external: true
        top_signame: pwrmgr_ast
        conn_type: false
        index: -1
      }
      {
        name: pwr_rst
        struct: pwr_rst
        package: pwrmgr_pkg
        type: req_rsp
        act: req
        width: 1
        inst_name: pwrmgr_aon
        default: ""
        end_idx: -1
        top_signame: pwrmgr_aon_pwr_rst
        index: -1
      }
      {
        name: pwr_clk
        struct: pwr_clk
        package: pwrmgr_pkg
        type: req_rsp
        act: req
        width: 1
        inst_name: pwrmgr_aon
        default: ""
        end_idx: -1
        top_signame: pwrmgr_aon_pwr_clk
        index: -1
      }
      {
        name: pwr_otp
        struct: pwr_otp
        package: pwrmgr_pkg
        type: req_rsp
        act: req
        width: 1
        inst_name: pwrmgr_aon
        default: ""
        end_idx: -1
        top_signame: pwrmgr_aon_pwr_otp
        index: -1
      }
      {
        name: pwr_lc
        struct: pwr_lc
        package: lc_ctrl_pkg
        type: req_rsp
        act: req
        width: 1
        inst_name: pwrmgr_aon
        default: ""
        end_idx: -1
        top_signame: pwrmgr_aon_pwr_lc
        index: -1
      }
      {
        name: pwr_flash
        struct: pwr_flash
        package: pwrmgr_pkg
        type: uni
        act: rcv
        width: 1
        inst_name: pwrmgr_aon
        index: -1
      }
      {
        name: esc_rst_tx
        struct: esc_tx
        package: prim_esc_pkg
        type: uni
        act: rcv
        width: 1
        inst_name: pwrmgr_aon
        default: ""
        top_signame: alert_handler_esc_tx
        index: 3
      }
      {
        name: esc_rst_rx
        struct: esc_rx
        package: prim_esc_pkg
        type: uni
        act: req
        width: 1
        inst_name: pwrmgr_aon
        default: ""
        top_signame: alert_handler_esc_rx
        index: 3
      }
      {
        name: pwr_cpu
        struct: cpu_pwrmgr
        package: rv_core_ibex_pkg
        type: uni
        act: rcv
        width: 1
        inst_name: pwrmgr_aon
        default: ""
        top_signame: rv_core_ibex_pwrmgr
        index: -1
      }
      {
        name: wakeups
        struct: logic
        type: uni
        act: rcv
        width: 4
        inst_name: pwrmgr_aon
        default: ""
        package: ""
        end_idx: -1
        top_type: one-to-N
        top_signame: pwrmgr_aon_wakeups
        index: -1
      }
      {
        name: rstreqs
        struct: logic
        type: uni
        act: rcv
        width: 2
        inst_name: pwrmgr_aon
        default: ""
        package: ""
        end_idx: -1
        top_type: one-to-N
        top_signame: pwrmgr_aon_rstreqs
        index: -1
      }
      {
        name: ndmreset_req
        struct: logic
        type: uni
        act: rcv
        width: 1
        inst_name: pwrmgr_aon
        default: ""
        package: ""
        top_signame: rv_dm_ndmreset_req
        index: -1
      }
      {
        name: strap
        struct: logic
        type: uni
        act: req
        width: 1
        inst_name: pwrmgr_aon
        default: ""
        package: ""
        end_idx: -1
        top_type: broadcast
        top_signame: pwrmgr_aon_strap
        index: -1
      }
      {
        name: low_power
        struct: logic
        type: uni
        act: req
        width: 1
        inst_name: pwrmgr_aon
        default: ""
        package: ""
        end_idx: -1
        top_type: broadcast
        top_signame: pwrmgr_aon_low_power
        index: -1
      }
      {
        name: rom_ctrl
        struct: pwrmgr_data
        package: rom_ctrl_pkg
        type: uni
        act: rcv
        width: 3
        default: rom_ctrl_pkg::PWRMGR_DATA_DEFAULT
        inst_name: pwrmgr_aon
        end_idx: -1
        top_type: one-to-N
        top_signame: pwrmgr_aon_rom_ctrl
        index: -1
      }
      {
        name: fetch_en
        struct: lc_tx
        package: lc_ctrl_pkg
        type: uni
        act: req
        width: 1
        inst_name: pwrmgr_aon
        default: ""
        end_idx: -1
        top_type: broadcast
        top_signame: pwrmgr_aon_fetch_en
        index: -1
      }
      {
        name: lc_dft_en
        struct: lc_tx
        package: lc_ctrl_pkg
        type: uni
        act: rcv
        width: 1
        inst_name: pwrmgr_aon
        default: ""
        top_signame: lc_ctrl_lc_dft_en
        index: -1
      }
      {
        name: lc_hw_debug_en
        struct: lc_tx
        package: lc_ctrl_pkg
        type: uni
        act: rcv
        width: 1
        inst_name: pwrmgr_aon
        default: ""
        top_signame: lc_ctrl_lc_hw_debug_en
        index: -1
      }
      {
        name: sw_rst_req
        struct: mubi4
        package: prim_mubi_pkg
        type: uni
        act: rcv
        width: 1
        inst_name: pwrmgr_aon
        default: ""
        top_signame: rstmgr_aon_sw_rst_req
        index: -1
      }
      {
        name: tl
        struct: tl
        package: tlul_pkg
        type: req_rsp
        act: rsp
        width: 1
        inst_name: pwrmgr_aon
        default: ""
        end_idx: -1
        top_signame: pwrmgr_aon_tl
        index: -1
      }
      {
        name: por_n
        desc:
          '''
          Root power on reset signals from ast.
          There is one root reset signal for each core power domain.
          '''
        struct: logic
        type: uni
        act: rcv
        width: 2
        inst_name: rstmgr_aon
        default: ""
        package: ""
        external: true
        top_signame: por_n
        conn_type: false
        index: -1
      }
      {
        name: pwr
        desc:
          '''
          Reset request signals from power manager.
          Power manager can request for specific domains of the lc/sys reset tree to assert.
          '''
        struct: pwr_rst
        type: req_rsp
        act: rsp
        width: 1
        inst_name: rstmgr_aon
        default: ""
        package: pwrmgr_pkg
        top_signame: pwrmgr_aon_pwr_rst
        index: -1
      }
      {
        name: resets
        desc: Leaf resets fed to the system.
        struct: rstmgr_out
        package: rstmgr_pkg
        type: uni
        act: req
        width: 1
        inst_name: rstmgr_aon
        default: ""
        top_signame: rstmgr_aon_resets
        index: -1
      }
      {
        name: rst_en
        desc: Low-power-group outputs used by alert handler.
        struct: rstmgr_rst_en
        package: rstmgr_pkg
        type: uni
        act: req
        width: 1
        inst_name: rstmgr_aon
        default: ""
        top_signame: rstmgr_aon_rst_en
        index: -1
      }
      {
        name: alert_dump
        desc: Alert handler crash dump information.
        struct: alert_crashdump
        package: alert_handler_pkg
        type: uni
        act: rcv
        width: 1
        inst_name: rstmgr_aon
        default: ""
        top_signame: alert_handler_crashdump
        index: -1
      }
      {
        name: cpu_dump
        desc: Main processing element crash dump information.
        struct: cpu_crash_dump
        package: rv_core_ibex_pkg
        type: uni
        act: rcv
        width: 1
        inst_name: rstmgr_aon
        default: ""
        top_signame: rv_core_ibex_crash_dump
        index: -1
      }
      {
        name: sw_rst_req
        desc: Software requested system reset to pwrmgr.
        struct: mubi4
        package: prim_mubi_pkg
        type: uni
        act: req
        width: 1
        inst_name: rstmgr_aon
        default: ""
        end_idx: -1
        top_type: broadcast
        top_signame: rstmgr_aon_sw_rst_req
        index: -1
      }
      {
        name: tl
        struct: tl
        package: tlul_pkg
        type: req_rsp
        act: rsp
        width: 1
        inst_name: rstmgr_aon
        default: ""
        end_idx: -1
        top_signame: rstmgr_aon_tl
        index: -1
      }
      {
        name: clocks
        struct: clkmgr_out
        package: clkmgr_pkg
        type: uni
        act: req
        width: 1
        inst_name: clkmgr_aon
        default: ""
        top_signame: clkmgr_aon_clocks
        index: -1
      }
      {
        name: cg_en
        struct: clkmgr_cg_en
        package: clkmgr_pkg
        type: uni
        act: req
        width: 1
        inst_name: clkmgr_aon
        default: ""
        top_signame: clkmgr_aon_cg_en
        index: -1
      }
      {
        name: lc_hw_debug_en
        struct: lc_tx
        package: lc_ctrl_pkg
        type: uni
        act: rcv
        width: 1
        inst_name: clkmgr_aon
        default: ""
        top_signame: lc_ctrl_lc_hw_debug_en
        index: -1
      }
      {
        name: io_clk_byp_req
        struct: mubi4
        package: prim_mubi_pkg
        type: uni
        act: req
        width: 1
        inst_name: clkmgr_aon
        default: ""
        external: true
        top_signame: io_clk_byp_req
        conn_type: false
        index: -1
      }
      {
        name: io_clk_byp_ack
        struct: mubi4
        package: prim_mubi_pkg
        type: uni
        act: rcv
        width: 1
        inst_name: clkmgr_aon
        default: ""
        external: true
        top_signame: io_clk_byp_ack
        conn_type: false
        index: -1
      }
      {
        name: all_clk_byp_req
        struct: mubi4
        package: prim_mubi_pkg
        type: uni
        act: req
        width: 1
        inst_name: clkmgr_aon
        default: ""
        external: true
        top_signame: all_clk_byp_req
        conn_type: false
        index: -1
      }
      {
        name: all_clk_byp_ack
        struct: mubi4
        package: prim_mubi_pkg
        type: uni
        act: rcv
        width: 1
        inst_name: clkmgr_aon
        default: ""
        external: true
        top_signame: all_clk_byp_ack
        conn_type: false
        index: -1
      }
      {
        name: hi_speed_sel
        struct: mubi4
        package: prim_mubi_pkg
        type: uni
        act: req
        width: 1
        inst_name: clkmgr_aon
        default: ""
        external: true
        top_signame: hi_speed_sel
        conn_type: false
        index: -1
      }
      {
        name: div_step_down_req
        struct: mubi4
        package: prim_mubi_pkg
        type: uni
        act: rcv
        width: 1
        inst_name: clkmgr_aon
        default: ""
        external: true
        top_signame: div_step_down_req
        conn_type: false
        index: -1
      }
      {
        name: lc_clk_byp_req
        struct: lc_tx
        package: lc_ctrl_pkg
        type: uni
        act: rcv
        width: 1
        inst_name: clkmgr_aon
        default: ""
        top_signame: lc_ctrl_lc_clk_byp_req
        index: -1
      }
      {
        name: lc_clk_byp_ack
        struct: lc_tx
        package: lc_ctrl_pkg
        type: uni
        act: req
        width: 1
        inst_name: clkmgr_aon
        default: ""
        top_signame: lc_ctrl_lc_clk_byp_ack
        index: -1
      }
      {
        name: jitter_en
        struct: mubi4
        package: prim_mubi_pkg
        type: uni
        act: req
        width: 1
        inst_name: clkmgr_aon
        default: ""
        external: true
        top_signame: clk_main_jitter_en
        conn_type: false
        index: -1
      }
      {
        name: pwr
        struct: pwr_clk
        type: req_rsp
        act: rsp
        width: 1
        inst_name: clkmgr_aon
        default: ""
        package: pwrmgr_pkg
        top_signame: pwrmgr_aon_pwr_clk
        index: -1
      }
      {
        name: idle
        struct: mubi4
        package: prim_mubi_pkg
        type: uni
        act: rcv
        width: 4
        inst_name: clkmgr_aon
        default: ""
        end_idx: -1
        top_type: one-to-N
        top_signame: clkmgr_aon_idle
        index: -1
      }
      {
        name: calib_rdy
        desc: Indicates clocks are calibrated and frequencies accurate
        struct: mubi4
        package: prim_mubi_pkg
        type: uni
        act: rcv
        width: 1
        default: prim_mubi_pkg::MuBi4True
        inst_name: clkmgr_aon
        external: true
        top_signame: calib_rdy
        conn_type: false
        index: -1
      }
      {
        name: tl
        struct: tl
        package: tlul_pkg
        type: req_rsp
        act: rsp
        width: 1
        inst_name: clkmgr_aon
        default: ""
        end_idx: -1
        top_signame: clkmgr_aon_tl
        index: -1
      }
      {
        name: sleep_en
        desc: Level signal that is asserted when the power manager enters sleep.
        struct: logic
        type: uni
        act: rcv
        width: 1
        default: 1'b0
        inst_name: pinmux_aon
        package: ""
        top_signame: pwrmgr_aon_low_power
        index: -1
      }
      {
        name: pin_wkup_req
        desc: Wakeup request from wakeup detectors, to the power manager, running on the AON clock.
        struct: logic
        type: uni
        act: req
        width: 1
        default: 1'b0
        inst_name: pinmux_aon
        package: ""
        top_signame: pwrmgr_aon_wakeups
        index: 0
      }
      {
        name: tl
        struct: tl
        package: tlul_pkg
        type: req_rsp
        act: rsp
        width: 1
        inst_name: pinmux_aon
        default: ""
        end_idx: -1
        top_signame: pinmux_aon_tl
        index: -1
      }
      {
        name: nmi_wdog_timer_bark
        struct: logic
        type: uni
        act: req
        width: 1
        default: 1'b0
        inst_name: aon_timer_aon
        package: ""
        end_idx: -1
        top_type: broadcast
        top_signame: aon_timer_aon_nmi_wdog_timer_bark
        index: -1
      }
      {
        name: wkup_req
        struct: logic
        type: uni
        act: req
        width: 1
        default: 1'b0
        inst_name: aon_timer_aon
        package: ""
        top_signame: pwrmgr_aon_wakeups
        index: 1
      }
      {
        name: aon_timer_rst_req
        struct: logic
        type: uni
        act: req
        width: 1
        default: 1'b0
        inst_name: aon_timer_aon
        package: ""
        top_signame: pwrmgr_aon_rstreqs
        index: 0
      }
      {
        name: lc_escalate_en
        struct: lc_tx
        package: lc_ctrl_pkg
        type: uni
        act: rcv
        width: 1
        default: lc_ctrl_pkg::Off
        inst_name: aon_timer_aon
        top_signame: lc_ctrl_lc_escalate_en
        index: -1
      }
      {
        name: sleep_mode
        struct: logic
        type: uni
        act: rcv
        width: 1
        inst_name: aon_timer_aon
        default: ""
        package: ""
        top_signame: pwrmgr_aon_low_power
        index: -1
      }
      {
        name: racl_policies
        desc:
          '''
          Incoming RACL policy vector from a racl_ctrl instance.
          The policy selection vector (parameter) selects the policy for each register.
          '''
        struct: racl_policy_vec
        package: top_racl_pkg
        type: uni
        act: rcv
        width: 1
        inst_name: aon_timer_aon
        index: -1
      }
      {
        name: racl_error
        desc: RACL error log information of this module.
        struct: racl_error_log
        package: top_racl_pkg
        type: uni
        act: req
        width: 1
        inst_name: aon_timer_aon
        index: -1
      }
      {
        name: tl
        struct: tl
        package: tlul_pkg
        type: req_rsp
        act: rsp
        width: 1
        inst_name: aon_timer_aon
        default: ""
        end_idx: -1
        top_signame: aon_timer_aon_tl
        index: -1
      }
      {
        name: tl
        struct: tl
        package: tlul_pkg
        type: req_rsp
        act: rsp
        width: 1
        inst_name: ast
        index: -1
      }
      {
        name: dma_tl_h2d
        desc: TL-UL host port for the DMA to egress into CTN (request part), synchronous
        struct: tl_h2d
        package: tlul_pkg
        type: uni
        act: rcv
        width: 1
        inst_name: soc_proxy
        default: ""
        end_idx: -1
        top_type: broadcast
        top_signame: soc_proxy_dma_tl_h2d
        index: -1
      }
      {
        name: dma_tl_d2h
        desc: TL-UL host port for the DMA to egress into CTN (response part), synchronous
        struct: tl_d2h
        package: tlul_pkg
        type: uni
        act: req
        width: 1
        inst_name: soc_proxy
        default: ""
        end_idx: -1
        top_type: broadcast
        top_signame: soc_proxy_dma_tl_d2h
        index: -1
      }
      {
        name: misc_tl_h2d
        desc: TL-UL host port for the MISC to egress into CTN (request part), synchronous
        struct: tl_h2d
        package: tlul_pkg
        type: uni
        act: rcv
        width: 1
        inst_name: soc_proxy
        default: ""
        external: true
        top_signame: ctn_misc_tl_h2d
        conn_type: false
        index: -1
      }
      {
        name: misc_tl_d2h
        desc: TL-UL host port for the MISC to egress into CTN (response part), synchronous
        struct: tl_d2h
        package: tlul_pkg
        type: uni
        act: req
        width: 1
        inst_name: soc_proxy
        default: ""
        external: true
        top_signame: ctn_misc_tl_d2h
        conn_type: false
        index: -1
      }
      {
        name: wkup_internal_req
        struct: logic
        type: uni
        act: req
        width: 1
        inst_name: soc_proxy
        default: ""
        package: ""
        top_signame: pwrmgr_aon_wakeups
        index: 2
      }
      {
        name: wkup_external_req
        struct: logic
        type: uni
        act: req
        width: 1
        inst_name: soc_proxy
        default: ""
        package: ""
        top_signame: pwrmgr_aon_wakeups
        index: 3
      }
      {
        name: rst_req_external
        struct: logic
        type: uni
        act: req
        width: 1
        inst_name: soc_proxy
        default: ""
        package: ""
        top_signame: pwrmgr_aon_rstreqs
        index: 1
      }
      {
        name: ctn_tl_h2d
        desc: TL-UL host port for egress into CTN (request part), synchronous
        struct: tl_h2d
        package: tlul_pkg
        type: uni
        act: req
        width: 1
        inst_name: soc_proxy
        default: ""
        end_idx: -1
        top_type: broadcast
        top_signame: soc_proxy_ctn_tl_h2d
        index: -1
      }
      {
        name: ctn_tl_d2h
        desc: TL-UL host port for egress into CTN (response part), synchronous
        struct: tl_d2h
        package: tlul_pkg
        type: uni
        act: rcv
        width: 1
        inst_name: soc_proxy
        default: ""
        end_idx: -1
        top_type: broadcast
        top_signame: soc_proxy_ctn_tl_d2h
        index: -1
      }
      {
        name: i2c_lsio_trigger
        desc: LSIO trigger signal from I2C
        struct: logic
        type: uni
        act: rcv
        width: 1
        inst_name: soc_proxy
        default: ""
        package: ""
        top_signame: i2c0_lsio_trigger
        index: -1
      }
      {
        name: spi_host_lsio_trigger
        desc: LSIO trigger signal from SPI Host
        struct: logic
        type: uni
        act: rcv
        width: 1
        inst_name: soc_proxy
        default: ""
        package: ""
        top_signame: spi_host0_lsio_trigger
        index: -1
      }
      {
        name: uart_lsio_trigger
        desc: LSIO trigger signal from UART
        struct: logic
        type: uni
        act: rcv
        width: 1
        inst_name: soc_proxy
        default: ""
        package: ""
        top_signame: uart0_lsio_trigger
        index: -1
      }
      {
        name: soc_lsio_trigger
        desc: LSIO trigger signal from SoC, synchronous
        struct: logic
        type: uni
        act: rcv
        width: 8
        inst_name: soc_proxy
        default: ""
        package: ""
        external: true
        top_signame: soc_lsio_trigger
        conn_type: false
        index: -1
      }
      {
        name: dma_lsio_trigger
        desc: Collated synchronous LSIO trigger signals for DMA
        struct: lsio_trigger
        package: dma_pkg
        type: uni
        act: req
        width: 1
        inst_name: soc_proxy
        default: ""
        top_signame: dma_lsio_trigger
        index: -1
      }
      {
        name: soc_fatal_alert
        desc: Differential fatal alert from SoC, synchronous
        struct: soc_alert
        package: soc_proxy_pkg
        type: req_rsp
        act: rsp
        width: 24
        inst_name: soc_proxy
        default: ""
        external: true
        top_signame: soc_fatal_alert
        conn_type: false
        index: -1
      }
      {
        name: soc_recov_alert
        desc: Differential recoverable alert from SoC, synchronous
        struct: soc_alert
        package: soc_proxy_pkg
        type: req_rsp
        act: rsp
        width: 4
        inst_name: soc_proxy
        default: ""
        external: true
        top_signame: soc_recov_alert
        conn_type: false
        index: -1
      }
      {
        name: soc_wkup_async
        desc: Wakeup request from SoC, asynchronous, level-encoded
        struct: logic
        type: uni
        act: rcv
        width: 1
        inst_name: soc_proxy
        default: ""
        package: ""
        external: true
        top_signame: soc_wkup_async
        conn_type: false
        index: -1
      }
      {
        name: soc_rst_req_async
        desc: Reset request from SoC, asynchronous, level-encoded
        struct: logic
        type: uni
        act: rcv
        width: 1
        inst_name: soc_proxy
        default: ""
        package: ""
        external: true
        top_signame: soc_rst_req_async
        conn_type: false
        index: -1
      }
      {
        name: soc_intr_async
        desc: Interrupt request from SoC, asynchronous, level-encoded
        struct: logic
        type: uni
        act: rcv
        width: 32
        inst_name: soc_proxy
        default: ""
        package: ""
        external: true
        top_signame: soc_intr_async
        conn_type: false
        index: -1
      }
      {
        name: soc_gpi_async
        desc: GPI from SoC, async
        struct: logic
        type: uni
        act: req
        width: 16
        inst_name: soc_proxy
        default: ""
        package: ""
        external: true
        top_signame: soc_gpi_async
        conn_type: false
        index: -1
      }
      {
        name: soc_gpo_async
        desc: GPO from SoC, async
        struct: logic
        type: uni
        act: rcv
        width: 16
        inst_name: soc_proxy
        default: ""
        package: ""
        external: true
        top_signame: soc_gpo_async
        conn_type: false
        index: -1
      }
      {
        name: integrator_id
        desc: Integrator ID signal used in BAT
        struct: logic
        type: uni
        act: rcv
        width: 4
        inst_name: soc_proxy
        default: ""
        package: ""
        external: true
        top_signame: integrator_id
        conn_type: false
        index: -1
      }
      {
        name: core_tl
        struct: tl
        package: tlul_pkg
        type: req_rsp
        act: rsp
        width: 1
        inst_name: soc_proxy
        default: ""
        end_idx: -1
        top_signame: soc_proxy_core_tl
        index: -1
      }
      {
        name: ctn_tl
        struct: tl
        package: tlul_pkg
        type: req_rsp
        act: rsp
        width: 1
        inst_name: soc_proxy
        default: ""
        end_idx: -1
        top_signame: soc_proxy_ctn_tl
        index: -1
      }
      {
        name: sram_otp_key
        struct: sram_otp_key
        package: otp_ctrl_pkg
        type: req_rsp
        act: req
        width: 1
        inst_name: sram_ctrl_ret_aon
        default: ""
        top_signame: otp_ctrl_sram_otp_key
        index: 1
      }
      {
        name: cfg
        struct: ram_1p_cfg
        package: prim_ram_1p_pkg
        type: uni
        act: rcv
        width:
        {
          name: NumRamInst
          desc: Number of internal RAM instances. Must be the same as ceil(MemSizeRam / InstSize) .
          param_type: int
          unpacked_dimensions: null
          default: 1
          local: false
          expose: true
          name_top: SramCtrlRetAonNumRamInst
        }
        default: "'0"
        inst_name: sram_ctrl_ret_aon
        external: true
        top_signame: sram_ctrl_ret_aon_ram_1p_cfg
        conn_type: false
        index: -1
      }
      {
        name: cfg_rsp
        struct: ram_1p_cfg_rsp
        package: prim_ram_1p_pkg
        type: uni
        act: req
        width:
        {
          name: NumRamInst
          desc: Number of internal RAM instances. Must be the same as ceil(MemSizeRam / InstSize) .
          param_type: int
          unpacked_dimensions: null
          default: 1
          local: false
          expose: true
          name_top: SramCtrlRetAonNumRamInst
        }
        default: "'0"
        inst_name: sram_ctrl_ret_aon
        external: true
        top_signame: sram_ctrl_ret_aon_ram_1p_cfg_rsp
        conn_type: false
        index: -1
      }
      {
        name: lc_escalate_en
        struct: lc_tx
        package: lc_ctrl_pkg
        type: uni
        act: rcv
        width: 1
        default: lc_ctrl_pkg::Off
        inst_name: sram_ctrl_ret_aon
        top_signame: lc_ctrl_lc_escalate_en
        index: -1
      }
      {
        name: lc_hw_debug_en
        struct: lc_tx
        package: lc_ctrl_pkg
        type: uni
        act: rcv
        width: 1
        default: lc_ctrl_pkg::Off
        inst_name: sram_ctrl_ret_aon
        index: -1
      }
      {
        name: otp_en_sram_ifetch
        struct: mubi8
        package: prim_mubi_pkg
        type: uni
        act: rcv
        width: 1
        default: prim_mubi_pkg::MuBi8False
        inst_name: sram_ctrl_ret_aon
        index: -1
      }
      {
        name: racl_policies
        desc:
          '''
          Incoming RACL policy vector from a racl_ctrl instance.
          The policy selection vector (parameter) selects the policy for each register.
          '''
        struct: racl_policy_vec
        package: top_racl_pkg
        type: uni
        act: rcv
        width: 1
        inst_name: sram_ctrl_ret_aon
        index: -1
      }
      {
        name: racl_error
        desc: RACL error log information of this module.
        struct: racl_error_log
        package: top_racl_pkg
        type: uni
        act: req
        width: 1
        inst_name: sram_ctrl_ret_aon
        index: -1
      }
      {
        name: sram_rerror
        desc: SRAM read error indicating correctable and uncorrectable ECC errors.
        struct: sram_error_t
        package: sram_ctrl_pkg
        type: uni
        act: req
        width: 1
        inst_name: sram_ctrl_ret_aon
        index: -1
      }
      {
        name: regs_tl
        struct: tl
        package: tlul_pkg
        type: req_rsp
        act: rsp
        width: 1
        inst_name: sram_ctrl_ret_aon
        default: ""
        end_idx: -1
        top_signame: sram_ctrl_ret_aon_regs_tl
        index: -1
      }
      {
        name: ram_tl
        struct: tl
        package: tlul_pkg
        type: req_rsp
        act: rsp
        width: 1
        inst_name: sram_ctrl_ret_aon
        default: ""
        end_idx: -1
        top_signame: sram_ctrl_ret_aon_ram_tl
        index: -1
      }
      {
        name: next_dm_addr
        desc:
          '''
          32bit word address of the next debug module.
          Set to 0x0 if this is the last debug module in the chain.
          '''
        struct: next_dm_addr
        package: rv_dm_pkg
        type: uni
        act: rcv
        width: 1
        default: "'0"
        inst_name: rv_dm
        external: true
        top_signame: rv_dm_next_dm_addr
        conn_type: false
        index: -1
      }
      {
        name: jtag
        desc: JTAG signals for the RISC-V TAP.
        struct: jtag
        package: jtag_pkg
        type: req_rsp
        act: rsp
        width: 1
        inst_name: rv_dm
        index: -1
      }
      {
        name: lc_hw_debug_en
        desc:
          '''
          Multibit life cycle hardware debug enable signal coming from life cycle controller,
          asserted when the hardware debug mechanisms are enabled in the system.
          '''
        struct: lc_tx
        package: lc_ctrl_pkg
        type: uni
        act: rcv
        width: 1
        default: lc_ctrl_pkg::Off
        inst_name: rv_dm
        top_signame: lc_ctrl_lc_hw_debug_en
        index: -1
      }
      {
        name: lc_dft_en
        desc:
          '''
          Multibit life cycle hardware debug enable signal coming from life cycle controller,
          asserted when the DFT mechanisms are enabled in the system.
          '''
        struct: lc_tx
        package: lc_ctrl_pkg
        type: uni
        act: rcv
        width: 1
        default: lc_ctrl_pkg::Off
        inst_name: rv_dm
        index: -1
      }
      {
        name: pinmux_hw_debug_en
        desc:
          '''
          Multibit life cycle hardware debug enable signal coming from pinmux.
          This is a latched version of the lc_hw_debug_en signal and is only used to
          gate the JTAG / TAP side of the RV_DM. It is used to keep a debug session live
          while the rest of the system undergoes an NDM reset.
          '''
        struct: lc_tx
        package: lc_ctrl_pkg
        type: uni
        act: rcv
        width: 1
        default: lc_ctrl_pkg::Off
        inst_name: rv_dm
        index: -1
      }
      {
        name: otp_dis_rv_dm_late_debug
        struct: mubi8
        package: prim_mubi_pkg
        type: uni
        act: rcv
        width: 1
        default: prim_mubi_pkg::MuBi8False
        inst_name: rv_dm
        top_signame: rv_dm_otp_dis_rv_dm_late_debug
        index: -1
      }
      {
        name: unavailable
        desc:
          '''
          This signal indicates to the debug module that the main processor is not available
          for debug (e.g. due to a low-power state).
          '''
        struct: logic
        type: uni
        act: rcv
        width: 1
        default: 1'b0
        inst_name: rv_dm
        index: -1
      }
      {
        name: ndmreset_req
        desc: Non-debug module reset request going to the system reset infrastructure.
        struct: logic
        type: uni
        act: req
        width: 1
        inst_name: rv_dm
        default: ""
        package: ""
        end_idx: -1
        top_type: broadcast
        top_signame: rv_dm_ndmreset_req
        index: -1
      }
      {
        name: dmactive
        desc:
          '''
          This signal indicates whether the debug module is active and can be used to prevent
          power down of the core and bus-attached peripherals.
          '''
        struct: logic
        type: uni
        act: req
        width: 1
        inst_name: rv_dm
        index: -1
      }
      {
        name: debug_req
        desc: This is the debug request interrupt going to the main processor.
        struct: logic [rv_dm_reg_pkg::NrHarts-1:0]
        type: uni
        act: req
        width: 1
        inst_name: rv_dm
        default: ""
        package: ""
        end_idx: -1
        top_type: broadcast
        top_signame: rv_dm_debug_req
        index: -1
      }
      {
        name: lc_escalate_en
        desc:
          '''
          Escalation enable signal coming from life cycle controller, used for invalidating
          the latched lc_hw_debug_en state inside the strap sampling logic.
          '''
        struct: lc_tx
        package: lc_ctrl_pkg
        type: uni
        act: rcv
        width: 1
        default: lc_ctrl_pkg::Off
        inst_name: rv_dm
        top_signame: lc_ctrl_lc_escalate_en
        index: -1
      }
      {
        name: lc_check_byp_en
        desc:
          '''
          Check bypass enable signal coming from life cycle controller, used for invalidating
          the latched lc_hw_debug_en state inside the strap sampling logic. This signal is asserted
          whenever the life cycle controller performs a life cycle transition. Its main use is
          to skip any background checks inside the life cycle partition of the OTP controller while
          a life cycle transition is in progress.
          '''
        struct: lc_tx
        package: lc_ctrl_pkg
        type: uni
        act: rcv
        width: 1
        default: lc_ctrl_pkg::Off
        inst_name: rv_dm
        top_signame: lc_ctrl_lc_check_byp_en
        index: -1
      }
      {
        name: strap_en
        desc: This signal is pulsed high by the power manager after reset in order to sample the HW straps.
        struct: logic
        type: uni
        act: rcv
        width: 1
        default: 1'b0
        inst_name: rv_dm
        package: ""
        top_signame: pwrmgr_aon_strap
        index: -1
      }
      {
        name: strap_en_override
        desc:
          '''
          This signal transitions from 0 -> 1 by the lc_ctrl manager after volatile RAW_UNLOCK in order to re-sample the HW straps.
          The signal must stay at 1 until reset.
          Note that this is only used in test chips when SecVolatileRawUnlockEn = 1.
          Otherwise this signal is unused.
          '''
        struct: logic
        type: uni
        act: rcv
        width: 1
        default: 1'b0
        inst_name: rv_dm
        package: ""
        top_signame: lc_ctrl_strap_en_override
        index: -1
      }
      {
        name: racl_policies
        desc:
          '''
          Incoming RACL policy vector from a racl_ctrl instance.
          The policy selection vector (parameter) selects the policy for each register.
          '''
        struct: racl_policy_vec
        package: top_racl_pkg
        type: uni
        act: rcv
        width: 1
        inst_name: rv_dm
        index: -1
      }
      {
        name: racl_error
        desc: RACL error log information of this module.
        struct: racl_error_log
        package: top_racl_pkg
        type: uni
        act: req
        width: 1
        inst_name: rv_dm
        index: -1
      }
      {
        name: sba_tl_h
        struct: tl
        package: tlul_pkg
        type: req_rsp
        act: req
        width: 1
        inst_name: rv_dm
        default: ""
        top_signame: main_tl_rv_dm__sba
        index: -1
      }
      {
        name: regs_tl_d
        struct: tl
        package: tlul_pkg
        type: req_rsp
        act: rsp
        width: 1
        inst_name: rv_dm
        default: ""
        end_idx: -1
        top_signame: rv_dm_regs_tl_d
        index: -1
      }
      {
        name: mem_tl_d
        struct: tl
        package: tlul_pkg
        type: req_rsp
        act: rsp
        width: 1
        inst_name: rv_dm
        default: ""
        end_idx: -1
        top_signame: rv_dm_mem_tl_d
        index: -1
      }
      {
        name: dbg_tl_d
        struct: tl
        package: tlul_pkg
        type: req_rsp
        act: rsp
        width: 1
        inst_name: rv_dm
        default: ""
        end_idx: -1
        top_signame: rv_dm_dbg_tl_d
        index: -1
      }
      {
        name: irq
        struct: logic
        type: uni
        act: req
        width: 1
        inst_name: rv_plic
        default: ""
        package: ""
        end_idx: -1
        top_type: broadcast
        top_signame: rv_plic_irq
        index: -1
      }
      {
        name: irq_id
        struct: logic
        type: uni
        act: req
        width: 1
        inst_name: rv_plic
        index: -1
      }
      {
        name: msip
        struct: logic
        type: uni
        act: req
        width: 1
        inst_name: rv_plic
        default: ""
        package: ""
        end_idx: -1
        top_type: broadcast
        top_signame: rv_plic_msip
        index: -1
      }
      {
        name: tl
        struct: tl
        package: tlul_pkg
        type: req_rsp
        act: rsp
        width: 1
        inst_name: rv_plic
        default: ""
        end_idx: -1
        top_signame: rv_plic_tl
        index: -1
      }
      {
        name: idle
        struct: mubi4
        package: prim_mubi_pkg
        type: uni
        act: req
        width: 1
        inst_name: aes
        default: ""
        top_signame: clkmgr_aon_idle
        index: 0
      }
      {
        name: lc_escalate_en
        struct: lc_tx
        package: lc_ctrl_pkg
        type: uni
        act: rcv
        width: 1
        default: lc_ctrl_pkg::Off
        inst_name: aes
        top_signame: lc_ctrl_lc_escalate_en
        index: -1
      }
      {
        name: edn
        struct: edn
        package: edn_pkg
        type: req_rsp
        act: req
        width: 1
        inst_name: aes
        default: ""
        top_signame: edn0_edn
        index: 5
      }
      {
        name: keymgr_key
        struct: hw_key_req
        package: keymgr_pkg
        type: uni
        act: rcv
        width: 1
        inst_name: aes
        default: ""
        top_signame: keymgr_dpe_aes_key
        index: -1
      }
      {
        name: tl
        struct: tl
        package: tlul_pkg
        type: req_rsp
        act: rsp
        width: 1
        inst_name: aes
        default: ""
        end_idx: -1
        top_signame: aes_tl
        index: -1
      }
      {
        name: idle
        struct: mubi4
        package: prim_mubi_pkg
        type: uni
        act: req
        width: 1
        inst_name: hmac
        default: ""
        top_signame: clkmgr_aon_idle
        index: 1
      }
      {
        name: tl
        struct: tl
        package: tlul_pkg
        type: req_rsp
        act: rsp
        width: 1
        inst_name: hmac
        default: ""
        end_idx: -1
        top_signame: hmac_tl
        index: -1
      }
      {
        name: keymgr_key
        struct: hw_key_req
        package: keymgr_pkg
        type: uni
        act: rcv
        width: 1
        inst_name: kmac
        default: ""
        top_signame: keymgr_dpe_kmac_key
        index: -1
      }
      {
        name: app
        struct: app
        package: kmac_pkg
        type: req_rsp
        act: rsp
        width:
        {
          name: NumAppIntf
          desc: Number of application interfaces
          param_type: int
          unpacked_dimensions: null
          default: 3
          local: false
          expose: true
          name_top: KmacNumAppIntf
        }
        inst_name: kmac
        default: ""
        end_idx: -1
        top_type: one-to-N
        top_signame: kmac_app
        index: -1
      }
      {
        name: entropy
        struct: edn
        package: edn_pkg
        type: req_rsp
        act: req
        width: 1
        inst_name: kmac
        default: ""
        top_signame: edn0_edn
        index: 3
      }
      {
        name: idle
        struct: mubi4
        package: prim_mubi_pkg
        type: uni
        act: req
        width: 1
        inst_name: kmac
        default: ""
        top_signame: clkmgr_aon_idle
        index: 2
      }
      {
        name: en_masking
        struct: logic
        type: uni
        act: req
        width: 1
        inst_name: kmac
        default: ""
        package: ""
        end_idx: -1
        top_type: broadcast
        top_signame: kmac_en_masking
        index: -1
      }
      {
        name: lc_escalate_en
        struct: lc_tx
        package: lc_ctrl_pkg
        type: uni
        act: rcv
        width: 1
        default: lc_ctrl_pkg::Off
        inst_name: kmac
        top_signame: lc_ctrl_lc_escalate_en
        index: -1
      }
      {
        name: tl
        struct: tl
        package: tlul_pkg
        type: req_rsp
        act: rsp
        width: 1
        inst_name: kmac
        default: ""
        end_idx: -1
        top_signame: kmac_tl
        index: -1
      }
      {
        name: otbn_otp_key
        struct: otbn_otp_key
        package: otp_ctrl_pkg
        type: req_rsp
        act: req
        width: 1
        default: "'0"
        inst_name: otbn
        top_signame: otp_ctrl_otbn_otp_key
        index: -1
      }
      {
        name: edn_rnd
        struct: edn
        package: edn_pkg
        type: req_rsp
        act: req
        width: 1
        inst_name: otbn
        default: ""
        top_signame: edn1_edn
        index: 0
      }
      {
        name: edn_urnd
        struct: edn
        package: edn_pkg
        type: req_rsp
        act: req
        width: 1
        inst_name: otbn
        default: ""
        top_signame: edn0_edn
        index: 6
      }
      {
        name: idle
        struct: mubi4
        package: prim_mubi_pkg
        type: uni
        act: req
        width: 1
        inst_name: otbn
        default: ""
        top_signame: clkmgr_aon_idle
        index: 3
      }
      {
        name: ram_cfg_imem
        struct: ram_1p_cfg
        package: prim_ram_1p_pkg
        type: uni
        act: rcv
        width: 1
        inst_name: otbn
        default: ""
        external: true
        top_signame: otbn_imem_ram_1p_cfg
        conn_type: false
        index: -1
      }
      {
        name: ram_cfg_dmem
        struct: ram_1p_cfg
        package: prim_ram_1p_pkg
        type: uni
        act: rcv
        width: 1
        inst_name: otbn
        default: ""
        external: true
        top_signame: otbn_dmem_ram_1p_cfg
        conn_type: false
        index: -1
      }
      {
        name: ram_cfg_rsp_imem
        struct: ram_1p_cfg_rsp
        package: prim_ram_1p_pkg
        type: uni
        act: req
        width: 1
        inst_name: otbn
        default: ""
        external: true
        top_signame: otbn_imem_ram_1p_cfg_rsp
        conn_type: false
        index: -1
      }
      {
        name: ram_cfg_rsp_dmem
        struct: ram_1p_cfg_rsp
        package: prim_ram_1p_pkg
        type: uni
        act: req
        width: 1
        inst_name: otbn
        default: ""
        external: true
        top_signame: otbn_dmem_ram_1p_cfg_rsp
        conn_type: false
        index: -1
      }
      {
        name: lc_escalate_en
        struct: lc_tx
        package: lc_ctrl_pkg
        type: uni
        act: rcv
        width: 1
        default: lc_ctrl_pkg::Off
        inst_name: otbn
        top_signame: lc_ctrl_lc_escalate_en
        index: -1
      }
      {
        name: lc_rma_req
        struct: lc_tx
        package: lc_ctrl_pkg
        type: uni
        act: rcv
        width: 1
        default: lc_ctrl_pkg::Off
        inst_name: otbn
        top_signame: lc_ctrl_lc_flash_rma_req
        index: -1
      }
      {
        name: lc_rma_ack
        struct: lc_tx
        package: lc_ctrl_pkg
        type: uni
        act: req
        width: 1
        default: lc_ctrl_pkg::Off
        inst_name: otbn
        end_idx: -1
        top_type: broadcast
        top_signame: otbn_lc_rma_ack
        index: -1
      }
      {
        name: keymgr_key
        struct: otbn_key_req
        package: keymgr_pkg
        type: uni
        act: rcv
        width: 1
        inst_name: otbn
        default: ""
        top_signame: keymgr_dpe_otbn_key
        index: -1
      }
      {
        name: tl
        struct: tl
        package: tlul_pkg
        type: req_rsp
        act: rsp
        width: 1
        inst_name: otbn
        default: ""
        end_idx: -1
        top_signame: otbn_tl
        index: -1
      }
      {
        name: edn
        struct: edn
        package: edn_pkg
        type: req_rsp
        act: req
        width: 1
        inst_name: keymgr_dpe
        default: ""
        top_signame: edn0_edn
        index: 0
      }
      {
        name: aes_key
        struct: hw_key_req
        package: keymgr_pkg
        type: uni
        act: req
        width: 1
        inst_name: keymgr_dpe
        default: ""
        end_idx: -1
        top_type: broadcast
        top_signame: keymgr_dpe_aes_key
        index: -1
      }
      {
        name: kmac_key
        struct: hw_key_req
        package: keymgr_pkg
        type: uni
        act: req
        width: 1
        inst_name: keymgr_dpe
        default: ""
        end_idx: -1
        top_type: broadcast
        top_signame: keymgr_dpe_kmac_key
        index: -1
      }
      {
        name: otbn_key
        struct: otbn_key_req
        package: keymgr_pkg
        type: uni
        act: req
        width: 1
        inst_name: keymgr_dpe
        default: ""
        end_idx: -1
        top_type: broadcast
        top_signame: keymgr_dpe_otbn_key
        index: -1
      }
      {
        name: kmac_data
        struct: app
        package: kmac_pkg
        type: req_rsp
        act: req
        width: 1
        inst_name: keymgr_dpe
        default: ""
        top_signame: kmac_app
        index: 0
      }
      {
        name: otp_key
        struct: otp_keymgr_key
        package: otp_ctrl_pkg
        type: uni
        act: rcv
        width: 1
        inst_name: keymgr_dpe
        default: ""
        top_signame: otp_ctrl_otp_keymgr_key
        index: -1
      }
      {
        name: otp_device_id
        struct: otp_device_id
        package: otp_ctrl_pkg
        type: uni
        act: rcv
        width: 1
        inst_name: keymgr_dpe
        default: ""
        top_signame: keymgr_dpe_otp_device_id
        index: -1
      }
      {
        name: lc_keymgr_en
        struct: lc_tx
        package: lc_ctrl_pkg
        type: uni
        act: rcv
        width: 1
        default: lc_ctrl_pkg::On
        inst_name: keymgr_dpe
        top_signame: lc_ctrl_lc_keymgr_en
        index: -1
      }
      {
        name: lc_keymgr_div
        struct: lc_keymgr_div
        package: lc_ctrl_pkg
        type: uni
        act: rcv
        width: 1
        inst_name: keymgr_dpe
        default: ""
        top_signame: lc_ctrl_lc_keymgr_div
        index: -1
      }
      {
        name: rom_digest
        struct: keymgr_data
        package: rom_ctrl_pkg
        type: uni
        act: rcv
        width: 2
        default: rom_ctrl_pkg::KEYMGR_DATA_DEFAULT
        inst_name: keymgr_dpe
        end_idx: -1
        top_type: one-to-N
        top_signame: keymgr_dpe_rom_digest
        index: -1
      }
      {
        name: kmac_en_masking
        struct: logic
        type: uni
        act: rcv
        width: 1
        inst_name: keymgr_dpe
        default: ""
        package: ""
        top_signame: kmac_en_masking
        index: -1
      }
      {
        name: tl
        struct: tl
        package: tlul_pkg
        type: req_rsp
        act: rsp
        width: 1
        inst_name: keymgr_dpe
        default: ""
        end_idx: -1
        top_signame: keymgr_dpe_tl
        index: -1
      }
      {
        name: csrng_cmd
        struct: csrng
        package: csrng_pkg
        type: req_rsp
        act: rsp
        width: 2
        inst_name: csrng
        default: ""
        end_idx: -1
        top_type: one-to-N
        top_signame: csrng_csrng_cmd
        index: -1
      }
      {
        name: entropy_src_hw_if
        struct: entropy_src_hw_if
        package: entropy_src_pkg
        type: req_rsp
        act: req
        width: 1
        inst_name: csrng
        default: ""
        external: true
        top_signame: entropy_src_hw_if
        conn_type: false
        index: -1
      }
      {
        name: cs_aes_halt
        desc:
          '''
          Coordinate activity between CSRNG's AES and Entropy Source's SHA3.
          When CSRNG gets a request and its AES is not active, it acknowledges and until the request has dropped neither runs its AES nor drops the acknowledge.
          '''
        struct: cs_aes_halt
        package: entropy_src_pkg
        type: req_rsp
        act: rsp
        width: 1
        inst_name: csrng
        index: -1
      }
      {
        name: otp_en_csrng_sw_app_read
        struct: mubi8
        package: prim_mubi_pkg
        type: uni
        act: rcv
        width: 1
        default: prim_mubi_pkg::MuBi8True
        inst_name: csrng
        index: -1
      }
      {
        name: lc_hw_debug_en
        struct: lc_tx
        package: lc_ctrl_pkg
        type: uni
        act: rcv
        width: 1
        default: lc_ctrl_pkg::Off
        inst_name: csrng
        top_signame: lc_ctrl_lc_hw_debug_en
        index: -1
      }
      {
        name: tl
        struct: tl
        package: tlul_pkg
        type: req_rsp
        act: rsp
        width: 1
        inst_name: csrng
        default: ""
        end_idx: -1
        top_signame: csrng_tl
        index: -1
      }
      {
        name: csrng_cmd
        desc: EDN supports a signal CSRNG application interface.
        struct: csrng
        package: csrng_pkg
        type: req_rsp
        act: req
        width: 1
        inst_name: edn0
        default: ""
        top_signame: csrng_csrng_cmd
        index: 0
      }
      {
        name: edn
        desc:
          '''
          The collection of peripheral ports supported by edn. The width (4)
          indicates the number of peripheral ports on a single instance.
          Due to limitations in the parametrization of top-level interconnects
          this value is not currently parameterizable.  However, the number
          of peripheral ports may change in a future revision.
          '''
        struct: edn
        package: edn_pkg
        type: req_rsp
        act: rsp
        width: 8
        default: "'0"
        inst_name: edn0
        end_idx: -1
        top_type: one-to-N
        top_signame: edn0_edn
        index: -1
      }
      {
        name: tl
        struct: tl
        package: tlul_pkg
        type: req_rsp
        act: rsp
        width: 1
        inst_name: edn0
        default: ""
        end_idx: -1
        top_signame: edn0_tl
        index: -1
      }
      {
        name: csrng_cmd
        desc: EDN supports a signal CSRNG application interface.
        struct: csrng
        package: csrng_pkg
        type: req_rsp
        act: req
        width: 1
        inst_name: edn1
        default: ""
        top_signame: csrng_csrng_cmd
        index: 1
      }
      {
        name: edn
        desc:
          '''
          The collection of peripheral ports supported by edn. The width (4)
          indicates the number of peripheral ports on a single instance.
          Due to limitations in the parametrization of top-level interconnects
          this value is not currently parameterizable.  However, the number
          of peripheral ports may change in a future revision.
          '''
        struct: edn
        package: edn_pkg
        type: req_rsp
        act: rsp
        width: 8
        default: "'0"
        inst_name: edn1
        end_idx: 1
        top_type: partial-one-to-N
        top_signame: edn1_edn
        index: -1
      }
      {
        name: tl
        struct: tl
        package: tlul_pkg
        type: req_rsp
        act: rsp
        width: 1
        inst_name: edn1
        default: ""
        end_idx: -1
        top_signame: edn1_tl
        index: -1
      }
      {
        name: sram_otp_key
        struct: sram_otp_key
        package: otp_ctrl_pkg
        type: req_rsp
        act: req
        width: 1
        inst_name: sram_ctrl_main
        default: ""
        top_signame: otp_ctrl_sram_otp_key
        index: 0
      }
      {
        name: cfg
        struct: ram_1p_cfg
        package: prim_ram_1p_pkg
        type: uni
        act: rcv
        width:
        {
          name: NumRamInst
          desc: Number of internal RAM instances. Must be the same as ceil(MemSizeRam / InstSize) .
          param_type: int
          unpacked_dimensions: null
          default: 1
          local: false
          expose: true
          name_top: SramCtrlMainNumRamInst
        }
        default: "'0"
        inst_name: sram_ctrl_main
        external: true
        top_signame: sram_ctrl_main_ram_1p_cfg
        conn_type: false
        index: -1
      }
      {
        name: cfg_rsp
        struct: ram_1p_cfg_rsp
        package: prim_ram_1p_pkg
        type: uni
        act: req
        width:
        {
          name: NumRamInst
          desc: Number of internal RAM instances. Must be the same as ceil(MemSizeRam / InstSize) .
          param_type: int
          unpacked_dimensions: null
          default: 1
          local: false
          expose: true
          name_top: SramCtrlMainNumRamInst
        }
        default: "'0"
        inst_name: sram_ctrl_main
        external: true
        top_signame: sram_ctrl_main_ram_1p_cfg_rsp
        conn_type: false
        index: -1
      }
      {
        name: lc_escalate_en
        struct: lc_tx
        package: lc_ctrl_pkg
        type: uni
        act: rcv
        width: 1
        default: lc_ctrl_pkg::Off
        inst_name: sram_ctrl_main
        top_signame: lc_ctrl_lc_escalate_en
        index: -1
      }
      {
        name: lc_hw_debug_en
        struct: lc_tx
        package: lc_ctrl_pkg
        type: uni
        act: rcv
        width: 1
        default: lc_ctrl_pkg::Off
        inst_name: sram_ctrl_main
        top_signame: lc_ctrl_lc_hw_debug_en
        index: -1
      }
      {
        name: otp_en_sram_ifetch
        struct: mubi8
        package: prim_mubi_pkg
        type: uni
        act: rcv
        width: 1
        default: prim_mubi_pkg::MuBi8False
        inst_name: sram_ctrl_main
        top_signame: sram_ctrl_main_otp_en_sram_ifetch
        index: -1
      }
      {
        name: racl_policies
        desc:
          '''
          Incoming RACL policy vector from a racl_ctrl instance.
          The policy selection vector (parameter) selects the policy for each register.
          '''
        struct: racl_policy_vec
        package: top_racl_pkg
        type: uni
        act: rcv
        width: 1
        inst_name: sram_ctrl_main
        index: -1
      }
      {
        name: racl_error
        desc: RACL error log information of this module.
        struct: racl_error_log
        package: top_racl_pkg
        type: uni
        act: req
        width: 1
        inst_name: sram_ctrl_main
        index: -1
      }
      {
        name: sram_rerror
        desc: SRAM read error indicating correctable and uncorrectable ECC errors.
        struct: sram_error_t
        package: sram_ctrl_pkg
        type: uni
        act: req
        width: 1
        inst_name: sram_ctrl_main
        index: -1
      }
      {
        name: regs_tl
        struct: tl
        package: tlul_pkg
        type: req_rsp
        act: rsp
        width: 1
        inst_name: sram_ctrl_main
        default: ""
        end_idx: -1
        top_signame: sram_ctrl_main_regs_tl
        index: -1
      }
      {
        name: ram_tl
        struct: tl
        package: tlul_pkg
        type: req_rsp
        act: rsp
        width: 1
        inst_name: sram_ctrl_main
        default: ""
        end_idx: -1
        top_signame: sram_ctrl_main_ram_tl
        index: -1
      }
      {
        name: sram_otp_key
        struct: sram_otp_key
        package: otp_ctrl_pkg
        type: req_rsp
        act: req
        width: 1
        inst_name: sram_ctrl_mbox
        default: ""
        top_signame: otp_ctrl_sram_otp_key
        index: 2
      }
      {
        name: cfg
        struct: ram_1p_cfg
        package: prim_ram_1p_pkg
        type: uni
        act: rcv
        width:
        {
          name: NumRamInst
          desc: Number of internal RAM instances. Must be the same as ceil(MemSizeRam / InstSize) .
          param_type: int
          unpacked_dimensions: null
          default: 1
          local: false
          expose: true
          name_top: SramCtrlMboxNumRamInst
        }
        default: "'0"
        inst_name: sram_ctrl_mbox
        external: true
        top_signame: sram_ctrl_mbox_ram_1p_cfg
        conn_type: false
        index: -1
      }
      {
        name: cfg_rsp
        struct: ram_1p_cfg_rsp
        package: prim_ram_1p_pkg
        type: uni
        act: req
        width:
        {
          name: NumRamInst
          desc: Number of internal RAM instances. Must be the same as ceil(MemSizeRam / InstSize) .
          param_type: int
          unpacked_dimensions: null
          default: 1
          local: false
          expose: true
          name_top: SramCtrlMboxNumRamInst
        }
        default: "'0"
        inst_name: sram_ctrl_mbox
        external: true
        top_signame: sram_ctrl_mbox_ram_1p_cfg_rsp
        conn_type: false
        index: -1
      }
      {
        name: lc_escalate_en
        struct: lc_tx
        package: lc_ctrl_pkg
        type: uni
        act: rcv
        width: 1
        default: lc_ctrl_pkg::Off
        inst_name: sram_ctrl_mbox
        top_signame: lc_ctrl_lc_escalate_en
        index: -1
      }
      {
        name: lc_hw_debug_en
        struct: lc_tx
        package: lc_ctrl_pkg
        type: uni
        act: rcv
        width: 1
        default: lc_ctrl_pkg::Off
        inst_name: sram_ctrl_mbox
        index: -1
      }
      {
        name: otp_en_sram_ifetch
        struct: mubi8
        package: prim_mubi_pkg
        type: uni
        act: rcv
        width: 1
        default: prim_mubi_pkg::MuBi8False
        inst_name: sram_ctrl_mbox
        index: -1
      }
      {
        name: racl_policies
        desc:
          '''
          Incoming RACL policy vector from a racl_ctrl instance.
          The policy selection vector (parameter) selects the policy for each register.
          '''
        struct: racl_policy_vec
        package: top_racl_pkg
        type: uni
        act: rcv
        width: 1
        inst_name: sram_ctrl_mbox
        index: -1
      }
      {
        name: racl_error
        desc: RACL error log information of this module.
        struct: racl_error_log
        package: top_racl_pkg
        type: uni
        act: req
        width: 1
        inst_name: sram_ctrl_mbox
        index: -1
      }
      {
        name: sram_rerror
        desc: SRAM read error indicating correctable and uncorrectable ECC errors.
        struct: sram_error_t
        package: sram_ctrl_pkg
        type: uni
        act: req
        width: 1
        inst_name: sram_ctrl_mbox
        index: -1
      }
      {
        name: regs_tl
        struct: tl
        package: tlul_pkg
        type: req_rsp
        act: rsp
        width: 1
        inst_name: sram_ctrl_mbox
        default: ""
        end_idx: -1
        top_signame: sram_ctrl_mbox_regs_tl
        index: -1
      }
      {
        name: ram_tl
        struct: tl
        package: tlul_pkg
        type: req_rsp
        act: rsp
        width: 1
        inst_name: sram_ctrl_mbox
        default: ""
        end_idx: -1
        top_signame: sram_ctrl_mbox_ram_tl
        index: -1
      }
      {
        name: rom_cfg
        struct: rom_cfg
        package: prim_rom_pkg
        type: uni
        act: rcv
        width: 1
        inst_name: rom_ctrl0
        default: ""
        external: true
        top_signame: rom_ctrl0_cfg
        conn_type: false
        index: -1
      }
      {
        name: pwrmgr_data
        struct: pwrmgr_data
        package: rom_ctrl_pkg
        type: uni
        act: req
        width: 1
        inst_name: rom_ctrl0
        default: ""
        top_signame: pwrmgr_aon_rom_ctrl
        index: 0
      }
      {
        name: keymgr_data
        struct: keymgr_data
        package: rom_ctrl_pkg
        type: uni
        act: req
        width: 1
        inst_name: rom_ctrl0
        default: ""
        top_signame: keymgr_dpe_rom_digest
        index: 0
      }
      {
        name: kmac_data
        struct: app
        package: kmac_pkg
        type: req_rsp
        act: req
        width: 1
        inst_name: rom_ctrl0
        default: ""
        top_signame: kmac_app
        index: 2
      }
      {
        name: regs_tl
        struct: tl
        package: tlul_pkg
        type: req_rsp
        act: rsp
        width: 1
        inst_name: rom_ctrl0
        default: ""
        end_idx: -1
        top_signame: rom_ctrl0_regs_tl
        index: -1
      }
      {
        name: rom_tl
        struct: tl
        package: tlul_pkg
        type: req_rsp
        act: rsp
        width: 1
        inst_name: rom_ctrl0
        default: ""
        end_idx: -1
        top_signame: rom_ctrl0_rom_tl
        index: -1
      }
      {
        name: rom_cfg
        struct: rom_cfg
        package: prim_rom_pkg
        type: uni
        act: rcv
        width: 1
        inst_name: rom_ctrl1
        default: ""
        external: true
        top_signame: rom_ctrl1_cfg
        conn_type: false
        index: -1
      }
      {
        name: pwrmgr_data
        struct: pwrmgr_data
        package: rom_ctrl_pkg
        type: uni
        act: req
        width: 1
        inst_name: rom_ctrl1
        default: ""
        top_signame: pwrmgr_aon_rom_ctrl
        index: 1
      }
      {
        name: keymgr_data
        struct: keymgr_data
        package: rom_ctrl_pkg
        type: uni
        act: req
        width: 1
        inst_name: rom_ctrl1
        default: ""
        top_signame: keymgr_dpe_rom_digest
        index: 1
      }
      {
        name: kmac_data
        struct: app
        package: kmac_pkg
        type: req_rsp
        act: req
        width: 1
        inst_name: rom_ctrl1
        default: ""
        top_signame: kmac_app
        index: 3
      }
      {
        name: regs_tl
        struct: tl
        package: tlul_pkg
        type: req_rsp
        act: rsp
        width: 1
        inst_name: rom_ctrl1
        default: ""
        end_idx: -1
        top_signame: rom_ctrl1_regs_tl
        index: -1
      }
      {
        name: rom_tl
        struct: tl
        package: tlul_pkg
        type: req_rsp
        act: rsp
        width: 1
        inst_name: rom_ctrl1
        default: ""
        end_idx: -1
        top_signame: rom_ctrl1_rom_tl
        index: -1
      }
      {
        name: lsio_trigger
        struct: lsio_trigger
        package: dma_pkg
        type: uni
        act: rcv
        width: 1
        inst_name: dma
        default: ""
        end_idx: -1
        top_type: broadcast
        top_signame: dma_lsio_trigger
        index: -1
      }
      {
        name: sys
        struct: sys
        package: dma_pkg
        type: req_rsp
        act: req
        width: 1
        inst_name: dma
        default: ""
        external: true
        top_signame: dma_sys
        conn_type: false
        index: -1
      }
      {
        name: ctn_tl_h2d
        desc: TL-UL host port for egress into CTN (request part), synchronous
        struct: tl_h2d
        package: tlul_pkg
        type: uni
        act: req
        width: 1
        inst_name: dma
        default: ""
        top_signame: soc_proxy_dma_tl_h2d
        index: -1
      }
      {
        name: ctn_tl_d2h
        desc: TL-UL host port for egress into CTN (response part), synchronous
        struct: tl_d2h
        package: tlul_pkg
        type: uni
        act: rcv
        width: 1
        inst_name: dma
        default: ""
        top_signame: soc_proxy_dma_tl_d2h
        index: -1
      }
      {
        name: racl_policies
        desc:
          '''
          Incoming RACL policy vector from a racl_ctrl instance.
          The policy selection vector (parameter) selects the policy for each register.
          '''
        struct: racl_policy_vec
        package: top_racl_pkg
        type: uni
        act: rcv
        width: 1
        inst_name: dma
        index: -1
      }
      {
        name: racl_error
        desc: RACL error log information of this module.
        struct: racl_error_log
        package: top_racl_pkg
        type: uni
        act: req
        width: 1
        inst_name: dma
        index: -1
      }
      {
        name: host_tl_h
        struct: tl
        package: tlul_pkg
        type: req_rsp
        act: req
        width: 1
        inst_name: dma
        default: ""
        top_signame: main_tl_dma__host
        index: -1
      }
      {
        name: tl_d
        struct: tl
        package: tlul_pkg
        type: req_rsp
        act: rsp
        width: 1
        inst_name: dma
        default: ""
        end_idx: -1
        top_signame: dma_tl_d
        index: -1
      }
      {
        name: doe_intr_support
        struct: logic
        type: uni
        act: req
        width: 1
        default: 1'b0
        inst_name: mbx0
        package: ""
        external: true
        top_signame: mbx0_doe_intr_support
        conn_type: false
        index: -1
      }
      {
        name: doe_intr_en
        struct: logic
        type: uni
        act: req
        width: 1
        default: 1'b0
        inst_name: mbx0
        package: ""
        external: true
        top_signame: mbx0_doe_intr_en
        conn_type: false
        index: -1
      }
      {
        name: doe_intr
        struct: logic
        type: uni
        act: req
        width: 1
        default: 1'b0
        inst_name: mbx0
        package: ""
        external: true
        top_signame: mbx0_doe_intr
        conn_type: false
        index: -1
      }
      {
        name: doe_async_msg_support
        struct: logic
        type: uni
        act: req
        width: 1
        default: 1'b0
        inst_name: mbx0
        package: ""
        external: true
        top_signame: mbx0_doe_async_msg_support
        conn_type: false
        index: -1
      }
      {
        name: racl_policies
        desc:
          '''
          Incoming RACL policy vector from a racl_ctrl instance.
          The policy selection vector (parameter) selects the policy for each register.
          '''
        struct: racl_policy_vec
        package: top_racl_pkg
        type: uni
        act: rcv
        width: 1
        inst_name: mbx0
        default: ""
        top_signame: racl_ctrl_racl_policies
        index: -1
      }
      {
        name: racl_error
        desc: RACL error log information of this module.
        struct: racl_error_log
        package: top_racl_pkg
        type: uni
        act: req
        width: 1
        inst_name: mbx0
        default: ""
        top_signame: racl_ctrl_racl_error
        index: 0
      }
      {
        name: sram_tl_h
        struct: tl
        package: tlul_pkg
        type: req_rsp
        act: req
        width: 1
        inst_name: mbx0
        default: ""
        top_signame: main_tl_mbx0__sram
        index: -1
      }
      {
        name: core_tl_d
        struct: tl
        package: tlul_pkg
        type: req_rsp
        act: rsp
        width: 1
        inst_name: mbx0
        default: ""
        end_idx: -1
        top_signame: mbx0_core_tl_d
        index: -1
      }
      {
        name: soc_tl_d
        struct: tl
        package: tlul_pkg
        type: req_rsp
        act: rsp
        width: 1
        inst_name: mbx0
        default: ""
        end_idx: -1
        top_signame: mbx0_soc_tl_d
        index: -1
      }
      {
        name: doe_intr_support
        struct: logic
        type: uni
        act: req
        width: 1
        default: 1'b0
        inst_name: mbx1
        package: ""
        external: true
        top_signame: mbx1_doe_intr_support
        conn_type: false
        index: -1
      }
      {
        name: doe_intr_en
        struct: logic
        type: uni
        act: req
        width: 1
        default: 1'b0
        inst_name: mbx1
        package: ""
        external: true
        top_signame: mbx1_doe_intr_en
        conn_type: false
        index: -1
      }
      {
        name: doe_intr
        struct: logic
        type: uni
        act: req
        width: 1
        default: 1'b0
        inst_name: mbx1
        package: ""
        external: true
        top_signame: mbx1_doe_intr
        conn_type: false
        index: -1
      }
      {
        name: doe_async_msg_support
        struct: logic
        type: uni
        act: req
        width: 1
        default: 1'b0
        inst_name: mbx1
        package: ""
        external: true
        top_signame: mbx1_doe_async_msg_support
        conn_type: false
        index: -1
      }
      {
        name: racl_policies
        desc:
          '''
          Incoming RACL policy vector from a racl_ctrl instance.
          The policy selection vector (parameter) selects the policy for each register.
          '''
        struct: racl_policy_vec
        package: top_racl_pkg
        type: uni
        act: rcv
        width: 1
        inst_name: mbx1
        default: ""
        top_signame: racl_ctrl_racl_policies
        index: -1
      }
      {
        name: racl_error
        desc: RACL error log information of this module.
        struct: racl_error_log
        package: top_racl_pkg
        type: uni
        act: req
        width: 1
        inst_name: mbx1
        default: ""
        top_signame: racl_ctrl_racl_error
        index: 1
      }
      {
        name: sram_tl_h
        struct: tl
        package: tlul_pkg
        type: req_rsp
        act: req
        width: 1
        inst_name: mbx1
        default: ""
        top_signame: main_tl_mbx1__sram
        index: -1
      }
      {
        name: core_tl_d
        struct: tl
        package: tlul_pkg
        type: req_rsp
        act: rsp
        width: 1
        inst_name: mbx1
        default: ""
        end_idx: -1
        top_signame: mbx1_core_tl_d
        index: -1
      }
      {
        name: soc_tl_d
        struct: tl
        package: tlul_pkg
        type: req_rsp
        act: rsp
        width: 1
        inst_name: mbx1
        default: ""
        end_idx: -1
        top_signame: mbx1_soc_tl_d
        index: -1
      }
      {
        name: doe_intr_support
        struct: logic
        type: uni
        act: req
        width: 1
        default: 1'b0
        inst_name: mbx2
        package: ""
        external: true
        top_signame: mbx2_doe_intr_support
        conn_type: false
        index: -1
      }
      {
        name: doe_intr_en
        struct: logic
        type: uni
        act: req
        width: 1
        default: 1'b0
        inst_name: mbx2
        package: ""
        external: true
        top_signame: mbx2_doe_intr_en
        conn_type: false
        index: -1
      }
      {
        name: doe_intr
        struct: logic
        type: uni
        act: req
        width: 1
        default: 1'b0
        inst_name: mbx2
        package: ""
        external: true
        top_signame: mbx2_doe_intr
        conn_type: false
        index: -1
      }
      {
        name: doe_async_msg_support
        struct: logic
        type: uni
        act: req
        width: 1
        default: 1'b0
        inst_name: mbx2
        package: ""
        external: true
        top_signame: mbx2_doe_async_msg_support
        conn_type: false
        index: -1
      }
      {
        name: racl_policies
        desc:
          '''
          Incoming RACL policy vector from a racl_ctrl instance.
          The policy selection vector (parameter) selects the policy for each register.
          '''
        struct: racl_policy_vec
        package: top_racl_pkg
        type: uni
        act: rcv
        width: 1
        inst_name: mbx2
        default: ""
        top_signame: racl_ctrl_racl_policies
        index: -1
      }
      {
        name: racl_error
        desc: RACL error log information of this module.
        struct: racl_error_log
        package: top_racl_pkg
        type: uni
        act: req
        width: 1
        inst_name: mbx2
        default: ""
        top_signame: racl_ctrl_racl_error
        index: 2
      }
      {
        name: sram_tl_h
        struct: tl
        package: tlul_pkg
        type: req_rsp
        act: req
        width: 1
        inst_name: mbx2
        default: ""
        top_signame: main_tl_mbx2__sram
        index: -1
      }
      {
        name: core_tl_d
        struct: tl
        package: tlul_pkg
        type: req_rsp
        act: rsp
        width: 1
        inst_name: mbx2
        default: ""
        end_idx: -1
        top_signame: mbx2_core_tl_d
        index: -1
      }
      {
        name: soc_tl_d
        struct: tl
        package: tlul_pkg
        type: req_rsp
        act: rsp
        width: 1
        inst_name: mbx2
        default: ""
        end_idx: -1
        top_signame: mbx2_soc_tl_d
        index: -1
      }
      {
        name: doe_intr_support
        struct: logic
        type: uni
        act: req
        width: 1
        default: 1'b0
        inst_name: mbx3
        package: ""
        external: true
        top_signame: mbx3_doe_intr_support
        conn_type: false
        index: -1
      }
      {
        name: doe_intr_en
        struct: logic
        type: uni
        act: req
        width: 1
        default: 1'b0
        inst_name: mbx3
        package: ""
        external: true
        top_signame: mbx3_doe_intr_en
        conn_type: false
        index: -1
      }
      {
        name: doe_intr
        struct: logic
        type: uni
        act: req
        width: 1
        default: 1'b0
        inst_name: mbx3
        package: ""
        external: true
        top_signame: mbx3_doe_intr
        conn_type: false
        index: -1
      }
      {
        name: doe_async_msg_support
        struct: logic
        type: uni
        act: req
        width: 1
        default: 1'b0
        inst_name: mbx3
        package: ""
        external: true
        top_signame: mbx3_doe_async_msg_support
        conn_type: false
        index: -1
      }
      {
        name: racl_policies
        desc:
          '''
          Incoming RACL policy vector from a racl_ctrl instance.
          The policy selection vector (parameter) selects the policy for each register.
          '''
        struct: racl_policy_vec
        package: top_racl_pkg
        type: uni
        act: rcv
        width: 1
        inst_name: mbx3
        default: ""
        top_signame: racl_ctrl_racl_policies
        index: -1
      }
      {
        name: racl_error
        desc: RACL error log information of this module.
        struct: racl_error_log
        package: top_racl_pkg
        type: uni
        act: req
        width: 1
        inst_name: mbx3
        default: ""
        top_signame: racl_ctrl_racl_error
        index: 3
      }
      {
        name: sram_tl_h
        struct: tl
        package: tlul_pkg
        type: req_rsp
        act: req
        width: 1
        inst_name: mbx3
        default: ""
        top_signame: main_tl_mbx3__sram
        index: -1
      }
      {
        name: core_tl_d
        struct: tl
        package: tlul_pkg
        type: req_rsp
        act: rsp
        width: 1
        inst_name: mbx3
        default: ""
        end_idx: -1
        top_signame: mbx3_core_tl_d
        index: -1
      }
      {
        name: soc_tl_d
        struct: tl
        package: tlul_pkg
        type: req_rsp
        act: rsp
        width: 1
        inst_name: mbx3
        default: ""
        end_idx: -1
        top_signame: mbx3_soc_tl_d
        index: -1
      }
      {
        name: doe_intr_support
        struct: logic
        type: uni
        act: req
        width: 1
        default: 1'b0
        inst_name: mbx4
        package: ""
        external: true
        top_signame: mbx4_doe_intr_support
        conn_type: false
        index: -1
      }
      {
        name: doe_intr_en
        struct: logic
        type: uni
        act: req
        width: 1
        default: 1'b0
        inst_name: mbx4
        package: ""
        external: true
        top_signame: mbx4_doe_intr_en
        conn_type: false
        index: -1
      }
      {
        name: doe_intr
        struct: logic
        type: uni
        act: req
        width: 1
        default: 1'b0
        inst_name: mbx4
        package: ""
        external: true
        top_signame: mbx4_doe_intr
        conn_type: false
        index: -1
      }
      {
        name: doe_async_msg_support
        struct: logic
        type: uni
        act: req
        width: 1
        default: 1'b0
        inst_name: mbx4
        package: ""
        external: true
        top_signame: mbx4_doe_async_msg_support
        conn_type: false
        index: -1
      }
      {
        name: racl_policies
        desc:
          '''
          Incoming RACL policy vector from a racl_ctrl instance.
          The policy selection vector (parameter) selects the policy for each register.
          '''
        struct: racl_policy_vec
        package: top_racl_pkg
        type: uni
        act: rcv
        width: 1
        inst_name: mbx4
        default: ""
        top_signame: racl_ctrl_racl_policies
        index: -1
      }
      {
        name: racl_error
        desc: RACL error log information of this module.
        struct: racl_error_log
        package: top_racl_pkg
        type: uni
        act: req
        width: 1
        inst_name: mbx4
        default: ""
        top_signame: racl_ctrl_racl_error
        index: 4
      }
      {
        name: sram_tl_h
        struct: tl
        package: tlul_pkg
        type: req_rsp
        act: req
        width: 1
        inst_name: mbx4
        default: ""
        top_signame: main_tl_mbx4__sram
        index: -1
      }
      {
        name: core_tl_d
        struct: tl
        package: tlul_pkg
        type: req_rsp
        act: rsp
        width: 1
        inst_name: mbx4
        default: ""
        end_idx: -1
        top_signame: mbx4_core_tl_d
        index: -1
      }
      {
        name: soc_tl_d
        struct: tl
        package: tlul_pkg
        type: req_rsp
        act: rsp
        width: 1
        inst_name: mbx4
        default: ""
        end_idx: -1
        top_signame: mbx4_soc_tl_d
        index: -1
      }
      {
        name: doe_intr_support
        struct: logic
        type: uni
        act: req
        width: 1
        default: 1'b0
        inst_name: mbx5
        package: ""
        external: true
        top_signame: mbx5_doe_intr_support
        conn_type: false
        index: -1
      }
      {
        name: doe_intr_en
        struct: logic
        type: uni
        act: req
        width: 1
        default: 1'b0
        inst_name: mbx5
        package: ""
        external: true
        top_signame: mbx5_doe_intr_en
        conn_type: false
        index: -1
      }
      {
        name: doe_intr
        struct: logic
        type: uni
        act: req
        width: 1
        default: 1'b0
        inst_name: mbx5
        package: ""
        external: true
        top_signame: mbx5_doe_intr
        conn_type: false
        index: -1
      }
      {
        name: doe_async_msg_support
        struct: logic
        type: uni
        act: req
        width: 1
        default: 1'b0
        inst_name: mbx5
        package: ""
        external: true
        top_signame: mbx5_doe_async_msg_support
        conn_type: false
        index: -1
      }
      {
        name: racl_policies
        desc:
          '''
          Incoming RACL policy vector from a racl_ctrl instance.
          The policy selection vector (parameter) selects the policy for each register.
          '''
        struct: racl_policy_vec
        package: top_racl_pkg
        type: uni
        act: rcv
        width: 1
        inst_name: mbx5
        default: ""
        top_signame: racl_ctrl_racl_policies
        index: -1
      }
      {
        name: racl_error
        desc: RACL error log information of this module.
        struct: racl_error_log
        package: top_racl_pkg
        type: uni
        act: req
        width: 1
        inst_name: mbx5
        default: ""
        top_signame: racl_ctrl_racl_error
        index: 5
      }
      {
        name: sram_tl_h
        struct: tl
        package: tlul_pkg
        type: req_rsp
        act: req
        width: 1
        inst_name: mbx5
        default: ""
        top_signame: main_tl_mbx5__sram
        index: -1
      }
      {
        name: core_tl_d
        struct: tl
        package: tlul_pkg
        type: req_rsp
        act: rsp
        width: 1
        inst_name: mbx5
        default: ""
        end_idx: -1
        top_signame: mbx5_core_tl_d
        index: -1
      }
      {
        name: soc_tl_d
        struct: tl
        package: tlul_pkg
        type: req_rsp
        act: rsp
        width: 1
        inst_name: mbx5
        default: ""
        end_idx: -1
        top_signame: mbx5_soc_tl_d
        index: -1
      }
      {
        name: doe_intr_support
        struct: logic
        type: uni
        act: req
        width: 1
        default: 1'b0
        inst_name: mbx6
        package: ""
        external: true
        top_signame: mbx6_doe_intr_support
        conn_type: false
        index: -1
      }
      {
        name: doe_intr_en
        struct: logic
        type: uni
        act: req
        width: 1
        default: 1'b0
        inst_name: mbx6
        package: ""
        external: true
        top_signame: mbx6_doe_intr_en
        conn_type: false
        index: -1
      }
      {
        name: doe_intr
        struct: logic
        type: uni
        act: req
        width: 1
        default: 1'b0
        inst_name: mbx6
        package: ""
        external: true
        top_signame: mbx6_doe_intr
        conn_type: false
        index: -1
      }
      {
        name: doe_async_msg_support
        struct: logic
        type: uni
        act: req
        width: 1
        default: 1'b0
        inst_name: mbx6
        package: ""
        external: true
        top_signame: mbx6_doe_async_msg_support
        conn_type: false
        index: -1
      }
      {
        name: racl_policies
        desc:
          '''
          Incoming RACL policy vector from a racl_ctrl instance.
          The policy selection vector (parameter) selects the policy for each register.
          '''
        struct: racl_policy_vec
        package: top_racl_pkg
        type: uni
        act: rcv
        width: 1
        inst_name: mbx6
        default: ""
        top_signame: racl_ctrl_racl_policies
        index: -1
      }
      {
        name: racl_error
        desc: RACL error log information of this module.
        struct: racl_error_log
        package: top_racl_pkg
        type: uni
        act: req
        width: 1
        inst_name: mbx6
        default: ""
        top_signame: racl_ctrl_racl_error
        index: 6
      }
      {
        name: sram_tl_h
        struct: tl
        package: tlul_pkg
        type: req_rsp
        act: req
        width: 1
        inst_name: mbx6
        default: ""
        top_signame: main_tl_mbx6__sram
        index: -1
      }
      {
        name: core_tl_d
        struct: tl
        package: tlul_pkg
        type: req_rsp
        act: rsp
        width: 1
        inst_name: mbx6
        default: ""
        end_idx: -1
        top_signame: mbx6_core_tl_d
        index: -1
      }
      {
        name: soc_tl_d
        struct: tl
        package: tlul_pkg
        type: req_rsp
        act: rsp
        width: 1
        inst_name: mbx6
        default: ""
        end_idx: -1
        top_signame: mbx6_soc_tl_d
        index: -1
      }
      {
        name: doe_intr_support
        struct: logic
        type: uni
        act: req
        width: 1
        default: 1'b0
        inst_name: mbx_jtag
        package: ""
        external: true
        top_signame: mbx_jtag_doe_intr_support
        conn_type: false
        index: -1
      }
      {
        name: doe_intr_en
        struct: logic
        type: uni
        act: req
        width: 1
        default: 1'b0
        inst_name: mbx_jtag
        package: ""
        external: true
        top_signame: mbx_jtag_doe_intr_en
        conn_type: false
        index: -1
      }
      {
        name: doe_intr
        struct: logic
        type: uni
        act: req
        width: 1
        default: 1'b0
        inst_name: mbx_jtag
        package: ""
        external: true
        top_signame: mbx_jtag_doe_intr
        conn_type: false
        index: -1
      }
      {
        name: doe_async_msg_support
        struct: logic
        type: uni
        act: req
        width: 1
        default: 1'b0
        inst_name: mbx_jtag
        package: ""
        external: true
        top_signame: mbx_jtag_doe_async_msg_support
        conn_type: false
        index: -1
      }
      {
        name: racl_policies
        desc:
          '''
          Incoming RACL policy vector from a racl_ctrl instance.
          The policy selection vector (parameter) selects the policy for each register.
          '''
        struct: racl_policy_vec
        package: top_racl_pkg
        type: uni
        act: rcv
        width: 1
        inst_name: mbx_jtag
        default: ""
        top_signame: racl_ctrl_racl_policies
        index: -1
      }
      {
        name: racl_error
        desc: RACL error log information of this module.
        struct: racl_error_log
        package: top_racl_pkg
        type: uni
        act: req
        width: 1
        inst_name: mbx_jtag
        default: ""
        top_signame: racl_ctrl_racl_error
        index: 7
      }
      {
        name: sram_tl_h
        struct: tl
        package: tlul_pkg
        type: req_rsp
        act: req
        width: 1
        inst_name: mbx_jtag
        default: ""
        top_signame: main_tl_mbx_jtag__sram
        index: -1
      }
      {
        name: core_tl_d
        struct: tl
        package: tlul_pkg
        type: req_rsp
        act: rsp
        width: 1
        inst_name: mbx_jtag
        default: ""
        end_idx: -1
        top_signame: mbx_jtag_core_tl_d
        index: -1
      }
      {
        name: soc_tl_d
        struct: tl
        package: tlul_pkg
        type: req_rsp
        act: rsp
        width: 1
        inst_name: mbx_jtag
        default: ""
        end_idx: -1
        top_signame: mbx_jtag_soc_tl_d
        index: -1
      }
      {
        name: doe_intr_support
        struct: logic
        type: uni
        act: req
        width: 1
        default: 1'b0
        inst_name: mbx_pcie0
        package: ""
        external: true
        top_signame: mbx_pcie0_doe_intr_support
        conn_type: false
        index: -1
      }
      {
        name: doe_intr_en
        struct: logic
        type: uni
        act: req
        width: 1
        default: 1'b0
        inst_name: mbx_pcie0
        package: ""
        external: true
        top_signame: mbx_pcie0_doe_intr_en
        conn_type: false
        index: -1
      }
      {
        name: doe_intr
        struct: logic
        type: uni
        act: req
        width: 1
        default: 1'b0
        inst_name: mbx_pcie0
        package: ""
        external: true
        top_signame: mbx_pcie0_doe_intr
        conn_type: false
        index: -1
      }
      {
        name: doe_async_msg_support
        struct: logic
        type: uni
        act: req
        width: 1
        default: 1'b0
        inst_name: mbx_pcie0
        package: ""
        external: true
        top_signame: mbx_pcie0_doe_async_msg_support
        conn_type: false
        index: -1
      }
      {
        name: racl_policies
        desc:
          '''
          Incoming RACL policy vector from a racl_ctrl instance.
          The policy selection vector (parameter) selects the policy for each register.
          '''
        struct: racl_policy_vec
        package: top_racl_pkg
        type: uni
        act: rcv
        width: 1
        inst_name: mbx_pcie0
        default: ""
        top_signame: racl_ctrl_racl_policies
        index: -1
      }
      {
        name: racl_error
        desc: RACL error log information of this module.
        struct: racl_error_log
        package: top_racl_pkg
        type: uni
        act: req
        width: 1
        inst_name: mbx_pcie0
        default: ""
        top_signame: racl_ctrl_racl_error
        index: 8
      }
      {
        name: sram_tl_h
        struct: tl
        package: tlul_pkg
        type: req_rsp
        act: req
        width: 1
        inst_name: mbx_pcie0
        default: ""
        top_signame: main_tl_mbx_pcie0__sram
        index: -1
      }
      {
        name: core_tl_d
        struct: tl
        package: tlul_pkg
        type: req_rsp
        act: rsp
        width: 1
        inst_name: mbx_pcie0
        default: ""
        end_idx: -1
        top_signame: mbx_pcie0_core_tl_d
        index: -1
      }
      {
        name: soc_tl_d
        struct: tl
        package: tlul_pkg
        type: req_rsp
        act: rsp
        width: 1
        inst_name: mbx_pcie0
        default: ""
        end_idx: -1
        top_signame: mbx_pcie0_soc_tl_d
        index: -1
      }
      {
        name: doe_intr_support
        struct: logic
        type: uni
        act: req
        width: 1
        default: 1'b0
        inst_name: mbx_pcie1
        package: ""
        external: true
        top_signame: mbx_pcie1_doe_intr_support
        conn_type: false
        index: -1
      }
      {
        name: doe_intr_en
        struct: logic
        type: uni
        act: req
        width: 1
        default: 1'b0
        inst_name: mbx_pcie1
        package: ""
        external: true
        top_signame: mbx_pcie1_doe_intr_en
        conn_type: false
        index: -1
      }
      {
        name: doe_intr
        struct: logic
        type: uni
        act: req
        width: 1
        default: 1'b0
        inst_name: mbx_pcie1
        package: ""
        external: true
        top_signame: mbx_pcie1_doe_intr
        conn_type: false
        index: -1
      }
      {
        name: doe_async_msg_support
        struct: logic
        type: uni
        act: req
        width: 1
        default: 1'b0
        inst_name: mbx_pcie1
        package: ""
        external: true
        top_signame: mbx_pcie1_doe_async_msg_support
        conn_type: false
        index: -1
      }
      {
        name: racl_policies
        desc:
          '''
          Incoming RACL policy vector from a racl_ctrl instance.
          The policy selection vector (parameter) selects the policy for each register.
          '''
        struct: racl_policy_vec
        package: top_racl_pkg
        type: uni
        act: rcv
        width: 1
        inst_name: mbx_pcie1
        default: ""
        top_signame: racl_ctrl_racl_policies
        index: -1
      }
      {
        name: racl_error
        desc: RACL error log information of this module.
        struct: racl_error_log
        package: top_racl_pkg
        type: uni
        act: req
        width: 1
        inst_name: mbx_pcie1
        default: ""
        top_signame: racl_ctrl_racl_error
        index: 9
      }
      {
        name: sram_tl_h
        struct: tl
        package: tlul_pkg
        type: req_rsp
        act: req
        width: 1
        inst_name: mbx_pcie1
        default: ""
        top_signame: main_tl_mbx_pcie1__sram
        index: -1
      }
      {
        name: core_tl_d
        struct: tl
        package: tlul_pkg
        type: req_rsp
        act: rsp
        width: 1
        inst_name: mbx_pcie1
        default: ""
        end_idx: -1
        top_signame: mbx_pcie1_core_tl_d
        index: -1
      }
      {
        name: soc_tl_d
        struct: tl
        package: tlul_pkg
        type: req_rsp
        act: rsp
        width: 1
        inst_name: mbx_pcie1
        default: ""
        end_idx: -1
        top_signame: mbx_pcie1_soc_tl_d
        index: -1
      }
      {
        name: boot_status
        struct: pwr_boot_status
        package: pwrmgr_pkg
        type: uni
        act: rcv
        width: 1
        inst_name: soc_dbg_ctrl
        default: ""
        top_signame: pwrmgr_aon_boot_status
        index: -1
      }
      {
        name: soc_dbg_state
        struct: soc_dbg_state
        package: lc_ctrl_state_pkg
        type: uni
        act: rcv
        width: 1
        inst_name: soc_dbg_ctrl
        default: ""
        top_signame: soc_dbg_ctrl_soc_dbg_state
        index: -1
      }
      {
        name: soc_dbg_policy_bus
        struct: soc_dbg_policy
        package: soc_dbg_ctrl_pkg
        type: uni
        act: req
        width: 1
        inst_name: soc_dbg_ctrl
        default: ""
        external: true
        top_signame: soc_dbg_policy_bus
        conn_type: false
        index: -1
      }
      {
        name: lc_hw_debug_en
        desc: Multibit life cycle hardware debug enable signal coming from life cycle controller, asserted when the hardware debug mechanisms are enabled in the system.
        struct: lc_tx
        package: lc_ctrl_pkg
        type: uni
        act: rcv
        width: 1
        default: lc_ctrl_pkg::Off
        inst_name: soc_dbg_ctrl
        top_signame: lc_ctrl_lc_hw_debug_en
        index: -1
      }
      {
        name: lc_dft_en
        desc:
          '''
          Test enable qualifier coming from life cycle controller.
          This signals enables TEST & RMA mode accesses.
          '''
        struct: lc_tx
        package: lc_ctrl_pkg
        type: uni
        act: rcv
        width: 1
        default: lc_ctrl_pkg::Off
        inst_name: soc_dbg_ctrl
        top_signame: lc_ctrl_lc_dft_en
        index: -1
      }
      {
        name: lc_raw_test_rma
        desc:
          '''
          Test enable qualifier coming from life cycle controller.
          This signals enables RAW, TEST and RMA mode accesses.
          '''
        struct: lc_tx
        package: lc_ctrl_pkg
        type: uni
        act: rcv
        width: 1
        default: lc_ctrl_pkg::Off
        inst_name: soc_dbg_ctrl
        top_signame: lc_ctrl_lc_raw_test_rma
        index: -1
      }
      {
        name: halt_cpu_boot
        desc: External request to halt the CPU until a JTAG command allows the boot process to continue.
        struct: logic
        type: uni
        act: rcv
        width: 1
        inst_name: soc_dbg_ctrl
        default: ""
        package: ""
        external: true
        top_signame: debug_halt_cpu_boot
        conn_type: false
        index: -1
      }
      {
        name: continue_cpu_boot
        desc: Artificial ROM control input to the pwrmgr to halt the boot process.
        struct: pwrmgr_data
        package: rom_ctrl_pkg
        type: uni
        act: req
        width: 1
        inst_name: soc_dbg_ctrl
        default: ""
        top_signame: pwrmgr_aon_rom_ctrl
        index: 2
      }
      {
        name: core_tl
        struct: tl
        package: tlul_pkg
        type: req_rsp
        act: rsp
        width: 1
        inst_name: soc_dbg_ctrl
        default: ""
        end_idx: -1
        top_signame: soc_dbg_ctrl_core_tl
        index: -1
      }
      {
        name: jtag_tl
        struct: tl
        package: tlul_pkg
        type: req_rsp
        act: rsp
        width: 1
        inst_name: soc_dbg_ctrl
        default: ""
        end_idx: -1
        top_signame: soc_dbg_ctrl_jtag_tl
        index: -1
      }
      {
        name: racl_policies
        desc: Policy vector distributed to the subscribing RACL IPs.
        struct: racl_policy_vec
        package: top_racl_pkg
        type: uni
        act: req
        width: 1
        inst_name: racl_ctrl
        default: ""
        end_idx: -1
        top_type: broadcast
        top_signame: racl_ctrl_racl_policies
        index: -1
        external: true
        conn_type: true
      }
      {
        name: racl_error
        desc:
          '''
          Error log information from all IPs.
          Only one IP can raise an error at a time.
          '''
        struct: racl_error_log
        package: top_racl_pkg
        type: uni
        act: rcv
        width:
        {
          name: NumSubscribingIps
          desc: Number of subscribing RACL IPs
          param_type: int
          unpacked_dimensions: null
          default: 11
          local: true
          expose: true
          name_top: RaclCtrlNumSubscribingIps
        }
        inst_name: racl_ctrl
        default: ""
        end_idx: -1
        top_type: one-to-N
        top_signame: racl_ctrl_racl_error
        index: -1
      }
      {
        name: racl_error_external
        desc:
          '''
          Error log information from all external IPs.
          Only one IP can raise an error at a time.
          '''
        struct: racl_error_log
        package: top_racl_pkg
        type: uni
        act: rcv
        width:
        {
          name: NumExternalSubscribingIps
          desc: Number of external subscribing RACL IPs
          param_type: int
          unpacked_dimensions: null
          default: 1
          local: false
          expose: true
          name_top: RaclCtrlNumExternalSubscribingIps
        }
        inst_name: racl_ctrl
        default: ""
        external: true
        top_signame: racl_error
        conn_type: false
        index: -1
      }
      {
        name: tl
        struct: tl
        package: tlul_pkg
        type: req_rsp
        act: rsp
        width: 1
        inst_name: racl_ctrl
        default: ""
        end_idx: -1
        top_signame: racl_ctrl_tl
        index: -1
      }
      {
        name: range_check_overwrite
        desc: Overwrites all ranges and let all requests pass through.
        struct: mubi8
        package: prim_mubi_pkg
        type: uni
        act: rcv
        width: 1
        inst_name: ac_range_check
        default: ""
        external: true
        top_signame: ac_range_check_overwrite
        conn_type: false
        index: -1
      }
      {
        name: ctn_tl_h2d
        desc: TL-UL input port (request part), synchronous
        struct: tl_h2d
        package: tlul_pkg
        type: uni
        act: rcv
        width: 1
        inst_name: ac_range_check
        default: ""
        top_signame: soc_proxy_ctn_tl_h2d
        index: -1
      }
      {
        name: ctn_tl_d2h
        desc: TL-UL input port (response part), synchronous
        struct: tl_d2h
        package: tlul_pkg
        type: uni
        act: req
        width: 1
        inst_name: ac_range_check
        default: ""
        top_signame: soc_proxy_ctn_tl_d2h
        index: -1
      }
      {
        name: ctn_filtered_tl_h2d
        desc: Filtered TL-UL output port (request part), synchronous
        struct: tl_h2d
        package: tlul_pkg
        type: uni
        act: req
        width: 1
        inst_name: ac_range_check
        default: ""
        external: true
        top_signame: ctn_tl_h2d
        conn_type: false
        index: -1
      }
      {
        name: ctn_filtered_tl_d2h
        desc: Filtered TL-UL output port (response part), synchronous
        struct: tl_d2h
        package: tlul_pkg
        type: uni
        act: rcv
        width: 1
        inst_name: ac_range_check
        default: ""
        external: true
        top_signame: ctn_tl_d2h
        conn_type: false
        index: -1
      }
      {
        name: racl_policies
        desc:
          '''
          Incoming RACL policy vector from a racl_ctrl instance.
          The policy selection vector (parameter) selects the policy for each register.
          '''
        struct: racl_policy_vec
        package: top_racl_pkg
        type: uni
        act: rcv
        width: 1
        inst_name: ac_range_check
        default: ""
        top_signame: racl_ctrl_racl_policies
        index: -1
      }
      {
        name: racl_error
        desc: RACL error log information of this module.
        struct: racl_error_log
        package: top_racl_pkg
        type: uni
        act: req
        width: 1
        inst_name: ac_range_check
        default: ""
        top_signame: racl_ctrl_racl_error
        index: 10
      }
      {
        name: tl
        struct: tl
        package: tlul_pkg
        type: req_rsp
        act: rsp
        width: 1
        inst_name: ac_range_check
        default: ""
        end_idx: -1
        top_signame: ac_range_check_tl
        index: -1
      }
      {
        name: rst_cpu_n
        struct: logic
        type: uni
        act: req
        width: 1
        inst_name: rv_core_ibex
        index: -1
      }
      {
        name: ram_cfg_icache_tag
        struct: ram_1p_cfg
        package: prim_ram_1p_pkg
        type: uni
        act: rcv
        width: 1
        inst_name: rv_core_ibex
        default: ""
        external: true
        top_signame: rv_core_ibex_icache_tag_ram_1p_cfg
        conn_type: false
        index: -1
      }
      {
        name: ram_cfg_rsp_icache_tag
        struct: ram_1p_cfg_rsp
        package: prim_ram_1p_pkg
        type: uni
        act: req
        width:
        {
          name: ICacheNWays
          desc: Number of instruction cache ways
          param_type: int unsigned
          unpacked_dimensions: null
          default: 2
          local: false
          expose: true
          name_top: RvCoreIbexICacheNWays
        }
        inst_name: rv_core_ibex
        default: ""
        external: true
        top_signame: rv_core_ibex_icache_tag_ram_1p_cfg_rsp
        conn_type: false
        index: -1
      }
      {
        name: ram_cfg_icache_data
        struct: ram_1p_cfg
        package: prim_ram_1p_pkg
        type: uni
        act: rcv
        width: 1
        inst_name: rv_core_ibex
        default: ""
        external: true
        top_signame: rv_core_ibex_icache_data_ram_1p_cfg
        conn_type: false
        index: -1
      }
      {
        name: ram_cfg_rsp_icache_data
        struct: ram_1p_cfg_rsp
        package: prim_ram_1p_pkg
        type: uni
        act: req
        width:
        {
          name: ICacheNWays
          desc: Number of instruction cache ways
          param_type: int unsigned
          unpacked_dimensions: null
          default: 2
          local: false
          expose: true
          name_top: RvCoreIbexICacheNWays
        }
        inst_name: rv_core_ibex
        default: ""
        external: true
        top_signame: rv_core_ibex_icache_data_ram_1p_cfg_rsp
        conn_type: false
        index: -1
      }
      {
        name: hart_id
        struct: logic
        type: uni
        act: rcv
        width: 32
        inst_name: rv_core_ibex
        default: ""
        package: ""
        top_signame: rv_core_ibex_hart_id
        index: -1
      }
      {
        name: boot_addr
        struct: logic
        type: uni
        act: rcv
        width: 32
        inst_name: rv_core_ibex
        default: ""
        package: ""
        top_signame: rv_core_ibex_boot_addr
        index: -1
      }
      {
        name: irq_software
        struct: logic
        type: uni
        act: rcv
        width: 1
        inst_name: rv_core_ibex
        default: ""
        package: ""
        top_signame: rv_plic_msip
        index: -1
      }
      {
        name: irq_timer
        struct: logic
        type: uni
        act: rcv
        width: 1
        inst_name: rv_core_ibex
        default: ""
        package: ""
        top_signame: rv_core_ibex_irq_timer
        index: -1
      }
      {
        name: irq_external
        struct: logic
        type: uni
        act: rcv
        width: 1
        inst_name: rv_core_ibex
        default: ""
        package: ""
        top_signame: rv_plic_irq
        index: -1
      }
      {
        name: esc_tx
        struct: esc_tx
        package: prim_esc_pkg
        type: uni
        act: rcv
        width: 1
        inst_name: rv_core_ibex
        default: ""
        top_signame: alert_handler_esc_tx
        index: 0
      }
      {
        name: esc_rx
        struct: esc_rx
        package: prim_esc_pkg
        type: uni
        act: req
        width: 1
        inst_name: rv_core_ibex
        default: ""
        top_signame: alert_handler_esc_rx
        index: 0
      }
      {
        name: debug_req
        struct: logic
        type: uni
        act: rcv
        width: 1
        inst_name: rv_core_ibex
        default: ""
        package: ""
        top_signame: rv_dm_debug_req
        index: -1
      }
      {
        name: crash_dump
        struct: cpu_crash_dump
        package: rv_core_ibex_pkg
        type: uni
        act: req
        width: 1
        inst_name: rv_core_ibex
        default: ""
        end_idx: -1
        top_type: broadcast
        top_signame: rv_core_ibex_crash_dump
        index: -1
      }
      {
        name: lc_cpu_en
        struct: lc_tx
        package: lc_ctrl_pkg
        type: uni
        act: rcv
        width: 1
        inst_name: rv_core_ibex
        default: ""
        top_signame: lc_ctrl_lc_cpu_en
        index: -1
      }
      {
        name: pwrmgr_cpu_en
        struct: lc_tx
        package: lc_ctrl_pkg
        type: uni
        act: rcv
        width: 1
        inst_name: rv_core_ibex
        default: ""
        top_signame: pwrmgr_aon_fetch_en
        index: -1
      }
      {
        name: pwrmgr
        struct: cpu_pwrmgr
        package: rv_core_ibex_pkg
        type: uni
        act: req
        width: 1
        inst_name: rv_core_ibex
        default: ""
        end_idx: -1
        top_type: broadcast
        top_signame: rv_core_ibex_pwrmgr
        index: -1
      }
      {
        name: nmi_wdog
        struct: logic
        type: uni
        act: rcv
        width: 1
        inst_name: rv_core_ibex
        default: ""
        package: ""
        top_signame: aon_timer_aon_nmi_wdog_timer_bark
        index: -1
      }
      {
        name: edn
        struct: edn
        package: edn_pkg
        type: req_rsp
        act: req
        width: 1
        inst_name: rv_core_ibex
        default: ""
        top_signame: edn0_edn
        index: 7
      }
      {
        name: icache_otp_key
        struct: sram_otp_key
        package: otp_ctrl_pkg
        type: req_rsp
        act: req
        width: 1
        inst_name: rv_core_ibex
        default: ""
        top_signame: otp_ctrl_sram_otp_key
        index: 3
      }
      {
        name: fpga_info
        struct: logic
        type: uni
        act: rcv
        width: 32
        inst_name: rv_core_ibex
        default: ""
        package: ""
        external: true
        top_signame: fpga_info
        conn_type: false
        index: -1
      }
      {
        name: corei_tl_h
        struct: tl
        package: tlul_pkg
        type: req_rsp
        act: req
        width: 1
        inst_name: rv_core_ibex
        default: ""
        top_signame: main_tl_rv_core_ibex__corei
        index: -1
      }
      {
        name: cored_tl_h
        struct: tl
        package: tlul_pkg
        type: req_rsp
        act: req
        width: 1
        inst_name: rv_core_ibex
        default: ""
        top_signame: main_tl_rv_core_ibex__cored
        index: -1
      }
      {
        name: cfg_tl_d
        struct: tl
        package: tlul_pkg
        type: req_rsp
        act: rsp
        width: 1
        inst_name: rv_core_ibex
        default: ""
        end_idx: -1
        top_signame: rv_core_ibex_cfg_tl_d
        index: -1
      }
      {
        name: tl_rv_core_ibex__corei
        struct: tl
        package: tlul_pkg
        type: req_rsp
        act: rsp
        inst_name: main
        width: 1
        default: ""
        end_idx: -1
        top_signame: main_tl_rv_core_ibex__corei
        index: -1
      }
      {
        name: tl_rv_core_ibex__cored
        struct: tl
        package: tlul_pkg
        type: req_rsp
        act: rsp
        inst_name: main
        width: 1
        default: ""
        end_idx: -1
        top_signame: main_tl_rv_core_ibex__cored
        index: -1
      }
      {
        name: tl_rv_dm__sba
        struct: tl
        package: tlul_pkg
        type: req_rsp
        act: rsp
        inst_name: main
        width: 1
        default: ""
        end_idx: -1
        top_signame: main_tl_rv_dm__sba
        index: -1
      }
      {
        name: tl_dma__host
        struct: tl
        package: tlul_pkg
        type: req_rsp
        act: rsp
        inst_name: main
        width: 1
        default: ""
        end_idx: -1
        top_signame: main_tl_dma__host
        index: -1
      }
      {
        name: tl_mbx0__sram
        struct: tl
        package: tlul_pkg
        type: req_rsp
        act: rsp
        inst_name: main
        width: 1
        default: ""
        end_idx: -1
        top_signame: main_tl_mbx0__sram
        index: -1
      }
      {
        name: tl_mbx1__sram
        struct: tl
        package: tlul_pkg
        type: req_rsp
        act: rsp
        inst_name: main
        width: 1
        default: ""
        end_idx: -1
        top_signame: main_tl_mbx1__sram
        index: -1
      }
      {
        name: tl_mbx2__sram
        struct: tl
        package: tlul_pkg
        type: req_rsp
        act: rsp
        inst_name: main
        width: 1
        default: ""
        end_idx: -1
        top_signame: main_tl_mbx2__sram
        index: -1
      }
      {
        name: tl_mbx3__sram
        struct: tl
        package: tlul_pkg
        type: req_rsp
        act: rsp
        inst_name: main
        width: 1
        default: ""
        end_idx: -1
        top_signame: main_tl_mbx3__sram
        index: -1
      }
      {
        name: tl_mbx4__sram
        struct: tl
        package: tlul_pkg
        type: req_rsp
        act: rsp
        inst_name: main
        width: 1
        default: ""
        end_idx: -1
        top_signame: main_tl_mbx4__sram
        index: -1
      }
      {
        name: tl_mbx5__sram
        struct: tl
        package: tlul_pkg
        type: req_rsp
        act: rsp
        inst_name: main
        width: 1
        default: ""
        end_idx: -1
        top_signame: main_tl_mbx5__sram
        index: -1
      }
      {
        name: tl_mbx6__sram
        struct: tl
        package: tlul_pkg
        type: req_rsp
        act: rsp
        inst_name: main
        width: 1
        default: ""
        end_idx: -1
        top_signame: main_tl_mbx6__sram
        index: -1
      }
      {
        name: tl_mbx_jtag__sram
        struct: tl
        package: tlul_pkg
        type: req_rsp
        act: rsp
        inst_name: main
        width: 1
        default: ""
        end_idx: -1
        top_signame: main_tl_mbx_jtag__sram
        index: -1
      }
      {
        name: tl_mbx_pcie0__sram
        struct: tl
        package: tlul_pkg
        type: req_rsp
        act: rsp
        inst_name: main
        width: 1
        default: ""
        end_idx: -1
        top_signame: main_tl_mbx_pcie0__sram
        index: -1
      }
      {
        name: tl_mbx_pcie1__sram
        struct: tl
        package: tlul_pkg
        type: req_rsp
        act: rsp
        inst_name: main
        width: 1
        default: ""
        end_idx: -1
        top_signame: main_tl_mbx_pcie1__sram
        index: -1
      }
      {
        name: tl_rv_dm__regs
        struct: tl
        package: tlul_pkg
        type: req_rsp
        act: req
        inst_name: main
        width: 1
        default: ""
        top_signame: rv_dm_regs_tl_d
        index: -1
      }
      {
        name: tl_rv_dm__mem
        struct: tl
        package: tlul_pkg
        type: req_rsp
        act: req
        inst_name: main
        width: 1
        default: ""
        top_signame: rv_dm_mem_tl_d
        index: -1
      }
      {
        name: tl_rom_ctrl0__rom
        struct: tl
        package: tlul_pkg
        type: req_rsp
        act: req
        inst_name: main
        width: 1
        default: ""
        top_signame: rom_ctrl0_rom_tl
        index: -1
      }
      {
        name: tl_rom_ctrl0__regs
        struct: tl
        package: tlul_pkg
        type: req_rsp
        act: req
        inst_name: main
        width: 1
        default: ""
        top_signame: rom_ctrl0_regs_tl
        index: -1
      }
      {
        name: tl_rom_ctrl1__rom
        struct: tl
        package: tlul_pkg
        type: req_rsp
        act: req
        inst_name: main
        width: 1
        default: ""
        top_signame: rom_ctrl1_rom_tl
        index: -1
      }
      {
        name: tl_rom_ctrl1__regs
        struct: tl
        package: tlul_pkg
        type: req_rsp
        act: req
        inst_name: main
        width: 1
        default: ""
        top_signame: rom_ctrl1_regs_tl
        index: -1
      }
      {
        name: tl_peri
        struct: tl
        package: tlul_pkg
        type: req_rsp
        act: req
        inst_name: main
        width: 1
        default: ""
        end_idx: -1
        top_signame: main_tl_peri
        index: -1
      }
      {
        name: tl_soc_proxy__core
        struct: tl
        package: tlul_pkg
        type: req_rsp
        act: req
        inst_name: main
        width: 1
        default: ""
        top_signame: soc_proxy_core_tl
        index: -1
      }
      {
        name: tl_soc_proxy__ctn
        struct: tl
        package: tlul_pkg
        type: req_rsp
        act: req
        inst_name: main
        width: 1
        default: ""
        top_signame: soc_proxy_ctn_tl
        index: -1
      }
      {
        name: tl_hmac
        struct: tl
        package: tlul_pkg
        type: req_rsp
        act: req
        inst_name: main
        width: 1
        default: ""
        top_signame: hmac_tl
        index: -1
      }
      {
        name: tl_kmac
        struct: tl
        package: tlul_pkg
        type: req_rsp
        act: req
        inst_name: main
        width: 1
        default: ""
        top_signame: kmac_tl
        index: -1
      }
      {
        name: tl_aes
        struct: tl
        package: tlul_pkg
        type: req_rsp
        act: req
        inst_name: main
        width: 1
        default: ""
        top_signame: aes_tl
        index: -1
      }
      {
        name: tl_csrng
        struct: tl
        package: tlul_pkg
        type: req_rsp
        act: req
        inst_name: main
        width: 1
        default: ""
        top_signame: csrng_tl
        index: -1
      }
      {
        name: tl_edn0
        struct: tl
        package: tlul_pkg
        type: req_rsp
        act: req
        inst_name: main
        width: 1
        default: ""
        top_signame: edn0_tl
        index: -1
      }
      {
        name: tl_edn1
        struct: tl
        package: tlul_pkg
        type: req_rsp
        act: req
        inst_name: main
        width: 1
        default: ""
        top_signame: edn1_tl
        index: -1
      }
      {
        name: tl_rv_plic
        struct: tl
        package: tlul_pkg
        type: req_rsp
        act: req
        inst_name: main
        width: 1
        default: ""
        top_signame: rv_plic_tl
        index: -1
      }
      {
        name: tl_otbn
        struct: tl
        package: tlul_pkg
        type: req_rsp
        act: req
        inst_name: main
        width: 1
        default: ""
        top_signame: otbn_tl
        index: -1
      }
      {
        name: tl_keymgr_dpe
        struct: tl
        package: tlul_pkg
        type: req_rsp
        act: req
        inst_name: main
        width: 1
        default: ""
        top_signame: keymgr_dpe_tl
        index: -1
      }
      {
        name: tl_rv_core_ibex__cfg
        struct: tl
        package: tlul_pkg
        type: req_rsp
        act: req
        inst_name: main
        width: 1
        default: ""
        top_signame: rv_core_ibex_cfg_tl_d
        index: -1
      }
      {
        name: tl_sram_ctrl_main__regs
        struct: tl
        package: tlul_pkg
        type: req_rsp
        act: req
        inst_name: main
        width: 1
        default: ""
        top_signame: sram_ctrl_main_regs_tl
        index: -1
      }
      {
        name: tl_sram_ctrl_main__ram
        struct: tl
        package: tlul_pkg
        type: req_rsp
        act: req
        inst_name: main
        width: 1
        default: ""
        top_signame: sram_ctrl_main_ram_tl
        index: -1
      }
      {
        name: tl_sram_ctrl_mbox__regs
        struct: tl
        package: tlul_pkg
        type: req_rsp
        act: req
        inst_name: main
        width: 1
        default: ""
        top_signame: sram_ctrl_mbox_regs_tl
        index: -1
      }
      {
        name: tl_sram_ctrl_mbox__ram
        struct: tl
        package: tlul_pkg
        type: req_rsp
        act: req
        inst_name: main
        width: 1
        default: ""
        top_signame: sram_ctrl_mbox_ram_tl
        index: -1
      }
      {
        name: tl_dma
        struct: tl
        package: tlul_pkg
        type: req_rsp
        act: req
        inst_name: main
        width: 1
        default: ""
        top_signame: dma_tl_d
        index: -1
      }
      {
        name: tl_mbx0__core
        struct: tl
        package: tlul_pkg
        type: req_rsp
        act: req
        inst_name: main
        width: 1
        default: ""
        top_signame: mbx0_core_tl_d
        index: -1
      }
      {
        name: tl_mbx1__core
        struct: tl
        package: tlul_pkg
        type: req_rsp
        act: req
        inst_name: main
        width: 1
        default: ""
        top_signame: mbx1_core_tl_d
        index: -1
      }
      {
        name: tl_mbx2__core
        struct: tl
        package: tlul_pkg
        type: req_rsp
        act: req
        inst_name: main
        width: 1
        default: ""
        top_signame: mbx2_core_tl_d
        index: -1
      }
      {
        name: tl_mbx3__core
        struct: tl
        package: tlul_pkg
        type: req_rsp
        act: req
        inst_name: main
        width: 1
        default: ""
        top_signame: mbx3_core_tl_d
        index: -1
      }
      {
        name: tl_mbx4__core
        struct: tl
        package: tlul_pkg
        type: req_rsp
        act: req
        inst_name: main
        width: 1
        default: ""
        top_signame: mbx4_core_tl_d
        index: -1
      }
      {
        name: tl_mbx5__core
        struct: tl
        package: tlul_pkg
        type: req_rsp
        act: req
        inst_name: main
        width: 1
        default: ""
        top_signame: mbx5_core_tl_d
        index: -1
      }
      {
        name: tl_mbx6__core
        struct: tl
        package: tlul_pkg
        type: req_rsp
        act: req
        inst_name: main
        width: 1
        default: ""
        top_signame: mbx6_core_tl_d
        index: -1
      }
      {
        name: tl_mbx_jtag__core
        struct: tl
        package: tlul_pkg
        type: req_rsp
        act: req
        inst_name: main
        width: 1
        default: ""
        top_signame: mbx_jtag_core_tl_d
        index: -1
      }
      {
        name: tl_mbx_pcie0__core
        struct: tl
        package: tlul_pkg
        type: req_rsp
        act: req
        inst_name: main
        width: 1
        default: ""
        top_signame: mbx_pcie0_core_tl_d
        index: -1
      }
      {
        name: tl_mbx_pcie1__core
        struct: tl
        package: tlul_pkg
        type: req_rsp
        act: req
        inst_name: main
        width: 1
        default: ""
        top_signame: mbx_pcie1_core_tl_d
        index: -1
      }
      {
        name: tl_main
        struct: tl
        package: tlul_pkg
        type: req_rsp
        act: rsp
        inst_name: peri
        width: 1
        default: ""
        top_signame: main_tl_peri
        index: -1
      }
      {
        name: tl_uart0
        struct: tl
        package: tlul_pkg
        type: req_rsp
        act: req
        inst_name: peri
        width: 1
        default: ""
        top_signame: uart0_tl
        index: -1
      }
      {
        name: tl_i2c0
        struct: tl
        package: tlul_pkg
        type: req_rsp
        act: req
        inst_name: peri
        width: 1
        default: ""
        top_signame: i2c0_tl
        index: -1
      }
      {
        name: tl_gpio
        struct: tl
        package: tlul_pkg
        type: req_rsp
        act: req
        inst_name: peri
        width: 1
        default: ""
        top_signame: gpio_tl
        index: -1
      }
      {
        name: tl_spi_host0
        struct: tl
        package: tlul_pkg
        type: req_rsp
        act: req
        inst_name: peri
        width: 1
        default: ""
        top_signame: spi_host0_tl
        index: -1
      }
      {
        name: tl_spi_device
        struct: tl
        package: tlul_pkg
        type: req_rsp
        act: req
        inst_name: peri
        width: 1
        default: ""
        top_signame: spi_device_tl
        index: -1
      }
      {
        name: tl_rv_timer
        struct: tl
        package: tlul_pkg
        type: req_rsp
        act: req
        inst_name: peri
        width: 1
        default: ""
        top_signame: rv_timer_tl
        index: -1
      }
      {
        name: tl_pwrmgr_aon
        struct: tl
        package: tlul_pkg
        type: req_rsp
        act: req
        inst_name: peri
        width: 1
        default: ""
        top_signame: pwrmgr_aon_tl
        index: -1
      }
      {
        name: tl_rstmgr_aon
        struct: tl
        package: tlul_pkg
        type: req_rsp
        act: req
        inst_name: peri
        width: 1
        default: ""
        top_signame: rstmgr_aon_tl
        index: -1
      }
      {
        name: tl_clkmgr_aon
        struct: tl
        package: tlul_pkg
        type: req_rsp
        act: req
        inst_name: peri
        width: 1
        default: ""
        top_signame: clkmgr_aon_tl
        index: -1
      }
      {
        name: tl_pinmux_aon
        struct: tl
        package: tlul_pkg
        type: req_rsp
        act: req
        inst_name: peri
        width: 1
        default: ""
        top_signame: pinmux_aon_tl
        index: -1
      }
      {
        name: tl_otp_ctrl__core
        struct: tl
        package: tlul_pkg
        type: req_rsp
        act: req
        inst_name: peri
        width: 1
        default: ""
        top_signame: otp_ctrl_core_tl
        index: -1
      }
      {
        name: tl_otp_macro
        struct: tl
        package: tlul_pkg
        type: req_rsp
        act: req
        inst_name: peri
        width: 1
        default: ""
        top_signame: otp_macro_tl
        index: -1
      }
      {
        name: tl_lc_ctrl__regs
        struct: tl
        package: tlul_pkg
        type: req_rsp
        act: req
        inst_name: peri
        width: 1
        default: ""
        top_signame: lc_ctrl_regs_tl
        index: -1
      }
      {
        name: tl_alert_handler
        struct: tl
        package: tlul_pkg
        type: req_rsp
        act: req
        inst_name: peri
        width: 1
        default: ""
        top_signame: alert_handler_tl
        index: -1
      }
      {
        name: tl_sram_ctrl_ret_aon__regs
        struct: tl
        package: tlul_pkg
        type: req_rsp
        act: req
        inst_name: peri
        width: 1
        default: ""
        top_signame: sram_ctrl_ret_aon_regs_tl
        index: -1
      }
      {
        name: tl_sram_ctrl_ret_aon__ram
        struct: tl
        package: tlul_pkg
        type: req_rsp
        act: req
        inst_name: peri
        width: 1
        default: ""
        top_signame: sram_ctrl_ret_aon_ram_tl
        index: -1
      }
      {
        name: tl_aon_timer_aon
        struct: tl
        package: tlul_pkg
        type: req_rsp
        act: req
        inst_name: peri
        width: 1
        default: ""
        top_signame: aon_timer_aon_tl
        index: -1
      }
      {
        name: tl_ast
        struct: tl
        package: tlul_pkg
        type: req_rsp
        act: req
        inst_name: peri
        width: 1
        default: ""
        external: true
        top_signame: ast_tl
        conn_type: false
        index: -1
      }
      {
        name: tl_soc_dbg_ctrl__core
        struct: tl
        package: tlul_pkg
        type: req_rsp
        act: req
        inst_name: peri
        width: 1
        default: ""
        top_signame: soc_dbg_ctrl_core_tl
        index: -1
      }
      {
        name: tl_mbx
        struct: tl
        package: tlul_pkg
        type: req_rsp
        act: rsp
        inst_name: mbx
        width: 1
        default: ""
        external: true
        top_signame: mbx_tl
        conn_type: false
        index: -1
      }
      {
        name: tl_mbx0__soc
        struct: tl
        package: tlul_pkg
        type: req_rsp
        act: req
        inst_name: mbx
        width: 1
        default: ""
        top_signame: mbx0_soc_tl_d
        index: -1
      }
      {
        name: tl_mbx1__soc
        struct: tl
        package: tlul_pkg
        type: req_rsp
        act: req
        inst_name: mbx
        width: 1
        default: ""
        top_signame: mbx1_soc_tl_d
        index: -1
      }
      {
        name: tl_mbx2__soc
        struct: tl
        package: tlul_pkg
        type: req_rsp
        act: req
        inst_name: mbx
        width: 1
        default: ""
        top_signame: mbx2_soc_tl_d
        index: -1
      }
      {
        name: tl_mbx3__soc
        struct: tl
        package: tlul_pkg
        type: req_rsp
        act: req
        inst_name: mbx
        width: 1
        default: ""
        top_signame: mbx3_soc_tl_d
        index: -1
      }
      {
        name: tl_mbx4__soc
        struct: tl
        package: tlul_pkg
        type: req_rsp
        act: req
        inst_name: mbx
        width: 1
        default: ""
        top_signame: mbx4_soc_tl_d
        index: -1
      }
      {
        name: tl_mbx5__soc
        struct: tl
        package: tlul_pkg
        type: req_rsp
        act: req
        inst_name: mbx
        width: 1
        default: ""
        top_signame: mbx5_soc_tl_d
        index: -1
      }
      {
        name: tl_mbx6__soc
        struct: tl
        package: tlul_pkg
        type: req_rsp
        act: req
        inst_name: mbx
        width: 1
        default: ""
        top_signame: mbx6_soc_tl_d
        index: -1
      }
      {
        name: tl_mbx_pcie0__soc
        struct: tl
        package: tlul_pkg
        type: req_rsp
        act: req
        inst_name: mbx
        width: 1
        default: ""
        top_signame: mbx_pcie0_soc_tl_d
        index: -1
      }
      {
        name: tl_mbx_pcie1__soc
        struct: tl
        package: tlul_pkg
        type: req_rsp
        act: req
        inst_name: mbx
        width: 1
        default: ""
        top_signame: mbx_pcie1_soc_tl_d
        index: -1
      }
      {
        name: tl_racl_ctrl
        struct: tl
        package: tlul_pkg
        type: req_rsp
        act: req
        inst_name: mbx
        width: 1
        default: ""
        top_signame: racl_ctrl_tl
        index: -1
      }
      {
        name: tl_ac_range_check
        struct: tl
        package: tlul_pkg
        type: req_rsp
        act: req
        inst_name: mbx
        width: 1
        default: ""
        top_signame: ac_range_check_tl
        index: -1
      }
      {
        name: tl_dbg
        struct: tl
        package: tlul_pkg
        type: req_rsp
        act: rsp
        inst_name: dbg
        width: 1
        default: ""
        external: true
        top_signame: dbg_tl
        conn_type: false
        index: -1
      }
      {
        name: tl_rv_dm__dbg
        struct: tl
        package: tlul_pkg
        type: req_rsp
        act: req
        inst_name: dbg
        width: 1
        default: ""
        top_signame: rv_dm_dbg_tl_d
        index: -1
      }
      {
        name: tl_mbx_jtag__soc
        struct: tl
        package: tlul_pkg
        type: req_rsp
        act: req
        inst_name: dbg
        width: 1
        default: ""
        top_signame: mbx_jtag_soc_tl_d
        index: -1
      }
      {
        name: tl_lc_ctrl__dmi
        struct: tl
        package: tlul_pkg
        type: req_rsp
        act: req
        inst_name: dbg
        width: 1
        default: ""
        top_signame: lc_ctrl_dmi_tl
        index: -1
      }
      {
        name: tl_soc_dbg_ctrl__jtag
        struct: tl
        package: tlul_pkg
        type: req_rsp
        act: req
        inst_name: dbg
        width: 1
        default: ""
        top_signame: soc_dbg_ctrl_jtag_tl
        index: -1
      }
      {
        struct: edn
        type: req_rsp
        name: edn
        act: rsp
        package: edn_pkg
        inst_name: ast
        width: 1
        default: ""
        top_signame: edn0_edn
        index: 2
        external: true
        conn_type: true
      }
      {
        struct: lc_tx
        type: uni
        name: lc_dft_en
        act: req
        package: lc_ctrl_pkg
        inst_name: ast
        width: 1
        default: ""
        top_signame: lc_ctrl_lc_dft_en
        index: -1
        external: true
        conn_type: true
      }
      {
        struct: lc_tx
        type: uni
        name: lc_hw_debug_en
        act: req
        package: lc_ctrl_pkg
        inst_name: ast
        width: 1
        default: ""
        top_signame: lc_ctrl_lc_hw_debug_en
        index: -1
        external: true
        conn_type: true
      }
      {
        struct: ast_obs_ctrl
        type: uni
        name: obs_ctrl
        act: rcv
        package: ast_pkg
        inst_name: ast
        width: 1
        default: ""
        end_idx: -1
        top_type: broadcast
        top_signame: ast_obs_ctrl
        index: -1
        external: true
        conn_type: true
      }
    ]
    external:
    [
      {
        package: edn_pkg
        struct: edn_req
        signame: ast_edn_req_i
        width: 1
        type: req_rsp
        default: ""
        direction: in
        conn_type: true
        index: 2
        netname: edn0_edn_req
      }
      {
        package: edn_pkg
        struct: edn_rsp
        signame: ast_edn_rsp_o
        width: 1
        type: req_rsp
        default: ""
        direction: out
        conn_type: true
        index: 2
        netname: edn0_edn_rsp
      }
      {
        package: lc_ctrl_pkg
        struct: lc_tx
        signame: ast_lc_dft_en_o
        width: 1
        type: uni
        default: ""
        direction: out
        conn_type: true
        index: -1
        netname: lc_ctrl_lc_dft_en
      }
      {
        package: lc_ctrl_pkg
        struct: lc_tx
        signame: ast_lc_hw_debug_en_o
        width: 1
        type: uni
        default: ""
        direction: out
        conn_type: true
        index: -1
        netname: lc_ctrl_lc_hw_debug_en
      }
      {
        package: ast_pkg
        struct: ast_obs_ctrl
        signame: obs_ctrl_i
        width: 1
        type: uni
        default: ""
        direction: in
        conn_type: true
        index: -1
        netname: ast_obs_ctrl
      }
      {
        package: prim_rom_pkg
        struct: rom_cfg
        signame: rom_ctrl0_cfg_i
        width: 1
        type: uni
        default: ""
        direction: in
        conn_type: false
        index: -1
        netname: rom_ctrl0_cfg
      }
      {
        package: prim_rom_pkg
        struct: rom_cfg
        signame: rom_ctrl1_cfg_i
        width: 1
        type: uni
        default: ""
        direction: in
        conn_type: false
        index: -1
        netname: rom_ctrl1_cfg
      }
      {
        package: prim_ram_1p_pkg
        struct: ram_1p_cfg
        signame: i2c_ram_1p_cfg_i
        width: 1
        type: uni
        default: ""
        direction: in
        conn_type: false
        index: -1
        netname: i2c_ram_1p_cfg
      }
      {
        package: prim_ram_1p_pkg
        struct: ram_1p_cfg_rsp
        signame: i2c_ram_1p_cfg_rsp_o
        width: 1
        type: uni
        default: ""
        direction: out
        conn_type: false
        index: -1
        netname: i2c_ram_1p_cfg_rsp
      }
      {
        package: prim_ram_1p_pkg
        struct: ram_1p_cfg
        signame: sram_ctrl_ret_aon_ram_1p_cfg_i
        width:
        {
          name: NumRamInst
          desc: Number of internal RAM instances. Must be the same as ceil(MemSizeRam / InstSize) .
          param_type: int
          unpacked_dimensions: null
          default: 1
          local: false
          expose: true
          name_top: SramCtrlRetAonNumRamInst
        }
        type: uni
        default: "'0"
        direction: in
        conn_type: false
        index: -1
        netname: sram_ctrl_ret_aon_ram_1p_cfg
      }
      {
        package: prim_ram_1p_pkg
        struct: ram_1p_cfg_rsp
        signame: sram_ctrl_ret_aon_ram_1p_cfg_rsp_o
        width:
        {
          name: NumRamInst
          desc: Number of internal RAM instances. Must be the same as ceil(MemSizeRam / InstSize) .
          param_type: int
          unpacked_dimensions: null
          default: 1
          local: false
          expose: true
          name_top: SramCtrlRetAonNumRamInst
        }
        type: uni
        default: "'0"
        direction: out
        conn_type: false
        index: -1
        netname: sram_ctrl_ret_aon_ram_1p_cfg_rsp
      }
      {
        package: prim_ram_1p_pkg
        struct: ram_1p_cfg
        signame: sram_ctrl_main_ram_1p_cfg_i
        width:
        {
          name: NumRamInst
          desc: Number of internal RAM instances. Must be the same as ceil(MemSizeRam / InstSize) .
          param_type: int
          unpacked_dimensions: null
          default: 1
          local: false
          expose: true
          name_top: SramCtrlMainNumRamInst
        }
        type: uni
        default: "'0"
        direction: in
        conn_type: false
        index: -1
        netname: sram_ctrl_main_ram_1p_cfg
      }
      {
        package: prim_ram_1p_pkg
        struct: ram_1p_cfg_rsp
        signame: sram_ctrl_main_ram_1p_cfg_rsp_o
        width:
        {
          name: NumRamInst
          desc: Number of internal RAM instances. Must be the same as ceil(MemSizeRam / InstSize) .
          param_type: int
          unpacked_dimensions: null
          default: 1
          local: false
          expose: true
          name_top: SramCtrlMainNumRamInst
        }
        type: uni
        default: "'0"
        direction: out
        conn_type: false
        index: -1
        netname: sram_ctrl_main_ram_1p_cfg_rsp
      }
      {
        package: prim_ram_1p_pkg
        struct: ram_1p_cfg
        signame: sram_ctrl_mbox_ram_1p_cfg_i
        width:
        {
          name: NumRamInst
          desc: Number of internal RAM instances. Must be the same as ceil(MemSizeRam / InstSize) .
          param_type: int
          unpacked_dimensions: null
          default: 1
          local: false
          expose: true
          name_top: SramCtrlMboxNumRamInst
        }
        type: uni
        default: "'0"
        direction: in
        conn_type: false
        index: -1
        netname: sram_ctrl_mbox_ram_1p_cfg
      }
      {
        package: prim_ram_1p_pkg
        struct: ram_1p_cfg_rsp
        signame: sram_ctrl_mbox_ram_1p_cfg_rsp_o
        width:
        {
          name: NumRamInst
          desc: Number of internal RAM instances. Must be the same as ceil(MemSizeRam / InstSize) .
          param_type: int
          unpacked_dimensions: null
          default: 1
          local: false
          expose: true
          name_top: SramCtrlMboxNumRamInst
        }
        type: uni
        default: "'0"
        direction: out
        conn_type: false
        index: -1
        netname: sram_ctrl_mbox_ram_1p_cfg_rsp
      }
      {
        package: prim_ram_1p_pkg
        struct: ram_1p_cfg
        signame: otbn_imem_ram_1p_cfg_i
        width: 1
        type: uni
        default: ""
        direction: in
        conn_type: false
        index: -1
        netname: otbn_imem_ram_1p_cfg
      }
      {
        package: prim_ram_1p_pkg
        struct: ram_1p_cfg_rsp
        signame: otbn_imem_ram_1p_cfg_rsp_o
        width: 1
        type: uni
        default: ""
        direction: out
        conn_type: false
        index: -1
        netname: otbn_imem_ram_1p_cfg_rsp
      }
      {
        package: prim_ram_1p_pkg
        struct: ram_1p_cfg
        signame: otbn_dmem_ram_1p_cfg_i
        width: 1
        type: uni
        default: ""
        direction: in
        conn_type: false
        index: -1
        netname: otbn_dmem_ram_1p_cfg
      }
      {
        package: prim_ram_1p_pkg
        struct: ram_1p_cfg_rsp
        signame: otbn_dmem_ram_1p_cfg_rsp_o
        width: 1
        type: uni
        default: ""
        direction: out
        conn_type: false
        index: -1
        netname: otbn_dmem_ram_1p_cfg_rsp
      }
      {
        package: prim_ram_1p_pkg
        struct: ram_1p_cfg
        signame: rv_core_ibex_icache_tag_ram_1p_cfg_i
        width: 1
        type: uni
        default: ""
        direction: in
        conn_type: false
        index: -1
        netname: rv_core_ibex_icache_tag_ram_1p_cfg
      }
      {
        package: prim_ram_1p_pkg
        struct: ram_1p_cfg_rsp
        signame: rv_core_ibex_icache_tag_ram_1p_cfg_rsp_o
        width:
        {
          name: ICacheNWays
          desc: Number of instruction cache ways
          param_type: int unsigned
          unpacked_dimensions: null
          default: 2
          local: false
          expose: true
          name_top: RvCoreIbexICacheNWays
        }
        type: uni
        default: ""
        direction: out
        conn_type: false
        index: -1
        netname: rv_core_ibex_icache_tag_ram_1p_cfg_rsp
      }
      {
        package: prim_ram_1p_pkg
        struct: ram_1p_cfg
        signame: rv_core_ibex_icache_data_ram_1p_cfg_i
        width: 1
        type: uni
        default: ""
        direction: in
        conn_type: false
        index: -1
        netname: rv_core_ibex_icache_data_ram_1p_cfg
      }
      {
        package: prim_ram_1p_pkg
        struct: ram_1p_cfg_rsp
        signame: rv_core_ibex_icache_data_ram_1p_cfg_rsp_o
        width:
        {
          name: ICacheNWays
          desc: Number of instruction cache ways
          param_type: int unsigned
          unpacked_dimensions: null
          default: 2
          local: false
          expose: true
          name_top: RvCoreIbexICacheNWays
        }
        type: uni
        default: ""
        direction: out
        conn_type: false
        index: -1
        netname: rv_core_ibex_icache_data_ram_1p_cfg_rsp
      }
      {
        package: prim_ram_2p_pkg
        struct: ram_2p_cfg
        signame: spi_device_ram_2p_cfg_sys2spi_i
        width: 1
        type: uni
        default: ""
        direction: in
        conn_type: false
        index: -1
        netname: spi_device_ram_2p_cfg_sys2spi
      }
      {
        package: prim_ram_2p_pkg
        struct: ram_2p_cfg_rsp
        signame: spi_device_ram_2p_cfg_rsp_sys2spi_o
        width: 1
        type: uni
        default: ""
        direction: out
        conn_type: false
        index: -1
        netname: spi_device_ram_2p_cfg_rsp_sys2spi
      }
      {
        package: prim_ram_2p_pkg
        struct: ram_2p_cfg_rsp
        signame: spi_device_ram_2p_cfg_rsp_spi2sys_o
        width: 1
        type: uni
        default: ""
        direction: out
        conn_type: false
        index: -1
        netname: spi_device_ram_2p_cfg_rsp_spi2sys
      }
      {
        package: prim_ram_2p_pkg
        struct: ram_2p_cfg
        signame: spi_device_ram_2p_cfg_spi2sys_i
        width: 1
        type: uni
        default: ""
        direction: in
        conn_type: false
        index: -1
        netname: spi_device_ram_2p_cfg_spi2sys
      }
      {
        package: pwrmgr_pkg
        struct: pwr_boot_status
        signame: pwrmgr_boot_status_o
        width: 1
        type: uni
        default: ""
        direction: out
        conn_type: true
        index: -1
        netname: pwrmgr_aon_boot_status
      }
      {
        package: prim_mubi_pkg
        struct: mubi4
        signame: clk_main_jitter_en_o
        width: 1
        type: uni
        default: ""
        direction: out
        conn_type: false
        index: -1
        netname: clk_main_jitter_en
      }
      {
        package: prim_mubi_pkg
        struct: mubi4
        signame: io_clk_byp_req_o
        width: 1
        type: uni
        default: ""
        direction: out
        conn_type: false
        index: -1
        netname: io_clk_byp_req
      }
      {
        package: prim_mubi_pkg
        struct: mubi4
        signame: io_clk_byp_ack_i
        width: 1
        type: uni
        default: ""
        direction: in
        conn_type: false
        index: -1
        netname: io_clk_byp_ack
      }
      {
        package: prim_mubi_pkg
        struct: mubi4
        signame: all_clk_byp_req_o
        width: 1
        type: uni
        default: ""
        direction: out
        conn_type: false
        index: -1
        netname: all_clk_byp_req
      }
      {
        package: prim_mubi_pkg
        struct: mubi4
        signame: all_clk_byp_ack_i
        width: 1
        type: uni
        default: ""
        direction: in
        conn_type: false
        index: -1
        netname: all_clk_byp_ack
      }
      {
        package: prim_mubi_pkg
        struct: mubi4
        signame: hi_speed_sel_o
        width: 1
        type: uni
        default: ""
        direction: out
        conn_type: false
        index: -1
        netname: hi_speed_sel
      }
      {
        package: prim_mubi_pkg
        struct: mubi4
        signame: div_step_down_req_i
        width: 1
        type: uni
        default: ""
        direction: in
        conn_type: false
        index: -1
        netname: div_step_down_req
      }
      {
        package: prim_mubi_pkg
        struct: mubi4
        signame: calib_rdy_i
        width: 1
        type: uni
        default: prim_mubi_pkg::MuBi4True
        direction: in
        conn_type: false
        index: -1
        netname: calib_rdy
      }
      {
        package: entropy_src_pkg
        struct: entropy_src_hw_if_req
        signame: entropy_src_hw_if_req_o
        width: 1
        type: req_rsp
        default: ""
        direction: out
        conn_type: false
        index: -1
        netname: entropy_src_hw_if_req
      }
      {
        package: entropy_src_pkg
        struct: entropy_src_hw_if_rsp
        signame: entropy_src_hw_if_rsp_i
        width: 1
        type: req_rsp
        default: ""
        direction: in
        conn_type: false
        index: -1
        netname: entropy_src_hw_if_rsp
      }
      {
        package: dma_pkg
        struct: sys_req
        signame: dma_sys_req_o
        width: 1
        type: req_rsp
        default: ""
        direction: out
        conn_type: false
        index: -1
        netname: dma_sys_req
      }
      {
        package: dma_pkg
        struct: sys_rsp
        signame: dma_sys_rsp_i
        width: 1
        type: req_rsp
        default: ""
        direction: in
        conn_type: false
        index: -1
        netname: dma_sys_rsp
      }
      {
        package: tlul_pkg
        struct: tl_h2d
        signame: mbx_tl_req_i
        width: 1
        type: req_rsp
        default: ""
        direction: in
        conn_type: false
        index: -1
        netname: mbx_tl_h2d
      }
      {
        package: tlul_pkg
        struct: tl_d2h
        signame: mbx_tl_rsp_o
        width: 1
        type: req_rsp
        default: ""
        direction: out
        conn_type: false
        index: -1
        netname: mbx_tl_d2h
      }
      {
        package: ""
        struct: logic
        signame: mbx0_doe_intr_o
        width: 1
        type: uni
        default: 1'b0
        direction: out
        conn_type: false
        index: -1
        netname: mbx0_doe_intr
      }
      {
        package: ""
        struct: logic
        signame: mbx0_doe_intr_en_o
        width: 1
        type: uni
        default: 1'b0
        direction: out
        conn_type: false
        index: -1
        netname: mbx0_doe_intr_en
      }
      {
        package: ""
        struct: logic
        signame: mbx0_doe_intr_support_o
        width: 1
        type: uni
        default: 1'b0
        direction: out
        conn_type: false
        index: -1
        netname: mbx0_doe_intr_support
      }
      {
        package: ""
        struct: logic
        signame: mbx0_doe_async_msg_support_o
        width: 1
        type: uni
        default: 1'b0
        direction: out
        conn_type: false
        index: -1
        netname: mbx0_doe_async_msg_support
      }
      {
        package: ""
        struct: logic
        signame: mbx1_doe_intr_o
        width: 1
        type: uni
        default: 1'b0
        direction: out
        conn_type: false
        index: -1
        netname: mbx1_doe_intr
      }
      {
        package: ""
        struct: logic
        signame: mbx1_doe_intr_en_o
        width: 1
        type: uni
        default: 1'b0
        direction: out
        conn_type: false
        index: -1
        netname: mbx1_doe_intr_en
      }
      {
        package: ""
        struct: logic
        signame: mbx1_doe_intr_support_o
        width: 1
        type: uni
        default: 1'b0
        direction: out
        conn_type: false
        index: -1
        netname: mbx1_doe_intr_support
      }
      {
        package: ""
        struct: logic
        signame: mbx1_doe_async_msg_support_o
        width: 1
        type: uni
        default: 1'b0
        direction: out
        conn_type: false
        index: -1
        netname: mbx1_doe_async_msg_support
      }
      {
        package: ""
        struct: logic
        signame: mbx2_doe_intr_o
        width: 1
        type: uni
        default: 1'b0
        direction: out
        conn_type: false
        index: -1
        netname: mbx2_doe_intr
      }
      {
        package: ""
        struct: logic
        signame: mbx2_doe_intr_en_o
        width: 1
        type: uni
        default: 1'b0
        direction: out
        conn_type: false
        index: -1
        netname: mbx2_doe_intr_en
      }
      {
        package: ""
        struct: logic
        signame: mbx2_doe_intr_support_o
        width: 1
        type: uni
        default: 1'b0
        direction: out
        conn_type: false
        index: -1
        netname: mbx2_doe_intr_support
      }
      {
        package: ""
        struct: logic
        signame: mbx2_doe_async_msg_support_o
        width: 1
        type: uni
        default: 1'b0
        direction: out
        conn_type: false
        index: -1
        netname: mbx2_doe_async_msg_support
      }
      {
        package: ""
        struct: logic
        signame: mbx3_doe_intr_o
        width: 1
        type: uni
        default: 1'b0
        direction: out
        conn_type: false
        index: -1
        netname: mbx3_doe_intr
      }
      {
        package: ""
        struct: logic
        signame: mbx3_doe_intr_en_o
        width: 1
        type: uni
        default: 1'b0
        direction: out
        conn_type: false
        index: -1
        netname: mbx3_doe_intr_en
      }
      {
        package: ""
        struct: logic
        signame: mbx3_doe_intr_support_o
        width: 1
        type: uni
        default: 1'b0
        direction: out
        conn_type: false
        index: -1
        netname: mbx3_doe_intr_support
      }
      {
        package: ""
        struct: logic
        signame: mbx3_doe_async_msg_support_o
        width: 1
        type: uni
        default: 1'b0
        direction: out
        conn_type: false
        index: -1
        netname: mbx3_doe_async_msg_support
      }
      {
        package: ""
        struct: logic
        signame: mbx4_doe_intr_o
        width: 1
        type: uni
        default: 1'b0
        direction: out
        conn_type: false
        index: -1
        netname: mbx4_doe_intr
      }
      {
        package: ""
        struct: logic
        signame: mbx4_doe_intr_en_o
        width: 1
        type: uni
        default: 1'b0
        direction: out
        conn_type: false
        index: -1
        netname: mbx4_doe_intr_en
      }
      {
        package: ""
        struct: logic
        signame: mbx4_doe_intr_support_o
        width: 1
        type: uni
        default: 1'b0
        direction: out
        conn_type: false
        index: -1
        netname: mbx4_doe_intr_support
      }
      {
        package: ""
        struct: logic
        signame: mbx4_doe_async_msg_support_o
        width: 1
        type: uni
        default: 1'b0
        direction: out
        conn_type: false
        index: -1
        netname: mbx4_doe_async_msg_support
      }
      {
        package: ""
        struct: logic
        signame: mbx5_doe_intr_o
        width: 1
        type: uni
        default: 1'b0
        direction: out
        conn_type: false
        index: -1
        netname: mbx5_doe_intr
      }
      {
        package: ""
        struct: logic
        signame: mbx5_doe_intr_en_o
        width: 1
        type: uni
        default: 1'b0
        direction: out
        conn_type: false
        index: -1
        netname: mbx5_doe_intr_en
      }
      {
        package: ""
        struct: logic
        signame: mbx5_doe_intr_support_o
        width: 1
        type: uni
        default: 1'b0
        direction: out
        conn_type: false
        index: -1
        netname: mbx5_doe_intr_support
      }
      {
        package: ""
        struct: logic
        signame: mbx5_doe_async_msg_support_o
        width: 1
        type: uni
        default: 1'b0
        direction: out
        conn_type: false
        index: -1
        netname: mbx5_doe_async_msg_support
      }
      {
        package: ""
        struct: logic
        signame: mbx6_doe_intr_o
        width: 1
        type: uni
        default: 1'b0
        direction: out
        conn_type: false
        index: -1
        netname: mbx6_doe_intr
      }
      {
        package: ""
        struct: logic
        signame: mbx6_doe_intr_en_o
        width: 1
        type: uni
        default: 1'b0
        direction: out
        conn_type: false
        index: -1
        netname: mbx6_doe_intr_en
      }
      {
        package: ""
        struct: logic
        signame: mbx6_doe_intr_support_o
        width: 1
        type: uni
        default: 1'b0
        direction: out
        conn_type: false
        index: -1
        netname: mbx6_doe_intr_support
      }
      {
        package: ""
        struct: logic
        signame: mbx6_doe_async_msg_support_o
        width: 1
        type: uni
        default: 1'b0
        direction: out
        conn_type: false
        index: -1
        netname: mbx6_doe_async_msg_support
      }
      {
        package: ""
        struct: logic
        signame: mbx_jtag_doe_intr_o
        width: 1
        type: uni
        default: 1'b0
        direction: out
        conn_type: false
        index: -1
        netname: mbx_jtag_doe_intr
      }
      {
        package: ""
        struct: logic
        signame: mbx_jtag_doe_intr_en_o
        width: 1
        type: uni
        default: 1'b0
        direction: out
        conn_type: false
        index: -1
        netname: mbx_jtag_doe_intr_en
      }
      {
        package: ""
        struct: logic
        signame: mbx_jtag_doe_intr_support_o
        width: 1
        type: uni
        default: 1'b0
        direction: out
        conn_type: false
        index: -1
        netname: mbx_jtag_doe_intr_support
      }
      {
        package: ""
        struct: logic
        signame: mbx_jtag_doe_async_msg_support_o
        width: 1
        type: uni
        default: 1'b0
        direction: out
        conn_type: false
        index: -1
        netname: mbx_jtag_doe_async_msg_support
      }
      {
        package: ""
        struct: logic
        signame: mbx_pcie0_doe_intr_o
        width: 1
        type: uni
        default: 1'b0
        direction: out
        conn_type: false
        index: -1
        netname: mbx_pcie0_doe_intr
      }
      {
        package: ""
        struct: logic
        signame: mbx_pcie0_doe_intr_en_o
        width: 1
        type: uni
        default: 1'b0
        direction: out
        conn_type: false
        index: -1
        netname: mbx_pcie0_doe_intr_en
      }
      {
        package: ""
        struct: logic
        signame: mbx_pcie0_doe_intr_support_o
        width: 1
        type: uni
        default: 1'b0
        direction: out
        conn_type: false
        index: -1
        netname: mbx_pcie0_doe_intr_support
      }
      {
        package: ""
        struct: logic
        signame: mbx_pcie0_doe_async_msg_support_o
        width: 1
        type: uni
        default: 1'b0
        direction: out
        conn_type: false
        index: -1
        netname: mbx_pcie0_doe_async_msg_support
      }
      {
        package: ""
        struct: logic
        signame: mbx_pcie1_doe_intr_o
        width: 1
        type: uni
        default: 1'b0
        direction: out
        conn_type: false
        index: -1
        netname: mbx_pcie1_doe_intr
      }
      {
        package: ""
        struct: logic
        signame: mbx_pcie1_doe_intr_en_o
        width: 1
        type: uni
        default: 1'b0
        direction: out
        conn_type: false
        index: -1
        netname: mbx_pcie1_doe_intr_en
      }
      {
        package: ""
        struct: logic
        signame: mbx_pcie1_doe_intr_support_o
        width: 1
        type: uni
        default: 1'b0
        direction: out
        conn_type: false
        index: -1
        netname: mbx_pcie1_doe_intr_support
      }
      {
        package: ""
        struct: logic
        signame: mbx_pcie1_doe_async_msg_support_o
        width: 1
        type: uni
        default: 1'b0
        direction: out
        conn_type: false
        index: -1
        netname: mbx_pcie1_doe_async_msg_support
      }
      {
        package: tlul_pkg
        struct: tl_h2d
        signame: dbg_tl_req_i
        width: 1
        type: req_rsp
        default: ""
        direction: in
        conn_type: false
        index: -1
        netname: dbg_tl_h2d
      }
      {
        package: tlul_pkg
        struct: tl_d2h
        signame: dbg_tl_rsp_o
        width: 1
        type: req_rsp
        default: ""
        direction: out
        conn_type: false
        index: -1
        netname: dbg_tl_d2h
      }
      {
        package: rv_dm_pkg
        struct: next_dm_addr
        signame: rv_dm_next_dm_addr_i
        width: 1
        type: uni
        default: "'0"
        direction: in
        conn_type: false
        index: -1
        netname: rv_dm_next_dm_addr
      }
      {
        package: tlul_pkg
        struct: tl_h2d
        signame: ast_tl_req_o
        width: 1
        type: req_rsp
        default: ""
        direction: out
        conn_type: false
        index: -1
        netname: ast_tl_h2d
      }
      {
        package: tlul_pkg
        struct: tl_d2h
        signame: ast_tl_rsp_i
        width: 1
        type: req_rsp
        default: ""
        direction: in
        conn_type: false
        index: -1
        netname: ast_tl_d2h
      }
      {
        package: pwrmgr_pkg
        struct: pwr_ast_req
        signame: pwrmgr_ast_req_o
        width: 1
        type: req_rsp
        default: ""
        direction: out
        conn_type: false
        index: -1
        netname: pwrmgr_ast_req
      }
      {
        package: pwrmgr_pkg
        struct: pwr_ast_rsp
        signame: pwrmgr_ast_rsp_i
        width: 1
        type: req_rsp
        default: ""
        direction: in
        conn_type: false
        index: -1
        netname: pwrmgr_ast_rsp
      }
      {
        package: otp_macro_pkg
        struct: pwr_seq
        signame: otp_macro_pwr_seq_o
        width: 1
        type: uni
        default: "'0"
        direction: out
        conn_type: false
        index: -1
        netname: otp_macro_pwr_seq
      }
      {
        package: otp_macro_pkg
        struct: pwr_seq
        signame: otp_macro_pwr_seq_h_i
        width: 1
        type: uni
        default: "'0"
        direction: in
        conn_type: false
        index: -1
        netname: otp_macro_pwr_seq_h
      }
      {
        package: ""
        struct: ""
        signame: otp_ext_voltage_h_io
        width: 1
        type: io
        default: "'0"
        direction: inout
        conn_type: false
        index: -1
        netname: otp_ext_voltage_h
      }
      {
        package: ""
        struct: logic
        signame: otp_obs_o
        width: 8
        type: uni
        default: ""
        direction: out
        conn_type: false
        index: -1
        netname: otp_obs
      }
      {
        package: otp_macro_pkg
        struct: otp_cfg
        signame: otp_cfg_i
        width: 1
        type: uni
        default: "'0"
        direction: in
        conn_type: false
        index: -1
        netname: otp_cfg
      }
      {
        package: otp_macro_pkg
        struct: otp_cfg_rsp
        signame: otp_cfg_rsp_o
        width: 1
        type: uni
        default: "'0"
        direction: out
        conn_type: false
        index: -1
        netname: otp_cfg_rsp
      }
      {
        package: ""
        struct: logic
        signame: por_n_i
        width: 2
        type: uni
        default: ""
        direction: in
        conn_type: false
        index: -1
        netname: por_n
      }
      {
        package: ""
        struct: logic
        signame: fpga_info_i
        width: 32
        type: uni
        default: ""
        direction: in
        conn_type: false
        index: -1
        netname: fpga_info
      }
      {
        package: tlul_pkg
        struct: tl_h2d
        signame: ctn_misc_tl_h2d_i
        width: 1
        type: uni
        default: ""
        direction: in
        conn_type: false
        index: -1
        netname: ctn_misc_tl_h2d
      }
      {
        package: tlul_pkg
        struct: tl_d2h
        signame: ctn_misc_tl_d2h_o
        width: 1
        type: uni
        default: ""
        direction: out
        conn_type: false
        index: -1
        netname: ctn_misc_tl_d2h
      }
      {
        package: soc_proxy_pkg
        struct: soc_alert_req
        signame: soc_fatal_alert_req_i
        width: 24
        type: req_rsp
        default: ""
        direction: in
        conn_type: false
        index: -1
        netname: soc_fatal_alert_req
      }
      {
        package: soc_proxy_pkg
        struct: soc_alert_rsp
        signame: soc_fatal_alert_rsp_o
        width: 24
        type: req_rsp
        default: ""
        direction: out
        conn_type: false
        index: -1
        netname: soc_fatal_alert_rsp
      }
      {
        package: soc_proxy_pkg
        struct: soc_alert_req
        signame: soc_recov_alert_req_i
        width: 4
        type: req_rsp
        default: ""
        direction: in
        conn_type: false
        index: -1
        netname: soc_recov_alert_req
      }
      {
        package: soc_proxy_pkg
        struct: soc_alert_rsp
        signame: soc_recov_alert_rsp_o
        width: 4
        type: req_rsp
        default: ""
        direction: out
        conn_type: false
        index: -1
        netname: soc_recov_alert_rsp
      }
      {
        package: ""
        struct: logic
        signame: soc_wkup_async_i
        width: 1
        type: uni
        default: ""
        direction: in
        conn_type: false
        index: -1
        netname: soc_wkup_async
      }
      {
        package: ""
        struct: logic
        signame: soc_rst_req_async_i
        width: 1
        type: uni
        default: ""
        direction: in
        conn_type: false
        index: -1
        netname: soc_rst_req_async
      }
      {
        package: ""
        struct: logic
        signame: soc_intr_async_i
        width: 32
        type: uni
        default: ""
        direction: in
        conn_type: false
        index: -1
        netname: soc_intr_async
      }
      {
        package: ""
        struct: logic
        signame: soc_lsio_trigger_i
        width: 8
        type: uni
        default: ""
        direction: in
        conn_type: false
        index: -1
        netname: soc_lsio_trigger
      }
      {
        package: ""
        struct: logic
        signame: soc_gpi_async_o
        width: 16
        type: uni
        default: ""
        direction: out
        conn_type: false
        index: -1
        netname: soc_gpi_async
      }
      {
        package: ""
        struct: logic
        signame: soc_gpo_async_i
        width: 16
        type: uni
        default: ""
        direction: in
        conn_type: false
        index: -1
        netname: soc_gpo_async
      }
      {
        package: ""
        struct: logic
        signame: integrator_id_i
        width: 4
        type: uni
        default: ""
        direction: in
        conn_type: false
        index: -1
        netname: integrator_id
      }
      {
        package: ""
        struct: logic
        signame: sck_monitor_o
        width: 1
        type: uni
        default: ""
        direction: out
        conn_type: false
        index: -1
        netname: sck_monitor
      }
      {
        package: soc_dbg_ctrl_pkg
        struct: soc_dbg_policy
        signame: soc_dbg_policy_bus_o
        width: 1
        type: uni
        default: ""
        direction: out
        conn_type: false
        index: -1
        netname: soc_dbg_policy_bus
      }
      {
        package: ""
        struct: logic
        signame: debug_halt_cpu_boot_i
        width: 1
        type: uni
        default: ""
        direction: in
        conn_type: false
        index: -1
        netname: debug_halt_cpu_boot
      }
      {
        package: top_racl_pkg
        struct: racl_policy_vec
        signame: racl_policies_o
        width: 1
        type: uni
        default: ""
        direction: out
        conn_type: true
        index: -1
        netname: racl_ctrl_racl_policies
      }
      {
        package: top_racl_pkg
        struct: racl_error_log
        signame: racl_error_i
        width:
        {
          name: NumExternalSubscribingIps
          desc: Number of external subscribing RACL IPs
          param_type: int
          unpacked_dimensions: null
          default: 1
          local: false
          expose: true
          name_top: RaclCtrlNumExternalSubscribingIps
        }
        type: uni
        default: ""
        direction: in
        conn_type: false
        index: -1
        netname: racl_error
      }
      {
        package: prim_mubi_pkg
        struct: mubi8
        signame: ac_range_check_overwrite_i
        width: 1
        type: uni
        default: ""
        direction: in
        conn_type: false
        index: -1
        netname: ac_range_check_overwrite
      }
      {
        package: tlul_pkg
        struct: tl_h2d
        signame: ctn_tl_h2d_o
        width: 1
        type: uni
        default: ""
        direction: out
        conn_type: false
        index: -1
        netname: ctn_tl_h2d
      }
      {
        package: tlul_pkg
        struct: tl_d2h
        signame: ctn_tl_d2h_i
        width: 1
        type: uni
        default: ""
        direction: in
        conn_type: false
        index: -1
        netname: ctn_tl_d2h
      }
    ]
    definitions:
    [
      {
        package: ast_pkg
        struct: ast_obs_ctrl
        signame: ast_obs_ctrl
        width: 1
        type: uni
        end_idx: -1
        act: rcv
        suffix: ""
        default: ast_pkg::AST_OBS_CTRL_DEFAULT
      }
      {
        package: alert_handler_pkg
        struct: alert_crashdump
        signame: alert_handler_crashdump
        width: 1
        type: uni
        end_idx: -1
        act: req
        suffix: ""
        default: alert_handler_pkg::ALERT_CRASHDUMP_DEFAULT
      }
      {
        package: prim_esc_pkg
        struct: esc_rx
        signame: alert_handler_esc_rx
        width: 4
        type: uni
        end_idx: -1
        act: rcv
        suffix: ""
        default: prim_esc_pkg::ESC_RX_DEFAULT
      }
      {
        package: prim_esc_pkg
        struct: esc_tx
        signame: alert_handler_esc_tx
        width: 4
        type: uni
        end_idx: -1
        act: req
        suffix: ""
        default: prim_esc_pkg::ESC_TX_DEFAULT
      }
      {
        package: ""
        struct: logic
        signame: aon_timer_aon_nmi_wdog_timer_bark
        width: 1
        type: uni
        end_idx: -1
        act: req
        suffix: ""
        default: 1'b0
      }
      {
        package: csrng_pkg
        struct: csrng_req
        signame: csrng_csrng_cmd_req
        width: 2
        type: req_rsp
        end_idx: -1
        act: rsp
        suffix: req
        default: csrng_pkg::CSRNG_REQ_DEFAULT
      }
      {
        package: csrng_pkg
        struct: csrng_rsp
        signame: csrng_csrng_cmd_rsp
        width: 2
        type: req_rsp
        end_idx: -1
        act: rsp
        suffix: rsp
        default: ""
      }
      {
        package: otp_ctrl_pkg
        struct: sram_otp_key_req
        signame: otp_ctrl_sram_otp_key_req
        width: 4
        type: req_rsp
        end_idx: -1
        act: rsp
        suffix: req
        default: "'0"
      }
      {
        package: otp_ctrl_pkg
        struct: sram_otp_key_rsp
        signame: otp_ctrl_sram_otp_key_rsp
        width: 4
        type: req_rsp
        end_idx: -1
        act: rsp
        suffix: rsp
        default: ""
      }
      {
        package: pwrmgr_pkg
        struct: pwr_rst_req
        signame: pwrmgr_aon_pwr_rst_req
        width: 1
        type: req_rsp
        end_idx: -1
        act: req
        suffix: req
        default: ""
      }
      {
        package: pwrmgr_pkg
        struct: pwr_rst_rsp
        signame: pwrmgr_aon_pwr_rst_rsp
        width: 1
        type: req_rsp
        end_idx: -1
        act: req
        suffix: rsp
        default: pwrmgr_pkg::PWR_RST_RSP_DEFAULT
      }
      {
        package: pwrmgr_pkg
        struct: pwr_clk_req
        signame: pwrmgr_aon_pwr_clk_req
        width: 1
        type: req_rsp
        end_idx: -1
        act: req
        suffix: req
        default: ""
      }
      {
        package: pwrmgr_pkg
        struct: pwr_clk_rsp
        signame: pwrmgr_aon_pwr_clk_rsp
        width: 1
        type: req_rsp
        end_idx: -1
        act: req
        suffix: rsp
        default: pwrmgr_pkg::PWR_CLK_RSP_DEFAULT
      }
      {
        package: pwrmgr_pkg
        struct: pwr_otp_req
        signame: pwrmgr_aon_pwr_otp_req
        width: 1
        type: req_rsp
        end_idx: -1
        act: req
        suffix: req
        default: ""
      }
      {
        package: pwrmgr_pkg
        struct: pwr_otp_rsp
        signame: pwrmgr_aon_pwr_otp_rsp
        width: 1
        type: req_rsp
        end_idx: -1
        act: req
        suffix: rsp
        default: pwrmgr_pkg::PWR_OTP_RSP_DEFAULT
      }
      {
        package: lc_ctrl_pkg
        struct: pwr_lc_req
        signame: pwrmgr_aon_pwr_lc_req
        width: 1
        type: req_rsp
        end_idx: -1
        act: req
        suffix: req
        default: ""
      }
      {
        package: lc_ctrl_pkg
        struct: pwr_lc_rsp
        signame: pwrmgr_aon_pwr_lc_rsp
        width: 1
        type: req_rsp
        end_idx: -1
        act: req
        suffix: rsp
        default: lc_ctrl_pkg::PWR_LC_RSP_DEFAULT
      }
      {
        package: ""
        struct: logic
        signame: pwrmgr_aon_strap
        width: 1
        type: uni
        end_idx: -1
        act: req
        suffix: ""
        default: "'0"
      }
      {
        package: ""
        struct: logic
        signame: pwrmgr_aon_low_power
        width: 1
        type: uni
        end_idx: -1
        act: req
        suffix: ""
        default: "'0"
      }
      {
        package: lc_ctrl_pkg
        struct: lc_tx
        signame: pwrmgr_aon_fetch_en
        width: 1
        type: uni
        end_idx: -1
        act: req
        suffix: ""
        default: lc_ctrl_pkg::LC_TX_DEFAULT
      }
      {
        package: rom_ctrl_pkg
        struct: pwrmgr_data
        signame: pwrmgr_aon_rom_ctrl
        width: 3
        type: uni
        end_idx: -1
        act: rcv
        suffix: ""
        default: rom_ctrl_pkg::PWRMGR_DATA_DEFAULT
      }
      {
        package: pwrmgr_pkg
        struct: pwr_boot_status
        signame: pwrmgr_aon_boot_status
        width: 1
        type: uni
        end_idx: -1
        act: req
        suffix: ""
        default: pwrmgr_pkg::PWR_BOOT_STATUS_DEFAULT
      }
      {
        package: rom_ctrl_pkg
        struct: keymgr_data
        signame: keymgr_dpe_rom_digest
        width: 2
        type: uni
        end_idx: -1
        act: rcv
        suffix: ""
        default: rom_ctrl_pkg::KEYMGR_DATA_DEFAULT
      }
      {
        package: dma_pkg
        struct: lsio_trigger
        signame: dma_lsio_trigger
        width: 1
        type: uni
        end_idx: -1
        act: rcv
        suffix: ""
        default: dma_pkg::LSIO_TRIGGER_DEFAULT
      }
      {
        package: ""
        struct: logic
        signame: i2c0_lsio_trigger
        width: 1
        type: uni
        end_idx: -1
        act: req
        suffix: ""
        default: "'0"
      }
      {
        package: ""
        struct: logic
        signame: spi_host0_lsio_trigger
        width: 1
        type: uni
        end_idx: -1
        act: req
        suffix: ""
        default: "'0"
      }
      {
        package: ""
        struct: logic
        signame: uart0_lsio_trigger
        width: 1
        type: uni
        end_idx: -1
        act: req
        suffix: ""
        default: "'0"
      }
      {
        package: lc_ctrl_pkg
        struct: lc_tx
        signame: lc_ctrl_lc_flash_rma_req
        width: 1
        type: uni
        end_idx: -1
        act: req
        suffix: ""
        default: lc_ctrl_pkg::Off
      }
      {
        package: lc_ctrl_pkg
        struct: lc_tx
        signame: otbn_lc_rma_ack
        width: 1
        type: uni
        end_idx: -1
        act: req
        suffix: ""
        default: lc_ctrl_pkg::Off
      }
      {
        package: edn_pkg
        struct: edn_req
        signame: edn0_edn_req
        width: 8
        type: req_rsp
        end_idx: -1
        act: rsp
        suffix: req
        default: "'0"
      }
      {
        package: edn_pkg
        struct: edn_rsp
        signame: edn0_edn_rsp
        width: 8
        type: req_rsp
        end_idx: -1
        act: rsp
        suffix: rsp
        default: ""
      }
      {
        package: edn_pkg
        struct: edn_req
        signame: edn1_edn_req
        width: 8
        type: req_rsp
        end_idx: 1
        act: rsp
        suffix: req
        default: "'0"
      }
      {
        package: edn_pkg
        struct: edn_rsp
        signame: edn1_edn_rsp
        width: 8
        type: req_rsp
        end_idx: 1
        act: rsp
        suffix: rsp
        default: ""
      }
      {
        package: otp_ctrl_pkg
        struct: otbn_otp_key_req
        signame: otp_ctrl_otbn_otp_key_req
        width: 1
        type: req_rsp
        end_idx: -1
        act: rsp
        suffix: req
        default: "'0"
      }
      {
        package: otp_ctrl_pkg
        struct: otbn_otp_key_rsp
        signame: otp_ctrl_otbn_otp_key_rsp
        width: 1
        type: req_rsp
        end_idx: -1
        act: rsp
        suffix: rsp
        default: ""
      }
      {
        package: otp_ctrl_pkg
        struct: otp_keymgr_key
        signame: otp_ctrl_otp_keymgr_key
        width: 1
        type: uni
        end_idx: -1
        act: req
        suffix: ""
        default: "'0"
      }
      {
        package: keymgr_pkg
        struct: hw_key_req
        signame: keymgr_dpe_aes_key
        width: 1
        type: uni
        end_idx: -1
        act: req
        suffix: ""
        default: keymgr_pkg::HW_KEY_REQ_DEFAULT
      }
      {
        package: keymgr_pkg
        struct: hw_key_req
        signame: keymgr_dpe_kmac_key
        width: 1
        type: uni
        end_idx: -1
        act: req
        suffix: ""
        default: keymgr_pkg::HW_KEY_REQ_DEFAULT
      }
      {
        package: keymgr_pkg
        struct: otbn_key_req
        signame: keymgr_dpe_otbn_key
        width: 1
        type: uni
        end_idx: -1
        act: req
        suffix: ""
        default: keymgr_pkg::OTBN_KEY_REQ_DEFAULT
      }
      {
        package: kmac_pkg
        struct: app_req
        signame: kmac_app_req
        width:
        {
          name: NumAppIntf
          desc: Number of application interfaces
          param_type: int
          unpacked_dimensions: null
          default: 3
          local: false
          expose: true
          name_top: KmacNumAppIntf
        }
        type: req_rsp
        end_idx: -1
        act: rsp
        suffix: req
        default: kmac_pkg::APP_REQ_DEFAULT
      }
      {
        package: kmac_pkg
        struct: app_rsp
        signame: kmac_app_rsp
        width:
        {
          name: NumAppIntf
          desc: Number of application interfaces
          param_type: int
          unpacked_dimensions: null
          default: 3
          local: false
          expose: true
          name_top: KmacNumAppIntf
        }
        type: req_rsp
        end_idx: -1
        act: rsp
        suffix: rsp
        default: ""
      }
      {
        package: ""
        struct: logic
        signame: kmac_en_masking
        width: 1
        type: uni
        end_idx: -1
        act: req
        suffix: ""
        default: "'0"
      }
      {
        package: prim_mubi_pkg
        struct: mubi4
        signame: clkmgr_aon_idle
        width: 4
        type: uni
        end_idx: -1
        act: rcv
        suffix: ""
        default: prim_mubi_pkg::MUBI4_DEFAULT
      }
      {
        package: otp_ctrl_pkg
        struct: otp_lc_data
        signame: otp_ctrl_otp_lc_data
        width: 1
        type: uni
        end_idx: -1
        act: req
        suffix: ""
        default: "'0"
      }
      {
        package: otp_ctrl_pkg
        struct: lc_otp_program_req
        signame: lc_ctrl_lc_otp_program_req
        width: 1
        type: req_rsp
        end_idx: -1
        act: req
        suffix: req
        default: ""
      }
      {
        package: otp_ctrl_pkg
        struct: lc_otp_program_rsp
        signame: lc_ctrl_lc_otp_program_rsp
        width: 1
        type: req_rsp
        end_idx: -1
        act: req
        suffix: rsp
        default: "'0"
      }
      {
        package: otp_macro_pkg
        struct: otp_test_req
        signame: lc_ctrl_lc_otp_vendor_test_req
        width: 1
        type: req_rsp
        end_idx: -1
        act: req
        suffix: req
        default: ""
      }
      {
        package: otp_macro_pkg
        struct: otp_test_rsp
        signame: lc_ctrl_lc_otp_vendor_test_rsp
        width: 1
        type: req_rsp
        end_idx: -1
        act: req
        suffix: rsp
        default: "'0"
      }
      {
        package: lc_ctrl_pkg
        struct: lc_keymgr_div
        signame: lc_ctrl_lc_keymgr_div
        width: 1
        type: uni
        end_idx: -1
        act: req
        suffix: ""
        default: "'0"
      }
      {
        package: ""
        struct: logic
        signame: lc_ctrl_strap_en_override
        width: 1
        type: uni
        end_idx: -1
        act: req
        suffix: ""
        default: 1'b0
      }
      {
        package: lc_ctrl_pkg
        struct: lc_tx
        signame: lc_ctrl_lc_raw_test_rma
        width: 1
        type: uni
        end_idx: -1
        act: req
        suffix: ""
        default: lc_ctrl_pkg::Off
      }
      {
        package: lc_ctrl_pkg
        struct: lc_tx
        signame: lc_ctrl_lc_dft_en
        width: 1
        type: uni
        end_idx: -1
        act: req
        suffix: ""
        default: lc_ctrl_pkg::Off
      }
      {
        package: lc_ctrl_pkg
        struct: lc_tx
        signame: lc_ctrl_lc_hw_debug_en
        width: 1
        type: uni
        end_idx: -1
        act: req
        suffix: ""
        default: lc_ctrl_pkg::Off
      }
      {
        package: lc_ctrl_pkg
        struct: lc_tx
        signame: lc_ctrl_lc_cpu_en
        width: 1
        type: uni
        end_idx: -1
        act: req
        suffix: ""
        default: lc_ctrl_pkg::Off
      }
      {
        package: lc_ctrl_pkg
        struct: lc_tx
        signame: lc_ctrl_lc_keymgr_en
        width: 1
        type: uni
        end_idx: -1
        act: req
        suffix: ""
        default: lc_ctrl_pkg::Off
      }
      {
        package: lc_ctrl_pkg
        struct: lc_tx
        signame: lc_ctrl_lc_escalate_en
        width: 1
        type: uni
        end_idx: -1
        act: req
        suffix: ""
        default: lc_ctrl_pkg::Off
      }
      {
        package: lc_ctrl_pkg
        struct: lc_tx
        signame: lc_ctrl_lc_check_byp_en
        width: 1
        type: uni
        end_idx: -1
        act: req
        suffix: ""
        default: lc_ctrl_pkg::Off
      }
      {
        package: lc_ctrl_pkg
        struct: lc_tx
        signame: lc_ctrl_lc_clk_byp_req
        width: 1
        type: uni
        end_idx: -1
        act: req
        suffix: ""
        default: lc_ctrl_pkg::Off
      }
      {
        package: lc_ctrl_pkg
        struct: lc_tx
        signame: lc_ctrl_lc_clk_byp_ack
        width: 1
        type: uni
        end_idx: -1
        act: rcv
        suffix: ""
        default: lc_ctrl_pkg::Off
      }
      {
        package: lc_ctrl_pkg
        struct: lc_tx
        signame: lc_ctrl_lc_creator_seed_sw_rw_en
        width: 1
        type: uni
        end_idx: -1
        act: req
        suffix: ""
        default: lc_ctrl_pkg::Off
      }
      {
        package: lc_ctrl_pkg
        struct: lc_tx
        signame: lc_ctrl_lc_owner_seed_sw_rw_en
        width: 1
        type: uni
        end_idx: -1
        act: req
        suffix: ""
        default: lc_ctrl_pkg::Off
      }
      {
        package: lc_ctrl_pkg
        struct: lc_tx
        signame: lc_ctrl_lc_seed_hw_rd_en
        width: 1
        type: uni
        end_idx: -1
        act: req
        suffix: ""
        default: lc_ctrl_pkg::Off
      }
      {
        package: otp_ctrl_macro_pkg
        struct: otp_ctrl_macro_req
        signame: otp_ctrl_otp_macro_req
        width: 1
        type: req_rsp
        end_idx: -1
        act: req
        suffix: req
        default: ""
      }
      {
        package: otp_ctrl_macro_pkg
        struct: otp_ctrl_macro_rsp
        signame: otp_ctrl_otp_macro_rsp
        width: 1
        type: req_rsp
        end_idx: -1
        act: req
        suffix: rsp
        default: "'0"
      }
      {
        package: ""
        struct: logic
        signame: rv_plic_msip
        width: 1
        type: uni
        end_idx: -1
        act: req
        suffix: ""
        default: "'0"
      }
      {
        package: ""
        struct: logic
        signame: rv_plic_irq
        width: 1
        type: uni
        end_idx: -1
        act: req
        suffix: ""
        default: "'0"
      }
      {
        package: ""
        struct: logic [rv_dm_reg_pkg::NrHarts-1:0]
        signame: rv_dm_debug_req
        width: 1
        type: uni
        end_idx: -1
        act: req
        suffix: ""
        default: "'0"
      }
      {
        package: rv_core_ibex_pkg
        struct: cpu_crash_dump
        signame: rv_core_ibex_crash_dump
        width: 1
        type: uni
        end_idx: -1
        act: req
        suffix: ""
        default: rv_core_ibex_pkg::CPU_CRASH_DUMP_DEFAULT
      }
      {
        package: rv_core_ibex_pkg
        struct: cpu_pwrmgr
        signame: rv_core_ibex_pwrmgr
        width: 1
        type: uni
        end_idx: -1
        act: req
        suffix: ""
        default: rv_core_ibex_pkg::CPU_PWRMGR_DEFAULT
      }
      {
        package: spi_device_pkg
        struct: passthrough_req
        signame: spi_device_passthrough_req
        width: 1
        type: req_rsp
        end_idx: -1
        act: req
        suffix: req
        default: ""
      }
      {
        package: spi_device_pkg
        struct: passthrough_rsp
        signame: spi_device_passthrough_rsp
        width: 1
        type: req_rsp
        end_idx: -1
        act: req
        suffix: rsp
        default: spi_device_pkg::PASSTHROUGH_RSP_DEFAULT
      }
      {
        package: ""
        struct: logic
        signame: rv_dm_ndmreset_req
        width: 1
        type: uni
        end_idx: -1
        act: req
        suffix: ""
        default: "'0"
      }
      {
        package: prim_mubi_pkg
        struct: mubi4
        signame: rstmgr_aon_sw_rst_req
        width: 1
        type: uni
        end_idx: -1
        act: req
        suffix: ""
        default: prim_mubi_pkg::MUBI4_DEFAULT
      }
      {
        package: tlul_pkg
        struct: tl_h2d
        signame: soc_proxy_dma_tl_h2d
        width: 1
        type: uni
        end_idx: -1
        act: rcv
        suffix: ""
        default: tlul_pkg::TL_H2D_DEFAULT
      }
      {
        package: tlul_pkg
        struct: tl_d2h
        signame: soc_proxy_dma_tl_d2h
        width: 1
        type: uni
        end_idx: -1
        act: req
        suffix: ""
        default: tlul_pkg::TL_D2H_DEFAULT
      }
      {
        package: tlul_pkg
        struct: tl_h2d
        signame: soc_proxy_ctn_tl_h2d
        width: 1
        type: uni
        end_idx: -1
        act: req
        suffix: ""
        default: tlul_pkg::TL_H2D_DEFAULT
      }
      {
        package: tlul_pkg
        struct: tl_d2h
        signame: soc_proxy_ctn_tl_d2h
        width: 1
        type: uni
        end_idx: -1
        act: rcv
        suffix: ""
        default: tlul_pkg::TL_D2H_DEFAULT
      }
      {
        package: ""
        struct: logic
        signame: pwrmgr_aon_wakeups
        width: 4
        type: uni
        end_idx: -1
        act: rcv
        suffix: ""
        default: "'0"
      }
      {
        package: ""
        struct: logic
        signame: pwrmgr_aon_rstreqs
        width: 2
        type: uni
        end_idx: -1
        act: rcv
        suffix: ""
        default: "'0"
      }
      {
        package: tlul_pkg
        struct: tl_h2d
        signame: main_tl_rv_core_ibex__corei_req
        width: 1
        type: req_rsp
        end_idx: -1
        act: rsp
        suffix: req
        default: tlul_pkg::TL_H2D_DEFAULT
      }
      {
        package: tlul_pkg
        struct: tl_d2h
        signame: main_tl_rv_core_ibex__corei_rsp
        width: 1
        type: req_rsp
        end_idx: -1
        act: rsp
        suffix: rsp
        default: ""
      }
      {
        package: tlul_pkg
        struct: tl_h2d
        signame: main_tl_rv_core_ibex__cored_req
        width: 1
        type: req_rsp
        end_idx: -1
        act: rsp
        suffix: req
        default: tlul_pkg::TL_H2D_DEFAULT
      }
      {
        package: tlul_pkg
        struct: tl_d2h
        signame: main_tl_rv_core_ibex__cored_rsp
        width: 1
        type: req_rsp
        end_idx: -1
        act: rsp
        suffix: rsp
        default: ""
      }
      {
        package: tlul_pkg
        struct: tl_h2d
        signame: main_tl_rv_dm__sba_req
        width: 1
        type: req_rsp
        end_idx: -1
        act: rsp
        suffix: req
        default: tlul_pkg::TL_H2D_DEFAULT
      }
      {
        package: tlul_pkg
        struct: tl_d2h
        signame: main_tl_rv_dm__sba_rsp
        width: 1
        type: req_rsp
        end_idx: -1
        act: rsp
        suffix: rsp
        default: ""
      }
      {
        package: tlul_pkg
        struct: tl_h2d
        signame: rv_dm_regs_tl_d_req
        width: 1
        type: req_rsp
        end_idx: -1
        act: rsp
        suffix: req
        default: tlul_pkg::TL_H2D_DEFAULT
      }
      {
        package: tlul_pkg
        struct: tl_d2h
        signame: rv_dm_regs_tl_d_rsp
        width: 1
        type: req_rsp
        end_idx: -1
        act: rsp
        suffix: rsp
        default: ""
      }
      {
        package: tlul_pkg
        struct: tl_h2d
        signame: rv_dm_mem_tl_d_req
        width: 1
        type: req_rsp
        end_idx: -1
        act: rsp
        suffix: req
        default: tlul_pkg::TL_H2D_DEFAULT
      }
      {
        package: tlul_pkg
        struct: tl_d2h
        signame: rv_dm_mem_tl_d_rsp
        width: 1
        type: req_rsp
        end_idx: -1
        act: rsp
        suffix: rsp
        default: ""
      }
      {
        package: tlul_pkg
        struct: tl_h2d
        signame: rom_ctrl0_rom_tl_req
        width: 1
        type: req_rsp
        end_idx: -1
        act: rsp
        suffix: req
        default: tlul_pkg::TL_H2D_DEFAULT
      }
      {
        package: tlul_pkg
        struct: tl_d2h
        signame: rom_ctrl0_rom_tl_rsp
        width: 1
        type: req_rsp
        end_idx: -1
        act: rsp
        suffix: rsp
        default: ""
      }
      {
        package: tlul_pkg
        struct: tl_h2d
        signame: rom_ctrl0_regs_tl_req
        width: 1
        type: req_rsp
        end_idx: -1
        act: rsp
        suffix: req
        default: tlul_pkg::TL_H2D_DEFAULT
      }
      {
        package: tlul_pkg
        struct: tl_d2h
        signame: rom_ctrl0_regs_tl_rsp
        width: 1
        type: req_rsp
        end_idx: -1
        act: rsp
        suffix: rsp
        default: ""
      }
      {
        package: tlul_pkg
        struct: tl_h2d
        signame: rom_ctrl1_rom_tl_req
        width: 1
        type: req_rsp
        end_idx: -1
        act: rsp
        suffix: req
        default: tlul_pkg::TL_H2D_DEFAULT
      }
      {
        package: tlul_pkg
        struct: tl_d2h
        signame: rom_ctrl1_rom_tl_rsp
        width: 1
        type: req_rsp
        end_idx: -1
        act: rsp
        suffix: rsp
        default: ""
      }
      {
        package: tlul_pkg
        struct: tl_h2d
        signame: rom_ctrl1_regs_tl_req
        width: 1
        type: req_rsp
        end_idx: -1
        act: rsp
        suffix: req
        default: tlul_pkg::TL_H2D_DEFAULT
      }
      {
        package: tlul_pkg
        struct: tl_d2h
        signame: rom_ctrl1_regs_tl_rsp
        width: 1
        type: req_rsp
        end_idx: -1
        act: rsp
        suffix: rsp
        default: ""
      }
      {
        package: tlul_pkg
        struct: tl_h2d
        signame: main_tl_peri_req
        width: 1
        type: req_rsp
        end_idx: -1
        act: req
        suffix: req
        default: ""
      }
      {
        package: tlul_pkg
        struct: tl_d2h
        signame: main_tl_peri_rsp
        width: 1
        type: req_rsp
        end_idx: -1
        act: req
        suffix: rsp
        default: tlul_pkg::TL_D2H_DEFAULT
      }
      {
        package: tlul_pkg
        struct: tl_h2d
        signame: soc_proxy_core_tl_req
        width: 1
        type: req_rsp
        end_idx: -1
        act: rsp
        suffix: req
        default: tlul_pkg::TL_H2D_DEFAULT
      }
      {
        package: tlul_pkg
        struct: tl_d2h
        signame: soc_proxy_core_tl_rsp
        width: 1
        type: req_rsp
        end_idx: -1
        act: rsp
        suffix: rsp
        default: ""
      }
      {
        package: tlul_pkg
        struct: tl_h2d
        signame: soc_proxy_ctn_tl_req
        width: 1
        type: req_rsp
        end_idx: -1
        act: rsp
        suffix: req
        default: tlul_pkg::TL_H2D_DEFAULT
      }
      {
        package: tlul_pkg
        struct: tl_d2h
        signame: soc_proxy_ctn_tl_rsp
        width: 1
        type: req_rsp
        end_idx: -1
        act: rsp
        suffix: rsp
        default: ""
      }
      {
        package: tlul_pkg
        struct: tl_h2d
        signame: hmac_tl_req
        width: 1
        type: req_rsp
        end_idx: -1
        act: rsp
        suffix: req
        default: tlul_pkg::TL_H2D_DEFAULT
      }
      {
        package: tlul_pkg
        struct: tl_d2h
        signame: hmac_tl_rsp
        width: 1
        type: req_rsp
        end_idx: -1
        act: rsp
        suffix: rsp
        default: ""
      }
      {
        package: tlul_pkg
        struct: tl_h2d
        signame: kmac_tl_req
        width: 1
        type: req_rsp
        end_idx: -1
        act: rsp
        suffix: req
        default: tlul_pkg::TL_H2D_DEFAULT
      }
      {
        package: tlul_pkg
        struct: tl_d2h
        signame: kmac_tl_rsp
        width: 1
        type: req_rsp
        end_idx: -1
        act: rsp
        suffix: rsp
        default: ""
      }
      {
        package: tlul_pkg
        struct: tl_h2d
        signame: aes_tl_req
        width: 1
        type: req_rsp
        end_idx: -1
        act: rsp
        suffix: req
        default: tlul_pkg::TL_H2D_DEFAULT
      }
      {
        package: tlul_pkg
        struct: tl_d2h
        signame: aes_tl_rsp
        width: 1
        type: req_rsp
        end_idx: -1
        act: rsp
        suffix: rsp
        default: ""
      }
      {
        package: tlul_pkg
        struct: tl_h2d
        signame: csrng_tl_req
        width: 1
        type: req_rsp
        end_idx: -1
        act: rsp
        suffix: req
        default: tlul_pkg::TL_H2D_DEFAULT
      }
      {
        package: tlul_pkg
        struct: tl_d2h
        signame: csrng_tl_rsp
        width: 1
        type: req_rsp
        end_idx: -1
        act: rsp
        suffix: rsp
        default: ""
      }
      {
        package: tlul_pkg
        struct: tl_h2d
        signame: edn0_tl_req
        width: 1
        type: req_rsp
        end_idx: -1
        act: rsp
        suffix: req
        default: tlul_pkg::TL_H2D_DEFAULT
      }
      {
        package: tlul_pkg
        struct: tl_d2h
        signame: edn0_tl_rsp
        width: 1
        type: req_rsp
        end_idx: -1
        act: rsp
        suffix: rsp
        default: ""
      }
      {
        package: tlul_pkg
        struct: tl_h2d
        signame: edn1_tl_req
        width: 1
        type: req_rsp
        end_idx: -1
        act: rsp
        suffix: req
        default: tlul_pkg::TL_H2D_DEFAULT
      }
      {
        package: tlul_pkg
        struct: tl_d2h
        signame: edn1_tl_rsp
        width: 1
        type: req_rsp
        end_idx: -1
        act: rsp
        suffix: rsp
        default: ""
      }
      {
        package: tlul_pkg
        struct: tl_h2d
        signame: rv_plic_tl_req
        width: 1
        type: req_rsp
        end_idx: -1
        act: rsp
        suffix: req
        default: tlul_pkg::TL_H2D_DEFAULT
      }
      {
        package: tlul_pkg
        struct: tl_d2h
        signame: rv_plic_tl_rsp
        width: 1
        type: req_rsp
        end_idx: -1
        act: rsp
        suffix: rsp
        default: ""
      }
      {
        package: tlul_pkg
        struct: tl_h2d
        signame: otbn_tl_req
        width: 1
        type: req_rsp
        end_idx: -1
        act: rsp
        suffix: req
        default: tlul_pkg::TL_H2D_DEFAULT
      }
      {
        package: tlul_pkg
        struct: tl_d2h
        signame: otbn_tl_rsp
        width: 1
        type: req_rsp
        end_idx: -1
        act: rsp
        suffix: rsp
        default: ""
      }
      {
        package: tlul_pkg
        struct: tl_h2d
        signame: keymgr_dpe_tl_req
        width: 1
        type: req_rsp
        end_idx: -1
        act: rsp
        suffix: req
        default: tlul_pkg::TL_H2D_DEFAULT
      }
      {
        package: tlul_pkg
        struct: tl_d2h
        signame: keymgr_dpe_tl_rsp
        width: 1
        type: req_rsp
        end_idx: -1
        act: rsp
        suffix: rsp
        default: ""
      }
      {
        package: tlul_pkg
        struct: tl_h2d
        signame: rv_core_ibex_cfg_tl_d_req
        width: 1
        type: req_rsp
        end_idx: -1
        act: rsp
        suffix: req
        default: tlul_pkg::TL_H2D_DEFAULT
      }
      {
        package: tlul_pkg
        struct: tl_d2h
        signame: rv_core_ibex_cfg_tl_d_rsp
        width: 1
        type: req_rsp
        end_idx: -1
        act: rsp
        suffix: rsp
        default: ""
      }
      {
        package: tlul_pkg
        struct: tl_h2d
        signame: sram_ctrl_main_regs_tl_req
        width: 1
        type: req_rsp
        end_idx: -1
        act: rsp
        suffix: req
        default: tlul_pkg::TL_H2D_DEFAULT
      }
      {
        package: tlul_pkg
        struct: tl_d2h
        signame: sram_ctrl_main_regs_tl_rsp
        width: 1
        type: req_rsp
        end_idx: -1
        act: rsp
        suffix: rsp
        default: ""
      }
      {
        package: tlul_pkg
        struct: tl_h2d
        signame: sram_ctrl_main_ram_tl_req
        width: 1
        type: req_rsp
        end_idx: -1
        act: rsp
        suffix: req
        default: tlul_pkg::TL_H2D_DEFAULT
      }
      {
        package: tlul_pkg
        struct: tl_d2h
        signame: sram_ctrl_main_ram_tl_rsp
        width: 1
        type: req_rsp
        end_idx: -1
        act: rsp
        suffix: rsp
        default: ""
      }
      {
        package: tlul_pkg
        struct: tl_h2d
        signame: sram_ctrl_mbox_regs_tl_req
        width: 1
        type: req_rsp
        end_idx: -1
        act: rsp
        suffix: req
        default: tlul_pkg::TL_H2D_DEFAULT
      }
      {
        package: tlul_pkg
        struct: tl_d2h
        signame: sram_ctrl_mbox_regs_tl_rsp
        width: 1
        type: req_rsp
        end_idx: -1
        act: rsp
        suffix: rsp
        default: ""
      }
      {
        package: tlul_pkg
        struct: tl_h2d
        signame: sram_ctrl_mbox_ram_tl_req
        width: 1
        type: req_rsp
        end_idx: -1
        act: rsp
        suffix: req
        default: tlul_pkg::TL_H2D_DEFAULT
      }
      {
        package: tlul_pkg
        struct: tl_d2h
        signame: sram_ctrl_mbox_ram_tl_rsp
        width: 1
        type: req_rsp
        end_idx: -1
        act: rsp
        suffix: rsp
        default: ""
      }
      {
        package: tlul_pkg
        struct: tl_h2d
        signame: dma_tl_d_req
        width: 1
        type: req_rsp
        end_idx: -1
        act: rsp
        suffix: req
        default: tlul_pkg::TL_H2D_DEFAULT
      }
      {
        package: tlul_pkg
        struct: tl_d2h
        signame: dma_tl_d_rsp
        width: 1
        type: req_rsp
        end_idx: -1
        act: rsp
        suffix: rsp
        default: ""
      }
      {
        package: tlul_pkg
        struct: tl_h2d
        signame: main_tl_dma__host_req
        width: 1
        type: req_rsp
        end_idx: -1
        act: rsp
        suffix: req
        default: tlul_pkg::TL_H2D_DEFAULT
      }
      {
        package: tlul_pkg
        struct: tl_d2h
        signame: main_tl_dma__host_rsp
        width: 1
        type: req_rsp
        end_idx: -1
        act: rsp
        suffix: rsp
        default: ""
      }
      {
        package: tlul_pkg
        struct: tl_h2d
        signame: mbx0_core_tl_d_req
        width: 1
        type: req_rsp
        end_idx: -1
        act: rsp
        suffix: req
        default: tlul_pkg::TL_H2D_DEFAULT
      }
      {
        package: tlul_pkg
        struct: tl_d2h
        signame: mbx0_core_tl_d_rsp
        width: 1
        type: req_rsp
        end_idx: -1
        act: rsp
        suffix: rsp
        default: ""
      }
      {
        package: tlul_pkg
        struct: tl_h2d
        signame: main_tl_mbx0__sram_req
        width: 1
        type: req_rsp
        end_idx: -1
        act: rsp
        suffix: req
        default: tlul_pkg::TL_H2D_DEFAULT
      }
      {
        package: tlul_pkg
        struct: tl_d2h
        signame: main_tl_mbx0__sram_rsp
        width: 1
        type: req_rsp
        end_idx: -1
        act: rsp
        suffix: rsp
        default: ""
      }
      {
        package: tlul_pkg
        struct: tl_h2d
        signame: mbx1_core_tl_d_req
        width: 1
        type: req_rsp
        end_idx: -1
        act: rsp
        suffix: req
        default: tlul_pkg::TL_H2D_DEFAULT
      }
      {
        package: tlul_pkg
        struct: tl_d2h
        signame: mbx1_core_tl_d_rsp
        width: 1
        type: req_rsp
        end_idx: -1
        act: rsp
        suffix: rsp
        default: ""
      }
      {
        package: tlul_pkg
        struct: tl_h2d
        signame: main_tl_mbx1__sram_req
        width: 1
        type: req_rsp
        end_idx: -1
        act: rsp
        suffix: req
        default: tlul_pkg::TL_H2D_DEFAULT
      }
      {
        package: tlul_pkg
        struct: tl_d2h
        signame: main_tl_mbx1__sram_rsp
        width: 1
        type: req_rsp
        end_idx: -1
        act: rsp
        suffix: rsp
        default: ""
      }
      {
        package: tlul_pkg
        struct: tl_h2d
        signame: mbx2_core_tl_d_req
        width: 1
        type: req_rsp
        end_idx: -1
        act: rsp
        suffix: req
        default: tlul_pkg::TL_H2D_DEFAULT
      }
      {
        package: tlul_pkg
        struct: tl_d2h
        signame: mbx2_core_tl_d_rsp
        width: 1
        type: req_rsp
        end_idx: -1
        act: rsp
        suffix: rsp
        default: ""
      }
      {
        package: tlul_pkg
        struct: tl_h2d
        signame: main_tl_mbx2__sram_req
        width: 1
        type: req_rsp
        end_idx: -1
        act: rsp
        suffix: req
        default: tlul_pkg::TL_H2D_DEFAULT
      }
      {
        package: tlul_pkg
        struct: tl_d2h
        signame: main_tl_mbx2__sram_rsp
        width: 1
        type: req_rsp
        end_idx: -1
        act: rsp
        suffix: rsp
        default: ""
      }
      {
        package: tlul_pkg
        struct: tl_h2d
        signame: mbx3_core_tl_d_req
        width: 1
        type: req_rsp
        end_idx: -1
        act: rsp
        suffix: req
        default: tlul_pkg::TL_H2D_DEFAULT
      }
      {
        package: tlul_pkg
        struct: tl_d2h
        signame: mbx3_core_tl_d_rsp
        width: 1
        type: req_rsp
        end_idx: -1
        act: rsp
        suffix: rsp
        default: ""
      }
      {
        package: tlul_pkg
        struct: tl_h2d
        signame: main_tl_mbx3__sram_req
        width: 1
        type: req_rsp
        end_idx: -1
        act: rsp
        suffix: req
        default: tlul_pkg::TL_H2D_DEFAULT
      }
      {
        package: tlul_pkg
        struct: tl_d2h
        signame: main_tl_mbx3__sram_rsp
        width: 1
        type: req_rsp
        end_idx: -1
        act: rsp
        suffix: rsp
        default: ""
      }
      {
        package: tlul_pkg
        struct: tl_h2d
        signame: mbx4_core_tl_d_req
        width: 1
        type: req_rsp
        end_idx: -1
        act: rsp
        suffix: req
        default: tlul_pkg::TL_H2D_DEFAULT
      }
      {
        package: tlul_pkg
        struct: tl_d2h
        signame: mbx4_core_tl_d_rsp
        width: 1
        type: req_rsp
        end_idx: -1
        act: rsp
        suffix: rsp
        default: ""
      }
      {
        package: tlul_pkg
        struct: tl_h2d
        signame: main_tl_mbx4__sram_req
        width: 1
        type: req_rsp
        end_idx: -1
        act: rsp
        suffix: req
        default: tlul_pkg::TL_H2D_DEFAULT
      }
      {
        package: tlul_pkg
        struct: tl_d2h
        signame: main_tl_mbx4__sram_rsp
        width: 1
        type: req_rsp
        end_idx: -1
        act: rsp
        suffix: rsp
        default: ""
      }
      {
        package: tlul_pkg
        struct: tl_h2d
        signame: mbx5_core_tl_d_req
        width: 1
        type: req_rsp
        end_idx: -1
        act: rsp
        suffix: req
        default: tlul_pkg::TL_H2D_DEFAULT
      }
      {
        package: tlul_pkg
        struct: tl_d2h
        signame: mbx5_core_tl_d_rsp
        width: 1
        type: req_rsp
        end_idx: -1
        act: rsp
        suffix: rsp
        default: ""
      }
      {
        package: tlul_pkg
        struct: tl_h2d
        signame: main_tl_mbx5__sram_req
        width: 1
        type: req_rsp
        end_idx: -1
        act: rsp
        suffix: req
        default: tlul_pkg::TL_H2D_DEFAULT
      }
      {
        package: tlul_pkg
        struct: tl_d2h
        signame: main_tl_mbx5__sram_rsp
        width: 1
        type: req_rsp
        end_idx: -1
        act: rsp
        suffix: rsp
        default: ""
      }
      {
        package: tlul_pkg
        struct: tl_h2d
        signame: mbx6_core_tl_d_req
        width: 1
        type: req_rsp
        end_idx: -1
        act: rsp
        suffix: req
        default: tlul_pkg::TL_H2D_DEFAULT
      }
      {
        package: tlul_pkg
        struct: tl_d2h
        signame: mbx6_core_tl_d_rsp
        width: 1
        type: req_rsp
        end_idx: -1
        act: rsp
        suffix: rsp
        default: ""
      }
      {
        package: tlul_pkg
        struct: tl_h2d
        signame: main_tl_mbx6__sram_req
        width: 1
        type: req_rsp
        end_idx: -1
        act: rsp
        suffix: req
        default: tlul_pkg::TL_H2D_DEFAULT
      }
      {
        package: tlul_pkg
        struct: tl_d2h
        signame: main_tl_mbx6__sram_rsp
        width: 1
        type: req_rsp
        end_idx: -1
        act: rsp
        suffix: rsp
        default: ""
      }
      {
        package: tlul_pkg
        struct: tl_h2d
        signame: mbx_jtag_core_tl_d_req
        width: 1
        type: req_rsp
        end_idx: -1
        act: rsp
        suffix: req
        default: tlul_pkg::TL_H2D_DEFAULT
      }
      {
        package: tlul_pkg
        struct: tl_d2h
        signame: mbx_jtag_core_tl_d_rsp
        width: 1
        type: req_rsp
        end_idx: -1
        act: rsp
        suffix: rsp
        default: ""
      }
      {
        package: tlul_pkg
        struct: tl_h2d
        signame: main_tl_mbx_jtag__sram_req
        width: 1
        type: req_rsp
        end_idx: -1
        act: rsp
        suffix: req
        default: tlul_pkg::TL_H2D_DEFAULT
      }
      {
        package: tlul_pkg
        struct: tl_d2h
        signame: main_tl_mbx_jtag__sram_rsp
        width: 1
        type: req_rsp
        end_idx: -1
        act: rsp
        suffix: rsp
        default: ""
      }
      {
        package: tlul_pkg
        struct: tl_h2d
        signame: mbx_pcie0_core_tl_d_req
        width: 1
        type: req_rsp
        end_idx: -1
        act: rsp
        suffix: req
        default: tlul_pkg::TL_H2D_DEFAULT
      }
      {
        package: tlul_pkg
        struct: tl_d2h
        signame: mbx_pcie0_core_tl_d_rsp
        width: 1
        type: req_rsp
        end_idx: -1
        act: rsp
        suffix: rsp
        default: ""
      }
      {
        package: tlul_pkg
        struct: tl_h2d
        signame: main_tl_mbx_pcie0__sram_req
        width: 1
        type: req_rsp
        end_idx: -1
        act: rsp
        suffix: req
        default: tlul_pkg::TL_H2D_DEFAULT
      }
      {
        package: tlul_pkg
        struct: tl_d2h
        signame: main_tl_mbx_pcie0__sram_rsp
        width: 1
        type: req_rsp
        end_idx: -1
        act: rsp
        suffix: rsp
        default: ""
      }
      {
        package: tlul_pkg
        struct: tl_h2d
        signame: mbx_pcie1_core_tl_d_req
        width: 1
        type: req_rsp
        end_idx: -1
        act: rsp
        suffix: req
        default: tlul_pkg::TL_H2D_DEFAULT
      }
      {
        package: tlul_pkg
        struct: tl_d2h
        signame: mbx_pcie1_core_tl_d_rsp
        width: 1
        type: req_rsp
        end_idx: -1
        act: rsp
        suffix: rsp
        default: ""
      }
      {
        package: tlul_pkg
        struct: tl_h2d
        signame: main_tl_mbx_pcie1__sram_req
        width: 1
        type: req_rsp
        end_idx: -1
        act: rsp
        suffix: req
        default: tlul_pkg::TL_H2D_DEFAULT
      }
      {
        package: tlul_pkg
        struct: tl_d2h
        signame: main_tl_mbx_pcie1__sram_rsp
        width: 1
        type: req_rsp
        end_idx: -1
        act: rsp
        suffix: rsp
        default: ""
      }
      {
        package: tlul_pkg
        struct: tl_h2d
        signame: uart0_tl_req
        width: 1
        type: req_rsp
        end_idx: -1
        act: rsp
        suffix: req
        default: tlul_pkg::TL_H2D_DEFAULT
      }
      {
        package: tlul_pkg
        struct: tl_d2h
        signame: uart0_tl_rsp
        width: 1
        type: req_rsp
        end_idx: -1
        act: rsp
        suffix: rsp
        default: ""
      }
      {
        package: tlul_pkg
        struct: tl_h2d
        signame: i2c0_tl_req
        width: 1
        type: req_rsp
        end_idx: -1
        act: rsp
        suffix: req
        default: tlul_pkg::TL_H2D_DEFAULT
      }
      {
        package: tlul_pkg
        struct: tl_d2h
        signame: i2c0_tl_rsp
        width: 1
        type: req_rsp
        end_idx: -1
        act: rsp
        suffix: rsp
        default: ""
      }
      {
        package: tlul_pkg
        struct: tl_h2d
        signame: gpio_tl_req
        width: 1
        type: req_rsp
        end_idx: -1
        act: rsp
        suffix: req
        default: tlul_pkg::TL_H2D_DEFAULT
      }
      {
        package: tlul_pkg
        struct: tl_d2h
        signame: gpio_tl_rsp
        width: 1
        type: req_rsp
        end_idx: -1
        act: rsp
        suffix: rsp
        default: ""
      }
      {
        package: tlul_pkg
        struct: tl_h2d
        signame: spi_host0_tl_req
        width: 1
        type: req_rsp
        end_idx: -1
        act: rsp
        suffix: req
        default: tlul_pkg::TL_H2D_DEFAULT
      }
      {
        package: tlul_pkg
        struct: tl_d2h
        signame: spi_host0_tl_rsp
        width: 1
        type: req_rsp
        end_idx: -1
        act: rsp
        suffix: rsp
        default: ""
      }
      {
        package: tlul_pkg
        struct: tl_h2d
        signame: spi_device_tl_req
        width: 1
        type: req_rsp
        end_idx: -1
        act: rsp
        suffix: req
        default: tlul_pkg::TL_H2D_DEFAULT
      }
      {
        package: tlul_pkg
        struct: tl_d2h
        signame: spi_device_tl_rsp
        width: 1
        type: req_rsp
        end_idx: -1
        act: rsp
        suffix: rsp
        default: ""
      }
      {
        package: tlul_pkg
        struct: tl_h2d
        signame: rv_timer_tl_req
        width: 1
        type: req_rsp
        end_idx: -1
        act: rsp
        suffix: req
        default: tlul_pkg::TL_H2D_DEFAULT
      }
      {
        package: tlul_pkg
        struct: tl_d2h
        signame: rv_timer_tl_rsp
        width: 1
        type: req_rsp
        end_idx: -1
        act: rsp
        suffix: rsp
        default: ""
      }
      {
        package: tlul_pkg
        struct: tl_h2d
        signame: pwrmgr_aon_tl_req
        width: 1
        type: req_rsp
        end_idx: -1
        act: rsp
        suffix: req
        default: tlul_pkg::TL_H2D_DEFAULT
      }
      {
        package: tlul_pkg
        struct: tl_d2h
        signame: pwrmgr_aon_tl_rsp
        width: 1
        type: req_rsp
        end_idx: -1
        act: rsp
        suffix: rsp
        default: ""
      }
      {
        package: tlul_pkg
        struct: tl_h2d
        signame: rstmgr_aon_tl_req
        width: 1
        type: req_rsp
        end_idx: -1
        act: rsp
        suffix: req
        default: tlul_pkg::TL_H2D_DEFAULT
      }
      {
        package: tlul_pkg
        struct: tl_d2h
        signame: rstmgr_aon_tl_rsp
        width: 1
        type: req_rsp
        end_idx: -1
        act: rsp
        suffix: rsp
        default: ""
      }
      {
        package: tlul_pkg
        struct: tl_h2d
        signame: clkmgr_aon_tl_req
        width: 1
        type: req_rsp
        end_idx: -1
        act: rsp
        suffix: req
        default: tlul_pkg::TL_H2D_DEFAULT
      }
      {
        package: tlul_pkg
        struct: tl_d2h
        signame: clkmgr_aon_tl_rsp
        width: 1
        type: req_rsp
        end_idx: -1
        act: rsp
        suffix: rsp
        default: ""
      }
      {
        package: tlul_pkg
        struct: tl_h2d
        signame: pinmux_aon_tl_req
        width: 1
        type: req_rsp
        end_idx: -1
        act: rsp
        suffix: req
        default: tlul_pkg::TL_H2D_DEFAULT
      }
      {
        package: tlul_pkg
        struct: tl_d2h
        signame: pinmux_aon_tl_rsp
        width: 1
        type: req_rsp
        end_idx: -1
        act: rsp
        suffix: rsp
        default: ""
      }
      {
        package: tlul_pkg
        struct: tl_h2d
        signame: otp_ctrl_core_tl_req
        width: 1
        type: req_rsp
        end_idx: -1
        act: rsp
        suffix: req
        default: tlul_pkg::TL_H2D_DEFAULT
      }
      {
        package: tlul_pkg
        struct: tl_d2h
        signame: otp_ctrl_core_tl_rsp
        width: 1
        type: req_rsp
        end_idx: -1
        act: rsp
        suffix: rsp
        default: ""
      }
      {
        package: tlul_pkg
        struct: tl_h2d
        signame: otp_macro_tl_req
        width: 1
        type: req_rsp
        end_idx: -1
        act: rsp
        suffix: req
        default: tlul_pkg::TL_H2D_DEFAULT
      }
      {
        package: tlul_pkg
        struct: tl_d2h
        signame: otp_macro_tl_rsp
        width: 1
        type: req_rsp
        end_idx: -1
        act: rsp
        suffix: rsp
        default: ""
      }
      {
        package: tlul_pkg
        struct: tl_h2d
        signame: lc_ctrl_regs_tl_req
        width: 1
        type: req_rsp
        end_idx: -1
        act: rsp
        suffix: req
        default: tlul_pkg::TL_H2D_DEFAULT
      }
      {
        package: tlul_pkg
        struct: tl_d2h
        signame: lc_ctrl_regs_tl_rsp
        width: 1
        type: req_rsp
        end_idx: -1
        act: rsp
        suffix: rsp
        default: ""
      }
      {
        package: tlul_pkg
        struct: tl_h2d
        signame: alert_handler_tl_req
        width: 1
        type: req_rsp
        end_idx: -1
        act: rsp
        suffix: req
        default: tlul_pkg::TL_H2D_DEFAULT
      }
      {
        package: tlul_pkg
        struct: tl_d2h
        signame: alert_handler_tl_rsp
        width: 1
        type: req_rsp
        end_idx: -1
        act: rsp
        suffix: rsp
        default: ""
      }
      {
        package: tlul_pkg
        struct: tl_h2d
        signame: sram_ctrl_ret_aon_regs_tl_req
        width: 1
        type: req_rsp
        end_idx: -1
        act: rsp
        suffix: req
        default: tlul_pkg::TL_H2D_DEFAULT
      }
      {
        package: tlul_pkg
        struct: tl_d2h
        signame: sram_ctrl_ret_aon_regs_tl_rsp
        width: 1
        type: req_rsp
        end_idx: -1
        act: rsp
        suffix: rsp
        default: ""
      }
      {
        package: tlul_pkg
        struct: tl_h2d
        signame: sram_ctrl_ret_aon_ram_tl_req
        width: 1
        type: req_rsp
        end_idx: -1
        act: rsp
        suffix: req
        default: tlul_pkg::TL_H2D_DEFAULT
      }
      {
        package: tlul_pkg
        struct: tl_d2h
        signame: sram_ctrl_ret_aon_ram_tl_rsp
        width: 1
        type: req_rsp
        end_idx: -1
        act: rsp
        suffix: rsp
        default: ""
      }
      {
        package: tlul_pkg
        struct: tl_h2d
        signame: aon_timer_aon_tl_req
        width: 1
        type: req_rsp
        end_idx: -1
        act: rsp
        suffix: req
        default: tlul_pkg::TL_H2D_DEFAULT
      }
      {
        package: tlul_pkg
        struct: tl_d2h
        signame: aon_timer_aon_tl_rsp
        width: 1
        type: req_rsp
        end_idx: -1
        act: rsp
        suffix: rsp
        default: ""
      }
      {
        package: tlul_pkg
        struct: tl_h2d
        signame: soc_dbg_ctrl_core_tl_req
        width: 1
        type: req_rsp
        end_idx: -1
        act: rsp
        suffix: req
        default: tlul_pkg::TL_H2D_DEFAULT
      }
      {
        package: tlul_pkg
        struct: tl_d2h
        signame: soc_dbg_ctrl_core_tl_rsp
        width: 1
        type: req_rsp
        end_idx: -1
        act: rsp
        suffix: rsp
        default: ""
      }
      {
        package: tlul_pkg
        struct: tl_h2d
        signame: mbx0_soc_tl_d_req
        width: 1
        type: req_rsp
        end_idx: -1
        act: rsp
        suffix: req
        default: tlul_pkg::TL_H2D_DEFAULT
      }
      {
        package: tlul_pkg
        struct: tl_d2h
        signame: mbx0_soc_tl_d_rsp
        width: 1
        type: req_rsp
        end_idx: -1
        act: rsp
        suffix: rsp
        default: ""
      }
      {
        package: tlul_pkg
        struct: tl_h2d
        signame: mbx1_soc_tl_d_req
        width: 1
        type: req_rsp
        end_idx: -1
        act: rsp
        suffix: req
        default: tlul_pkg::TL_H2D_DEFAULT
      }
      {
        package: tlul_pkg
        struct: tl_d2h
        signame: mbx1_soc_tl_d_rsp
        width: 1
        type: req_rsp
        end_idx: -1
        act: rsp
        suffix: rsp
        default: ""
      }
      {
        package: tlul_pkg
        struct: tl_h2d
        signame: mbx2_soc_tl_d_req
        width: 1
        type: req_rsp
        end_idx: -1
        act: rsp
        suffix: req
        default: tlul_pkg::TL_H2D_DEFAULT
      }
      {
        package: tlul_pkg
        struct: tl_d2h
        signame: mbx2_soc_tl_d_rsp
        width: 1
        type: req_rsp
        end_idx: -1
        act: rsp
        suffix: rsp
        default: ""
      }
      {
        package: tlul_pkg
        struct: tl_h2d
        signame: mbx3_soc_tl_d_req
        width: 1
        type: req_rsp
        end_idx: -1
        act: rsp
        suffix: req
        default: tlul_pkg::TL_H2D_DEFAULT
      }
      {
        package: tlul_pkg
        struct: tl_d2h
        signame: mbx3_soc_tl_d_rsp
        width: 1
        type: req_rsp
        end_idx: -1
        act: rsp
        suffix: rsp
        default: ""
      }
      {
        package: tlul_pkg
        struct: tl_h2d
        signame: mbx4_soc_tl_d_req
        width: 1
        type: req_rsp
        end_idx: -1
        act: rsp
        suffix: req
        default: tlul_pkg::TL_H2D_DEFAULT
      }
      {
        package: tlul_pkg
        struct: tl_d2h
        signame: mbx4_soc_tl_d_rsp
        width: 1
        type: req_rsp
        end_idx: -1
        act: rsp
        suffix: rsp
        default: ""
      }
      {
        package: tlul_pkg
        struct: tl_h2d
        signame: mbx5_soc_tl_d_req
        width: 1
        type: req_rsp
        end_idx: -1
        act: rsp
        suffix: req
        default: tlul_pkg::TL_H2D_DEFAULT
      }
      {
        package: tlul_pkg
        struct: tl_d2h
        signame: mbx5_soc_tl_d_rsp
        width: 1
        type: req_rsp
        end_idx: -1
        act: rsp
        suffix: rsp
        default: ""
      }
      {
        package: tlul_pkg
        struct: tl_h2d
        signame: mbx6_soc_tl_d_req
        width: 1
        type: req_rsp
        end_idx: -1
        act: rsp
        suffix: req
        default: tlul_pkg::TL_H2D_DEFAULT
      }
      {
        package: tlul_pkg
        struct: tl_d2h
        signame: mbx6_soc_tl_d_rsp
        width: 1
        type: req_rsp
        end_idx: -1
        act: rsp
        suffix: rsp
        default: ""
      }
      {
        package: tlul_pkg
        struct: tl_h2d
        signame: mbx_pcie0_soc_tl_d_req
        width: 1
        type: req_rsp
        end_idx: -1
        act: rsp
        suffix: req
        default: tlul_pkg::TL_H2D_DEFAULT
      }
      {
        package: tlul_pkg
        struct: tl_d2h
        signame: mbx_pcie0_soc_tl_d_rsp
        width: 1
        type: req_rsp
        end_idx: -1
        act: rsp
        suffix: rsp
        default: ""
      }
      {
        package: tlul_pkg
        struct: tl_h2d
        signame: mbx_pcie1_soc_tl_d_req
        width: 1
        type: req_rsp
        end_idx: -1
        act: rsp
        suffix: req
        default: tlul_pkg::TL_H2D_DEFAULT
      }
      {
        package: tlul_pkg
        struct: tl_d2h
        signame: mbx_pcie1_soc_tl_d_rsp
        width: 1
        type: req_rsp
        end_idx: -1
        act: rsp
        suffix: rsp
        default: ""
      }
      {
        package: tlul_pkg
        struct: tl_h2d
        signame: racl_ctrl_tl_req
        width: 1
        type: req_rsp
        end_idx: -1
        act: rsp
        suffix: req
        default: tlul_pkg::TL_H2D_DEFAULT
      }
      {
        package: tlul_pkg
        struct: tl_d2h
        signame: racl_ctrl_tl_rsp
        width: 1
        type: req_rsp
        end_idx: -1
        act: rsp
        suffix: rsp
        default: ""
      }
      {
        package: tlul_pkg
        struct: tl_h2d
        signame: ac_range_check_tl_req
        width: 1
        type: req_rsp
        end_idx: -1
        act: rsp
        suffix: req
        default: tlul_pkg::TL_H2D_DEFAULT
      }
      {
        package: tlul_pkg
        struct: tl_d2h
        signame: ac_range_check_tl_rsp
        width: 1
        type: req_rsp
        end_idx: -1
        act: rsp
        suffix: rsp
        default: ""
      }
      {
        package: tlul_pkg
        struct: tl_h2d
        signame: rv_dm_dbg_tl_d_req
        width: 1
        type: req_rsp
        end_idx: -1
        act: rsp
        suffix: req
        default: tlul_pkg::TL_H2D_DEFAULT
      }
      {
        package: tlul_pkg
        struct: tl_d2h
        signame: rv_dm_dbg_tl_d_rsp
        width: 1
        type: req_rsp
        end_idx: -1
        act: rsp
        suffix: rsp
        default: ""
      }
      {
        package: tlul_pkg
        struct: tl_h2d
        signame: mbx_jtag_soc_tl_d_req
        width: 1
        type: req_rsp
        end_idx: -1
        act: rsp
        suffix: req
        default: tlul_pkg::TL_H2D_DEFAULT
      }
      {
        package: tlul_pkg
        struct: tl_d2h
        signame: mbx_jtag_soc_tl_d_rsp
        width: 1
        type: req_rsp
        end_idx: -1
        act: rsp
        suffix: rsp
        default: ""
      }
      {
        package: tlul_pkg
        struct: tl_h2d
        signame: lc_ctrl_dmi_tl_req
        width: 1
        type: req_rsp
        end_idx: -1
        act: rsp
        suffix: req
        default: tlul_pkg::TL_H2D_DEFAULT
      }
      {
        package: tlul_pkg
        struct: tl_d2h
        signame: lc_ctrl_dmi_tl_rsp
        width: 1
        type: req_rsp
        end_idx: -1
        act: rsp
        suffix: rsp
        default: ""
      }
      {
        package: tlul_pkg
        struct: tl_h2d
        signame: soc_dbg_ctrl_jtag_tl_req
        width: 1
        type: req_rsp
        end_idx: -1
        act: rsp
        suffix: req
        default: tlul_pkg::TL_H2D_DEFAULT
      }
      {
        package: tlul_pkg
        struct: tl_d2h
        signame: soc_dbg_ctrl_jtag_tl_rsp
        width: 1
        type: req_rsp
        end_idx: -1
        act: rsp
        suffix: rsp
        default: ""
      }
      {
        package: top_racl_pkg
        struct: racl_policy_vec
        signame: racl_ctrl_racl_policies
        width: 1
        type: uni
        end_idx: -1
        act: req
        suffix: ""
        default: top_racl_pkg::RACL_POLICY_VEC_DEFAULT
      }
      {
        package: top_racl_pkg
        struct: racl_error_log
        signame: racl_ctrl_racl_error
        width:
        {
          name: NumSubscribingIps
          desc: Number of subscribing RACL IPs
          param_type: int
          unpacked_dimensions: null
          default: 11
          local: true
          expose: true
          name_top: RaclCtrlNumSubscribingIps
        }
        type: uni
        end_idx: -1
        act: rcv
        suffix: ""
        default: top_racl_pkg::RACL_ERROR_LOG_DEFAULT
      }
      {
        package: clkmgr_pkg
        struct: clkmgr_out
        signame: clkmgr_aon_clocks
        width: 1
        type: uni
        end_idx: -1
        default: ""
      }
      {
        package: clkmgr_pkg
        struct: clkmgr_cg_en
        signame: clkmgr_aon_cg_en
        width: 1
        type: uni
        end_idx: -1
        default: ""
      }
      {
        package: rstmgr_pkg
        struct: rstmgr_out
        signame: rstmgr_aon_resets
        width: 1
        type: uni
        end_idx: -1
        default: ""
      }
      {
        package: rstmgr_pkg
        struct: rstmgr_rst_en
        signame: rstmgr_aon_rst_en
        width: 1
        type: uni
        end_idx: -1
        default: ""
      }
      {
        package: ""
        struct: logic
        signame: rv_core_ibex_irq_timer
        width: 1
        type: uni
        end_idx: -1
        default: ""
      }
      {
        package: ""
        struct: logic
        signame: rv_core_ibex_hart_id
        width: 32
        type: uni
        end_idx: -1
        default: ""
      }
      {
        package: ""
        struct: logic
        signame: rv_core_ibex_boot_addr
        width: 32
        type: uni
        end_idx: -1
        default: ""
      }
      {
        package: otp_ctrl_part_pkg
        struct: otp_broadcast
        signame: otp_ctrl_otp_broadcast
        width: 1
        type: uni
        end_idx: -1
        default: "'0"
      }
      {
        package: lc_ctrl_state_pkg
        struct: soc_dbg_state
        signame: soc_dbg_ctrl_soc_dbg_state
        width: 1
        type: uni
        end_idx: -1
        default: ""
      }
      {
        package: otp_ctrl_pkg
        struct: otp_device_id
        signame: lc_ctrl_otp_device_id
        width: 1
        type: uni
        end_idx: -1
        default: "'0"
      }
      {
        package: otp_ctrl_pkg
        struct: otp_manuf_state
        signame: lc_ctrl_otp_manuf_state
        width: 1
        type: uni
        end_idx: -1
        default: "'0"
      }
      {
        package: otp_ctrl_pkg
        struct: otp_device_id
        signame: keymgr_dpe_otp_device_id
        width: 1
        type: uni
        end_idx: -1
        default: ""
      }
      {
        package: prim_mubi_pkg
        struct: mubi8
        signame: sram_ctrl_main_otp_en_sram_ifetch
        width: 1
        type: uni
        end_idx: -1
        default: prim_mubi_pkg::MuBi8False
      }
      {
        package: prim_mubi_pkg
        struct: mubi8
        signame: rv_dm_otp_dis_rv_dm_late_debug
        width: 1
        type: uni
        end_idx: -1
        default: prim_mubi_pkg::MuBi8False
      }
    ]
  }
}
