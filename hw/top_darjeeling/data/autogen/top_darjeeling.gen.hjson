// Copyright lowRISC contributors (OpenTitan project).
// Licensed under the Apache License, Version 2.0, see LICENSE for details.
// SPDX-License-Identifier: Apache-2.0
//
// ------------------- W A R N I N G: A U T O - G E N E R A T E D   C O D E !! -------------------//
// PLEASE DO NOT HAND-EDIT THIS FILE. IT HAS BEEN AUTO-GENERATED WITH THE FOLLOWING COMMAND:
// util/topgen.py -t hw/top_darjeeling/data/top_darjeeling.hjson
//                -o hw/top_darjeeling/
{
  name: darjeeling
  type: top
  datawidth: "32"
  racl_config: racl/racl.hjson
  power:
  {
    domains:
    [
      Aon
      Main
    ]
    default: Main
    wait_for_external_reset: true
    halt_ibex_via_rom_ctrl: true
  }
  unmanaged_clocks: {}
  clocks:
  {
    srcs:
    [
      {
        name: main
        aon: no
        freq: "1000000000"
        ref: false
      }
      {
        name: io
        aon: no
        freq: "250000000"
        ref: false
      }
      {
        name: aon
        aon: yes
        freq: "62500000"
        ref: true
      }
    ]
    derived_srcs: []
    groups:
    [
      {
        name: ast
        src: ext
        sw_cg: no
        unique: no
        clocks:
        {
          clk_main_i: main
          clk_io_i: io
          clk_aon_i: aon
        }
      }
      {
        name: powerup
        src: top
        sw_cg: no
        unique: no
        clocks:
        {
          clk_io_powerup: io
          clk_aon_powerup: aon
          clk_main_powerup: main
        }
      }
      {
        name: trans
        src: top
        sw_cg: hint
        unique: yes
        clocks:
        {
          clk_main_aes: main
          clk_main_hmac: main
          clk_main_kmac: main
          clk_main_otbn: main
        }
      }
      {
        name: infra
        src: top
        sw_cg: no
        unique: no
        clocks:
        {
          clk_io_infra: io
          clk_main_infra: main
          clk_aon_infra: aon
        }
      }
      {
        name: secure
        src: top
        sw_cg: no
        unique: no
        clocks:
        {
          clk_io_secure: io
          clk_main_secure: main
        }
      }
      {
        name: peri
        src: top
        sw_cg: yes
        unique: no
        clocks:
        {
          clk_io_peri: io
        }
      }
      {
        name: timers
        src: top
        sw_cg: no
        unique: no
        clocks:
        {
          clk_io_timers: io
          clk_aon_timers: aon
        }
      }
    ]
  }
  resets:
  {
    nodes:
    [
      {
        name: por_aon
        gen: false
        type: top
        domains:
        [
          Main
          Aon
        ]
        shadowed: false
        sw: false
        path: rst_por_aon_n
        clock: aon
      }
      {
        name: lc_src
        gen: false
        type: int
        domains: []
        shadowed: false
        sw: false
        path: ""
        clock: io
      }
      {
        name: sys_src
        gen: false
        type: int
        domains: []
        shadowed: false
        sw: false
        path: ""
        clock: io
      }
      {
        name: por
        gen: true
        type: top
        domains:
        [
          Aon
        ]
        shadowed: false
        sw: false
        path: rst_por_n
        parent: por_aon
        clock: main
      }
      {
        name: por_io
        gen: true
        type: top
        domains:
        [
          Aon
        ]
        shadowed: false
        sw: false
        path: rst_por_io_n
        parent: por_aon
        clock: io
      }
      {
        name: lc
        gen: true
        type: top
        domains:
        [
          Main
          Aon
        ]
        shadowed: true
        sw: false
        path: rst_lc_n
        parent: lc_src
        clock: main
      }
      {
        name: lc_aon
        gen: true
        type: top
        domains:
        [
          Aon
        ]
        shadowed: false
        sw: false
        path: rst_lc_aon_n
        parent: lc_src
        clock: aon
      }
      {
        name: lc_io
        gen: true
        type: top
        domains:
        [
          Main
          Aon
        ]
        shadowed: true
        sw: false
        path: rst_lc_io_n
        parent: lc_src
        clock: io
      }
      {
        name: sys
        gen: true
        type: top
        domains:
        [
          Main
        ]
        shadowed: false
        sw: false
        path: rst_sys_n
        parent: sys_src
        clock: main
      }
      {
        name: spi_device
        gen: true
        type: top
        domains:
        [
          Main
        ]
        shadowed: false
        sw: true
        path: rst_spi_device_n
        parent: lc_src
        clock: io
      }
      {
        name: spi_host0
        gen: true
        type: top
        domains:
        [
          Main
        ]
        shadowed: false
        sw: true
        path: rst_spi_host0_n
        parent: lc_src
        clock: io
      }
      {
        name: i2c0
        gen: true
        type: top
        domains:
        [
          Main
        ]
        shadowed: false
        sw: true
        path: rst_i2c0_n
        parent: lc_src
        clock: io
      }
    ]
  }
  reset_requests:
  {
    int:
    [
      {
        name: MainPwr
        desc: main power glitch reset request
        module: pwrmgr
      }
      {
        name: Esc
        desc: escalation reset request
        module: alert_handler
      }
    ]
    debug:
    [
      {
        name: Ndm
        desc: non-debug-module reset request
        module: rv_dm
      }
    ]
    peripheral:
    [
      {
        name: aon_timer_rst_req
        width: "1"
        module: aon_timer
        desc: Watchdog reset request.
        enabled_after_reset: false
      }
      {
        name: rst_req_external
        width: "1"
        module: soc_proxy
        desc: External reset request
        enabled_after_reset: true
      }
    ]
  }
  num_cores: "1"
  default_plic: rv_plic
  default_alert_handler: alert_handler
  addr_spaces:
  [
    {
      name: hart
      desc: The main address space, shared between the CPU and DM
      subspaces:
      [
        {
          name: mmio
          desc:
            '''
            MMIO region excludes any memory that is separate from the module configuration
            space, i.e. ROM, main SRAM, and mbx SRAM are excluded but retention SRAM or
            spi_device are included.
            '''
          nodes:
          [
            uart0
            gpio0
            spi_device
            i2c0
            rv_timer
            otp_ctrl
            lc_ctrl.regs
            alert_handler
            spi_host0
            pwrmgr
            rstmgr
            clkmgr
            pinmux
            aon_timer
            ast
            soc_proxy.core
            soc_dbg_ctrl.core
            sram_ctrl_ret
            rv_plic
            aes
            hmac
            otbn
            keymgr_dpe
            csrng
            entropy_src
            edn0
            edn1
            sram_ctrl_main.regs
            sram_ctrl_mbox.regs
            rom_ctrl0.regs
            rom_ctrl1.regs
            dma
            mbx0.core
            mbx1.core
            mbx2.core
            mbx3.core
            mbx4.core
            mbx5.core
            mbx6.core
            mbx_jtag.core
            mbx_pcie0.core
            mbx_pcie1.core
            rv_core_ibex
          ]
        }
      ]
    }
    {
      name: soc_mbx
      desc: SoC address space for mailbox access
    }
    {
      name: soc_dbg
      desc: SoC address space for debug module interfaces
    }
  ]
  module:
  [
    {
      name: uart0
      type: uart
      clock_srcs:
      {
        clk_i: io
      }
      clock_group: peri
      reset_connections:
      {
        rst_ni:
        {
          name: lc_io
          domain: Main
        }
      }
      domain: Main
      clock_connections:
      {
        clk_i: clkmgr_clocks_i.clk_io_peri
      }
      param_decl: {}
      memory: {}
      param_list: []
      inter_signal_list:
      [
        {
          name: lsio_trigger
          desc:
            '''
            Self-clearing status trigger for the DMA.
            Set when RX or TX FIFOs are past their configured watermarks matching watermark interrupt behaviour.
            '''
          struct: logic
          type: uni
          act: req
          width: 1
          inst_name: uart0
          default: ""
          package: ""
          end_idx: -1
          top_type: broadcast
          top_signame: uart0_lsio_trigger
          index: -1
          external: true
          conn_type: false
        }
        {
          name: racl_policies
          desc:
            '''
            Incoming RACL policy vector from a racl_ctrl instance.
            The policy selection vector (parameter) selects the policy for each register.
            '''
          struct: racl_policy_vec
          package: top_racl_pkg
          type: uni
          act: rcv
          width: 1
          inst_name: uart0
          index: -1
        }
        {
          name: racl_error
          desc: RACL error log information of this module.
          struct: racl_error_log
          package: top_racl_pkg
          type: uni
          act: req
          width: 1
          inst_name: uart0
          index: -1
        }
        {
          name: tl
          struct: tl
          package: tlul_pkg
          type: req_rsp
          act: rsp
          width: 1
          inst_name: uart0
          default: ""
          end_idx: -1
          top_type: one-to-one
          top_signame: uart0_tl
          index: -1
        }
      ]
      base_addrs:
      {
        null:
        {
          hart: 0x30010000
        }
      }
      generate_dif: true
    }
    {
      name: gpio0
      type: gpio
      template_type: gpio
      clock_srcs:
      {
        clk_i: io
      }
      clock_group: peri
      reset_connections:
      {
        rst_ni:
        {
          name: lc_io
          domain: Main
        }
      }
      param_decl:
      {
        GpioAsHwStrapsEn: "1"
        GpioAsyncOn: "1"
      }
      ipgen_params:
      {
        num_inp_period_counters: 8
      }
      attr: ipgen
      domain: Main
      clock_connections:
      {
        clk_i: clkmgr_clocks_i.clk_io_peri
      }
      memory: {}
      param_list:
      [
        {
          name: GpioAsyncOn
          desc: Instantiates 2-flop synchronizers on all GPIO inputs if set to 1.
          type: bit
          default: "1"
          local: "false"
          expose: "true"
          name_top: Gpio0GpioAsyncOn
        }
        {
          name: GpioAsHwStrapsEn
          desc: Enable HW straps sampling logic for GPIO inputs at initial cold boot
          type: bit
          default: "1"
          local: "false"
          expose: "true"
          name_top: Gpio0GpioAsHwStrapsEn
        }
      ]
      inter_signal_list:
      [
        {
          name: strap_en
          desc:
            '''
            The strap enable signal tells gpio to take a snapshot of the input pins.
            The behaviour of this signal after that event will have no effect.
            '''
          struct: logic
          type: uni
          act: rcv
          width: 1
          default: 1'b0
          inst_name: gpio0
          package: ""
          domain: Main
          top_signame: pwrmgr_strap
          index: -1
          external: true
          conn_type: false
        }
        {
          name: sampled_straps
          desc: This vector contains the sampled strap values.
          struct: gpio_straps
          package: gpio_pkg
          type: uni
          act: req
          width: 1
          default: "'0"
          inst_name: gpio0
          index: -1
        }
        {
          name: racl_policies
          desc:
            '''
            Incoming RACL policy vector from a racl_ctrl instance.
            The policy selection vector (parameter) selects the policy for each register.
            '''
          struct: racl_policy_vec
          package: top_racl_pkg
          type: uni
          act: rcv
          width: 1
          inst_name: gpio0
          index: -1
        }
        {
          name: racl_error
          desc: RACL error log information of this module.
          struct: racl_error_log
          package: top_racl_pkg
          type: uni
          act: req
          width: 1
          inst_name: gpio0
          index: -1
        }
        {
          name: tl
          struct: tl
          package: tlul_pkg
          type: req_rsp
          act: rsp
          width: 1
          inst_name: gpio0
          default: ""
          end_idx: -1
          top_type: one-to-one
          top_signame: gpio0_tl
          index: -1
        }
      ]
      base_addrs:
      {
        null:
        {
          hart: 0x30000000
        }
      }
      generate_dif: true
    }
    {
      name: spi_device
      type: spi_device
      clock_srcs:
      {
        clk_i: io
        scan_clk_i: io
      }
      clock_group: peri
      reset_connections:
      {
        rst_ni:
        {
          name: spi_device
          domain: Main
        }
      }
      param_decl:
      {
        SramType: spi_device_pkg::SramType1r1w
      }
      domain: Main
      clock_connections:
      {
        clk_i: clkmgr_clocks_i.clk_io_peri
        scan_clk_i: clkmgr_clocks_i.clk_io_peri
      }
      memory: {}
      param_list:
      [
        {
          name: SramType
          desc: Sram Entries. Word size is 32bit width.
          type: spi_device_pkg::sram_type_e
          default: spi_device_pkg::SramType1r1w
          local: "false"
          expose: "true"
          name_top: SpiDeviceSramType
        }
      ]
      inter_signal_list:
      [
        {
          name: ram_cfg_sys2spi
          struct: ram_1r1w_cfg
          package: prim_ram_1r1w_pkg
          type: req_rsp
          act: rsp
          width: 1
          inst_name: spi_device
          default: ""
          external: true
          conn_type: false
          index: -1
          top_signame: spi_device_sys2spi_ram_cfg
        }
        {
          name: ram_cfg_spi2sys
          struct: ram_1r1w_cfg
          package: prim_ram_1r1w_pkg
          type: req_rsp
          act: rsp
          width: 1
          inst_name: spi_device
          default: ""
          external: true
          conn_type: false
          index: -1
          top_signame: spi_device_spi2sys_ram_cfg
        }
        {
          name: passthrough
          struct: passthrough
          package: spi_device_pkg
          type: req_rsp
          act: req
          width: 1
          inst_name: spi_device
          default: ""
          end_idx: -1
          top_type: one-to-one
          top_signame: spi_device_passthrough
          index: -1
        }
        {
          name: mbist_en
          struct: logic
          type: uni
          act: rcv
          width: 1
          inst_name: spi_device
          index: -1
        }
        {
          name: sck_monitor
          struct: logic
          type: uni
          act: req
          width: 1
          inst_name: spi_device
          default: ""
          package: ""
          external: true
          conn_type: false
          index: -1
          top_signame: sck_monitor
        }
        {
          name: racl_policies
          desc:
            '''
            Incoming RACL policy vector from a racl_ctrl instance.
            The policy selection vector (parameter) selects the policy for each register.
            '''
          struct: racl_policy_vec
          package: top_racl_pkg
          type: uni
          act: rcv
          width: 1
          inst_name: spi_device
          index: -1
        }
        {
          name: racl_error
          desc: RACL error log information of this module.
          struct: racl_error_log
          package: top_racl_pkg
          type: uni
          act: req
          width: 1
          inst_name: spi_device
          index: -1
        }
        {
          name: tl
          struct: tl
          package: tlul_pkg
          type: req_rsp
          act: rsp
          width: 1
          inst_name: spi_device
          default: ""
          end_idx: -1
          top_type: one-to-one
          top_signame: spi_device_tl
          index: -1
        }
      ]
      base_addrs:
      {
        null:
        {
          hart: 0x30310000
        }
      }
      generate_dif: true
    }
    {
      name: i2c0
      type: i2c
      clock_srcs:
      {
        clk_i: io
      }
      clock_group: peri
      reset_connections:
      {
        rst_ni:
        {
          name: i2c0
          domain: Main
        }
      }
      domain: Main
      clock_connections:
      {
        clk_i: clkmgr_clocks_i.clk_io_peri
      }
      param_decl: {}
      memory: {}
      param_list:
      [
        {
          name: InputDelayCycles
          desc:
            '''
            Maximum number of cycles of propagation delay between a change on the cio_scl_en_o or cio_sda_en_o pins and sensing the new values on the corresponding input pins, not including the rise/fall times.
            For the purposes of this calculation, an input delay of 0 cycles means an output pin changing at the beginning of clock edge N will be sampled and observed on the input pins at clock edge N+1.
            '''
          type: int
          default: "0"
          local: "false"
          expose: "true"
          name_top: I2c0InputDelayCycles
        }
      ]
      inter_signal_list:
      [
        {
          name: ram_cfg
          struct: ram_1p_cfg
          package: prim_ram_1p_pkg
          type: req_rsp
          act: rsp
          width: 1
          inst_name: i2c0
          default: ""
          external: true
          conn_type: false
          index: -1
          top_signame: i2c0_ram_cfg
        }
        {
          name: lsio_trigger
          desc:
            '''
            Self-clearing status trigger for the DMA.
            Set when RX TX FIFO is past their configured watermark matching watermark interrupt behaviour.
            '''
          struct: logic
          type: uni
          act: req
          width: 1
          inst_name: i2c0
          default: ""
          package: ""
          end_idx: -1
          top_type: broadcast
          top_signame: i2c0_lsio_trigger
          index: -1
          external: true
          conn_type: false
        }
        {
          name: racl_policies
          desc:
            '''
            Incoming RACL policy vector from a racl_ctrl instance.
            The policy selection vector (parameter) selects the policy for each register.
            '''
          struct: racl_policy_vec
          package: top_racl_pkg
          type: uni
          act: rcv
          width: 1
          inst_name: i2c0
          index: -1
        }
        {
          name: racl_error
          desc: RACL error log information of this module.
          struct: racl_error_log
          package: top_racl_pkg
          type: uni
          act: req
          width: 1
          inst_name: i2c0
          index: -1
        }
        {
          name: tl
          struct: tl
          package: tlul_pkg
          type: req_rsp
          act: rsp
          width: 1
          inst_name: i2c0
          default: ""
          end_idx: -1
          top_type: one-to-one
          top_signame: i2c0_tl
          index: -1
        }
      ]
      base_addrs:
      {
        null:
        {
          hart: 0x30080000
        }
      }
      generate_dif: true
    }
    {
      name: rv_timer
      type: rv_timer
      clock_srcs:
      {
        clk_i: io
      }
      clock_group: timers
      reset_connections:
      {
        rst_ni:
        {
          name: lc_io
          domain: Main
        }
      }
      domain: Main
      clock_connections:
      {
        clk_i: clkmgr_clocks_i.clk_io_timers
      }
      param_decl: {}
      memory: {}
      param_list: []
      inter_signal_list:
      [
        {
          name: racl_policies
          desc:
            '''
            Incoming RACL policy vector from a racl_ctrl instance.
            The policy selection vector (parameter) selects the policy for each register.
            '''
          struct: racl_policy_vec
          package: top_racl_pkg
          type: uni
          act: rcv
          width: 1
          inst_name: rv_timer
          index: -1
        }
        {
          name: racl_error
          desc: RACL error log information of this module.
          struct: racl_error_log
          package: top_racl_pkg
          type: uni
          act: req
          width: 1
          inst_name: rv_timer
          index: -1
        }
        {
          name: tl
          struct: tl
          package: tlul_pkg
          type: req_rsp
          act: rsp
          width: 1
          inst_name: rv_timer
          default: ""
          end_idx: -1
          top_type: one-to-one
          top_signame: rv_timer_tl
          index: -1
        }
      ]
      base_addrs:
      {
        null:
        {
          hart: 0x30100000
        }
      }
      generate_dif: true
    }
    {
      name: otp_ctrl
      type: otp_ctrl
      template_type: otp_ctrl
      clock_srcs:
      {
        clk_i: io
        clk_edn_i: main
      }
      clock_group: secure
      reset_connections:
      {
        rst_ni:
        {
          name: lc_io
          domain: Main
        }
        rst_edn_ni:
        {
          name: lc
          domain: Main
        }
      }
      base_addrs:
      {
        core:
        {
          hart: 0x30130000
        }
      }
      attr: ipgen
      domain: Main
      clock_connections:
      {
        clk_i: clkmgr_clocks_i.clk_io_secure
        clk_edn_i: clkmgr_clocks_i.clk_main_secure
      }
      param_decl: {}
      memory: {}
      param_list: []
      inter_signal_list:
      [
        {
          name: edn
          desc: Entropy request to the entropy distribution network for LFSR reseeding and ephemeral key derivation.
          struct: edn
          package: edn_pkg
          type: req_rsp
          act: req
          width: 1
          inst_name: otp_ctrl
          default: ""
          domain: Main
          top_signame: edn0_edn
          index: 1
        }
        {
          name: pwr_otp
          desc: Initialization request/acknowledge from/to power manager.
          struct: pwr_otp
          package: pwrmgr_pkg
          type: req_rsp
          act: rsp
          width: 1
          default: "'0"
          inst_name: otp_ctrl
          domain: Main
          top_signame: pwrmgr_pwr_otp
          index: -1
          external: true
          conn_type: false
        }
        {
          name: lc_otp_program
          desc: Life cycle state transition interface.
          struct: lc_otp_program
          package: otp_ctrl_pkg
          type: req_rsp
          act: rsp
          width: 1
          default: "'0"
          inst_name: otp_ctrl
          domain: Main
          top_signame: lc_ctrl_lc_otp_program
          index: -1
        }
        {
          name: otp_lc_data
          desc:
            '''
            Life cycle state output holding the current life cycle state,
            the value of the transition counter and the tokens needed for life cycle transitions.
            '''
          struct: otp_lc_data
          package: otp_ctrl_pkg
          type: uni
          act: req
          width: 1
          default: "'0"
          inst_name: otp_ctrl
          end_idx: -1
          top_type: broadcast
          top_signame: otp_ctrl_otp_lc_data
          index: -1
        }
        {
          name: lc_escalate_en
          desc:
            '''
            Life cycle escalation enable coming from life cycle controller.
            This signal moves all FSMs within OTP into the error state.
            '''
          struct: lc_tx
          package: lc_ctrl_pkg
          type: uni
          act: rcv
          width: 1
          default: lc_ctrl_pkg::Off
          inst_name: otp_ctrl
          domain: Main
          top_signame: lc_ctrl_lc_escalate_en
          index: -1
        }
        {
          name: lc_creator_seed_sw_rw_en
          desc:
            '''
            Provision enable qualifier coming from life cycle controller.
            This signal enables SW read / write access to the RMA_TOKEN and CREATOR_ROOT_KEY_SHARE0 and CREATOR_ROOT_KEY_SHARE1.
            '''
          struct: lc_tx
          package: lc_ctrl_pkg
          type: uni
          act: rcv
          width: 1
          default: lc_ctrl_pkg::Off
          inst_name: otp_ctrl
          domain: Main
          top_signame: lc_ctrl_lc_creator_seed_sw_rw_en
          index: -1
        }
        {
          name: lc_owner_seed_sw_rw_en
          desc:
            '''
            Provision enable qualifier coming from life cycle controller.
            This signal enables SW read / write access to the OWNER_SEED.
            '''
          struct: lc_tx
          package: lc_ctrl_pkg
          type: uni
          act: rcv
          width: 1
          default: lc_ctrl_pkg::Off
          inst_name: otp_ctrl
          domain: Main
          top_signame: lc_ctrl_lc_owner_seed_sw_rw_en
          index: -1
        }
        {
          name: lc_seed_hw_rd_en
          desc:
            '''
            Seed read enable coming from life cycle controller.
            This signal enables HW read access to the:
            - CREATOR_ROOT_KEY_SHARE0 and CREATOR_ROOT_KEY_SHARE1
            '''
          struct: lc_tx
          package: lc_ctrl_pkg
          type: uni
          act: rcv
          width: 1
          default: lc_ctrl_pkg::Off
          inst_name: otp_ctrl
          domain: Main
          top_signame: lc_ctrl_lc_seed_hw_rd_en
          index: -1
        }
        {
          name: lc_rma_state
          desc:
            '''
            This signal states whether the current life cycle is RMA.
            It is used to enable SW read access to (read-locked) partitions in the RMA state.
            '''
          struct: lc_tx
          package: lc_ctrl_pkg
          type: uni
          act: rcv
          width: 1
          default: lc_ctrl_pkg::Off
          inst_name: otp_ctrl
          domain: Main
          top_signame: lc_ctrl_lc_rma_state
          index: -1
        }
        {
          name: lc_check_byp_en
          desc:
            '''
            Life cycle partition check bypass signal.
            This signal causes the life cycle partition to bypass consistency checks during life cycle state transitions in order to prevent spurious consistency check failures.
            '''
          struct: lc_tx
          package: lc_ctrl_pkg
          type: uni
          act: rcv
          width: 1
          default: lc_ctrl_pkg::Off
          inst_name: otp_ctrl
          domain: Main
          top_signame: lc_ctrl_lc_check_byp_en
          index: -1
        }
        {
          name: keymgr_creator_root_key
          desc: Key output to the key manager holding CREATOR_ROOT_KEY_SHARE0 and CREATOR_ROOT_KEY_SHARE1.
          struct: keymgr_dpe_creator_root_key
          package: keymgr_dpe_pkg
          type: uni
          act: req
          width: 1
          default: "'0"
          inst_name: otp_ctrl
          end_idx: -1
          top_type: broadcast
          top_signame: otp_ctrl_keymgr_creator_root_key
          index: -1
        }
        {
          name: keymgr_creator_seed
          desc: Creator seed output to the key manager
          struct: keymgr_dpe_creator_seed
          package: keymgr_dpe_pkg
          type: uni
          act: req
          width: 1
          default: "'0"
          inst_name: otp_ctrl
          end_idx: -1
          top_type: broadcast
          top_signame: otp_ctrl_keymgr_creator_seed
          index: -1
        }
        {
          name: keymgr_owner_seed
          desc: Owner seed output to the key manager
          struct: keymgr_dpe_owner_seed
          package: keymgr_dpe_pkg
          type: uni
          act: req
          width: 1
          default: "'0"
          inst_name: otp_ctrl
          end_idx: -1
          top_type: broadcast
          top_signame: otp_ctrl_keymgr_owner_seed
          index: -1
        }
        {
          name: sram_otp_key
          desc: Array with key derivation interfaces for SRAM scrambling devices.
          struct: sram_otp_key
          package: otp_ctrl_pkg
          type: req_rsp
          act: rsp
          width: 4
          default: "'0"
          inst_name: otp_ctrl
          end_idx: -1
          top_type: one-to-N
          top_signame: otp_ctrl_sram_otp_key
          index: 1
          external: true
          conn_type: true
        }
        {
          name: otbn_otp_key
          desc: Key derivation interface for OTBN scrambling devices.
          struct: otbn_otp_key
          package: otp_ctrl_pkg
          type: req_rsp
          act: rsp
          width: 1
          default: "'0"
          inst_name: otp_ctrl
          end_idx: -1
          top_type: one-to-one
          top_signame: otp_ctrl_otbn_otp_key
          index: -1
        }
        {
          name: otp_broadcast
          desc: Output of the HW partitions with breakout data types.
          struct: otp_broadcast
          package: otp_ctrl_part_pkg
          type: uni
          act: req
          width: 1
          default: "'0"
          inst_name: otp_ctrl
          top_signame: otp_ctrl_otp_broadcast
          index: -1
        }
        {
          name: otp_macro
          desc: Data interface for the OTP macro.
          struct: otp_ctrl_macro
          package: otp_ctrl_macro_pkg
          type: req_rsp
          act: req
          width: 1
          default: "'0"
          inst_name: otp_ctrl
          end_idx: -1
          top_type: one-to-one
          top_signame: otp_ctrl_otp_macro
          index: -1
        }
        {
          name: core_tl
          struct: tl
          package: tlul_pkg
          type: req_rsp
          act: rsp
          width: 1
          inst_name: otp_ctrl
          default: ""
          end_idx: -1
          top_type: one-to-one
          top_signame: otp_ctrl_core_tl
          index: -1
        }
      ]
      generate_dif: true
    }
    {
      name: otp_macro
      type: otp_macro
      clock_srcs:
      {
        clk_i: io
      }
      clock_group: secure
      reset_connections:
      {
        rst_ni:
        {
          name: lc_io
          domain: Main
        }
      }
      base_addrs:
      {
        prim:
        {
          hart: 0x30140000
        }
      }
      param_decl:
      {
        Width: otp_ctrl_macro_pkg::OtpWidth
        Depth: otp_ctrl_macro_pkg::OtpDepth
        SizeWidth: otp_ctrl_macro_pkg::OtpSizeWidth
        VendorTestOffset: otp_ctrl_reg_pkg::VendorTestOffset
        VendorTestSize: otp_ctrl_reg_pkg::VendorTestSize
      }
      domain: Main
      clock_connections:
      {
        clk_i: clkmgr_clocks_i.clk_io_secure
      }
      memory: {}
      param_list:
      [
        {
          name: Width
          desc: Size of storage words in bits
          type: int
          default: otp_ctrl_macro_pkg::OtpWidth
          local: "false"
          expose: "false"
          name_top: OtpMacroWidth
        }
        {
          name: Depth
          desc: Number of words
          type: int
          default: otp_ctrl_macro_pkg::OtpDepth
          local: "false"
          expose: "false"
          name_top: OtpMacroDepth
        }
        {
          name: SizeWidth
          desc: Number of words transferred per access
          type: int
          default: otp_ctrl_macro_pkg::OtpSizeWidth
          local: "false"
          expose: "false"
          name_top: OtpMacroSizeWidth
        }
        {
          name: MemInitFile
          desc: ""
          type: ""
          default: '''""'''
          local: "false"
          expose: "true"
          name_top: OtpMacroMemInitFile
        }
        {
          name: VendorTestOffset
          desc: ""
          type: int
          default: otp_ctrl_reg_pkg::VendorTestOffset
          local: "false"
          expose: "false"
          name_top: OtpMacroVendorTestOffset
        }
        {
          name: VendorTestSize
          desc: ""
          type: int
          default: otp_ctrl_reg_pkg::VendorTestSize
          local: "false"
          expose: "false"
          name_top: OtpMacroVendorTestSize
        }
      ]
      inter_signal_list:
      [
        {
          name: obs_ctrl
          desc: AST observability control signals.
          struct: ast_obs_ctrl
          package: ast_pkg
          type: uni
          act: rcv
          width: 1
          inst_name: otp_macro
          default: ""
          domain: Main
          top_signame: ast_obs_ctrl
          index: -1
        }
        {
          name: otp_obs
          desc: AST observability bus.
          struct: logic
          type: uni
          act: req
          width: 8
          inst_name: otp_macro
          default: ""
          package: ""
          external: true
          conn_type: false
          index: -1
          top_signame: otp_obs
        }
        {
          name: pwr_seq
          desc: Power sequencing signals to AST (VDD domain).
          struct: pwr_seq
          package: otp_macro_pkg
          type: uni
          act: req
          width: 1
          default: "'0"
          inst_name: otp_macro
          external: true
          conn_type: false
          index: -1
          top_signame: otp_macro_pwr_seq
        }
        {
          name: pwr_seq_h
          desc: Power sequencing signals coming from AST (VCC domain).
          struct: pwr_seq
          package: otp_macro_pkg
          type: uni
          act: rcv
          width: 1
          default: "'0"
          inst_name: otp_macro
          external: true
          conn_type: false
          index: -1
          top_signame: otp_macro_pwr_seq_h
        }
        {
          name: ext_voltage_h
          struct: ""
          type: io
          act: none
          width: 1
          default: "'0"
          inst_name: otp_macro
          package: ""
          external: true
          conn_type: false
          index: -1
          top_signame: otp_ext_voltage_h
        }
        {
          name: lc_dft_en
          desc:
            '''
            Test enable qualifier coming from life cycle controller.
            This signals enables the TL-UL access port.
            '''
          struct: lc_tx
          package: lc_ctrl_pkg
          type: uni
          act: rcv
          width: 1
          default: lc_ctrl_pkg::Off
          inst_name: otp_macro
          domain: Main
          top_signame: lc_ctrl_lc_dft_en
          index: -1
        }
        {
          name: test
          desc: Vendor test control signals from/to the life cycle TAP.
          struct: otp_test
          package: otp_macro_pkg
          type: req_rsp
          act: rsp
          width: 1
          default: "'0"
          inst_name: otp_macro
          domain: Main
          top_signame: lc_ctrl_lc_otp_vendor_test
          index: -1
        }
        {
          name: otp
          desc: Data interface for the OTP macro.
          struct: otp_ctrl_macro
          package: otp_ctrl_macro_pkg
          type: req_rsp
          act: rsp
          width: 1
          default: "'0"
          inst_name: otp_macro
          domain: Main
          top_signame: otp_ctrl_otp_macro
          index: -1
        }
        {
          name: cfg
          struct: otp_cfg
          package: otp_macro_pkg
          type: uni
          act: rcv
          width: 1
          default: "'0"
          inst_name: otp_macro
          external: true
          conn_type: false
          index: -1
          top_signame: otp_cfg
        }
        {
          name: cfg_rsp
          struct: otp_cfg_rsp
          package: otp_macro_pkg
          type: uni
          act: req
          width: 1
          default: "'0"
          inst_name: otp_macro
          index: -1
        }
        {
          name: racl_policies
          desc:
            '''
            Incoming RACL policy vector from a racl_ctrl instance.
            The policy selection vector (parameter) selects the policy for each register.
            '''
          struct: racl_policy_vec
          package: top_racl_pkg
          type: uni
          act: rcv
          width: 1
          inst_name: otp_macro
          index: -1
        }
        {
          name: racl_error
          desc: RACL error log information of this module.
          struct: racl_error_log
          package: top_racl_pkg
          type: uni
          act: req
          width: 1
          inst_name: otp_macro
          index: -1
        }
        {
          name: prim_tl
          struct: tl
          package: tlul_pkg
          type: req_rsp
          act: rsp
          width: 1
          inst_name: otp_macro
          default: ""
          end_idx: -1
          top_type: one-to-one
          top_signame: otp_macro_prim_tl
          index: -1
        }
      ]
      generate_dif: true
    }
    {
      name: lc_ctrl
      type: lc_ctrl
      clock_srcs:
      {
        clk_i: io
        clk_kmac_i: main
      }
      clock_group: secure
      reset_connections:
      {
        rst_ni:
        {
          name: lc_io
          domain: Main
        }
        rst_kmac_ni:
        {
          name: lc
          domain: Main
        }
      }
      base_addrs:
      {
        regs:
        {
          hart: 0x30150000
        }
        dmi:
        {
          soc_dbg: 0x3000
        }
      }
      param_decl:
      {
        SecVolatileRawUnlockEn: top_pkg::SecVolatileRawUnlockEn
        SiliconCreatorId: 16'h 4002
        ProductId: 16'h 4000
        RevisionId: 8'h 01
        UseDmiInterface: "1"
        NumRmaAckSigs: "1"
        EscNumSeverities: AlertHandlerEscNumSeverities
        EscPingCountWidth: AlertHandlerEscPingCountWidth
      }
      domain: Main
      clock_connections:
      {
        clk_i: clkmgr_clocks_i.clk_io_secure
        clk_kmac_i: clkmgr_clocks_i.clk_main_secure
      }
      memory: {}
      param_list:
      [
        {
          name: SecVolatileRawUnlockEn
          desc:
            '''
            Disable (0) or enable (1) volatile RAW UNLOCK capability.
            If enabled, it is possible to perform a volatile RAW -> TEST_UNLOCKED0 transition
            without programming the OTP. This is a useful fallback mode in case the OTP is
            not working correctly.

            IMPORTANT NOTE: This should only be used in test chips. The parameter must be set
            to 0 in production tapeouts since this weakens the security posture of the RAW
            UNLOCK mechanism.
            '''
          type: bit
          default: top_pkg::SecVolatileRawUnlockEn
          local: "false"
          expose: "true"
          name_top: SecLcCtrlVolatileRawUnlockEn
        }
        {
          name: UseDmiInterface
          desc: When 1, a TLUL-based DMI interface is used. When 0, a JTAG TAP is used.
          type: bit
          default: "1"
          local: "false"
          expose: "true"
          name_top: LcCtrlUseDmiInterface
        }
        {
          name: SiliconCreatorId
          desc: Chip generation number.
          type: logic [15:0]
          default: 16'h 4002
          local: "false"
          expose: "true"
          name_top: LcCtrlSiliconCreatorId
        }
        {
          name: ProductId
          desc: Chip revision number.
          type: logic [15:0]
          default: 16'h 4000
          local: "false"
          expose: "true"
          name_top: LcCtrlProductId
        }
        {
          name: RevisionId
          desc: Chip revision number.
          type: logic [7:0]
          default: 8'h 01
          local: "false"
          expose: "true"
          name_top: LcCtrlRevisionId
        }
        {
          name: IdcodeValue
          desc: JTAG ID code.
          type: logic [31:0]
          default: 32'h00000001
          local: "false"
          expose: "true"
          name_top: LcCtrlIdcodeValue
        }
        {
          name: NumRmaAckSigs
          desc: Number of NVM RMA wiping response signals
          type: int
          default: "1"
          local: "true"
          expose: "true"
          name_top: LcCtrlNumRmaAckSigs
        }
        {
          name: EscNumSeverities
          desc: Number of escalation severities
          type: int
          default: AlertHandlerEscNumSeverities
          local: "false"
          expose: "false"
          name_top: LcCtrlEscNumSeverities
        }
        {
          name: EscPingCountWidth
          desc: Width of ping count for the escalation receiver
          type: int
          default: AlertHandlerEscPingCountWidth
          local: "false"
          expose: "false"
          name_top: LcCtrlEscPingCountWidth
        }
      ]
      inter_signal_list:
      [
        {
          name: jtag
          struct: jtag
          package: jtag_pkg
          type: req_rsp
          act: rsp
          width: 1
          inst_name: lc_ctrl
          index: -1
        }
        {
          name: esc_scrap_state0_tx
          struct: esc_tx
          package: prim_esc_pkg
          type: uni
          act: rcv
          width: 1
          inst_name: lc_ctrl
          default: ""
          domain: Main
          top_signame: alert_handler_esc_tx
          index: 1
        }
        {
          name: esc_scrap_state0_rx
          struct: esc_rx
          package: prim_esc_pkg
          type: uni
          act: req
          width: 1
          inst_name: lc_ctrl
          default: ""
          domain: Main
          top_signame: alert_handler_esc_rx
          index: 1
        }
        {
          name: esc_scrap_state1_tx
          struct: esc_tx
          package: prim_esc_pkg
          type: uni
          act: rcv
          width: 1
          inst_name: lc_ctrl
          default: ""
          domain: Main
          top_signame: alert_handler_esc_tx
          index: 2
        }
        {
          name: esc_scrap_state1_rx
          struct: esc_rx
          package: prim_esc_pkg
          type: uni
          act: req
          width: 1
          inst_name: lc_ctrl
          default: ""
          domain: Main
          top_signame: alert_handler_esc_rx
          index: 2
        }
        {
          name: pwr_lc
          struct: pwr_lc
          package: lc_ctrl_pkg
          type: req_rsp
          act: rsp
          width: 1
          inst_name: lc_ctrl
          default: ""
          domain: Main
          top_signame: pwrmgr_pwr_lc
          index: -1
          external: true
          conn_type: false
        }
        {
          name: lc_otp_vendor_test
          struct: otp_test
          package: otp_macro_pkg
          type: req_rsp
          act: req
          width: 1
          default: "'0"
          inst_name: lc_ctrl
          end_idx: -1
          top_type: one-to-one
          top_signame: lc_ctrl_lc_otp_vendor_test
          index: -1
        }
        {
          name: otp_lc_data
          struct: otp_lc_data
          package: otp_ctrl_pkg
          type: uni
          act: rcv
          width: 1
          default: otp_ctrl_pkg::OTP_LC_DATA_DEFAULT
          inst_name: lc_ctrl
          domain: Main
          top_signame: otp_ctrl_otp_lc_data
          index: -1
        }
        {
          name: lc_otp_program
          struct: lc_otp_program
          package: otp_ctrl_pkg
          type: req_rsp
          act: req
          width: 1
          default: "'0"
          inst_name: lc_ctrl
          end_idx: -1
          top_type: one-to-one
          top_signame: lc_ctrl_lc_otp_program
          index: -1
        }
        {
          name: kmac_data
          struct: app
          package: kmac_pkg
          type: req_rsp
          act: req
          width: 1
          default: "'0"
          inst_name: lc_ctrl
          domain: Main
          top_signame: kmac_app
          index: 1
        }
        {
          name: lc_init_done
          desc:
            '''
            Indicates that life cycle initialization is complete and the broadcast signals are valid; see `INIT_DONE` in the Theory of Operation doc for details.
            This signal is Off while lc_ctrl is in reset.
            Once On, it stays On until lc_ctrl is reset.
            '''
          struct: lc_tx
          package: lc_ctrl_pkg
          type: uni
          act: req
          width: 1
          default: lc_ctrl_pkg::Off
          inst_name: lc_ctrl
          end_idx: -1
          top_type: broadcast
          top_signame: lc_ctrl_lc_init_done
          index: -1
        }
        {
          name: lc_raw_test_rma
          struct: lc_tx
          package: lc_ctrl_pkg
          type: uni
          act: req
          width: 1
          default: lc_ctrl_pkg::Off
          inst_name: lc_ctrl
          end_idx: -1
          top_type: broadcast
          top_signame: lc_ctrl_lc_raw_test_rma
          index: -1
        }
        {
          name: lc_dft_en
          struct: lc_tx
          package: lc_ctrl_pkg
          type: uni
          act: req
          width: 1
          default: lc_ctrl_pkg::Off
          inst_name: lc_ctrl
          end_idx: -1
          top_type: broadcast
          top_signame: lc_ctrl_lc_dft_en
          index: -1
          external: true
          conn_type: true
        }
        {
          name: lc_nvm_debug_en
          struct: lc_tx
          package: lc_ctrl_pkg
          type: uni
          act: req
          width: 1
          default: lc_ctrl_pkg::Off
          inst_name: lc_ctrl
          index: -1
        }
        {
          name: lc_hw_debug_clr
          desc:
            '''
            Clear HW debug functionality; see `HW_DEBUG_CLR` in the Theory of Operation doc for details.

            This signal is used to clear stored copies of `lc_hw_debug_en` when HW debug functionality gets disabled outside a reset of `lc_ctrl`.
            This signal is On in the SCRAP, INVALID, POST_TRANSITION and ESCALATION states, in which `lc_hw_debug_en` is Off.
            Once On, it remains On until lc_ctrl is reset.
            Flops storing the value of `lc_hw_debug_en` (see below) must be cleared whenever this signal is not Off.
            '''
          struct: lc_tx
          package: lc_ctrl_pkg
          type: uni
          act: req
          width: 1
          default: lc_ctrl_pkg::Off
          inst_name: lc_ctrl
          end_idx: -1
          top_type: broadcast
          top_signame: lc_ctrl_lc_hw_debug_clr
          index: -1
        }
        {
          name: lc_hw_debug_en
          desc:
            '''
            Enable HW debug functionality; see `HW_DEBUG_EN` in the Theory of Operation doc for details.

            This signal is Off while lc_ctrl is in reset.
            In order to prevent a JTAG disconnect during non-debug-module (NDM) reset, this signal should be flopped outside the NDM reset domain.
            Such a flop must be cleared whenever `lc_hw_debug_clr` is not Off; see above.
            '''
          struct: lc_tx
          package: lc_ctrl_pkg
          type: uni
          act: req
          width: 1
          default: lc_ctrl_pkg::Off
          inst_name: lc_ctrl
          end_idx: -1
          top_type: broadcast
          top_signame: lc_ctrl_lc_hw_debug_en
          index: -1
          external: true
          conn_type: true
        }
        {
          name: lc_cpu_en
          struct: lc_tx
          package: lc_ctrl_pkg
          type: uni
          act: req
          width: 1
          default: lc_ctrl_pkg::Off
          inst_name: lc_ctrl
          end_idx: -1
          top_type: broadcast
          top_signame: lc_ctrl_lc_cpu_en
          index: -1
        }
        {
          name: lc_keymgr_en
          struct: lc_tx
          package: lc_ctrl_pkg
          type: uni
          act: req
          width: 1
          default: lc_ctrl_pkg::Off
          inst_name: lc_ctrl
          end_idx: -1
          top_type: broadcast
          top_signame: lc_ctrl_lc_keymgr_en
          index: -1
        }
        {
          name: lc_escalate_en
          struct: lc_tx
          package: lc_ctrl_pkg
          type: uni
          act: req
          width: 1
          default: lc_ctrl_pkg::Off
          inst_name: lc_ctrl
          end_idx: -1
          top_type: broadcast
          top_signame: lc_ctrl_lc_escalate_en
          index: -1
          external: true
          conn_type: true
        }
        {
          name: lc_clk_byp_req
          struct: lc_tx
          package: lc_ctrl_pkg
          type: uni
          act: req
          width: 1
          default: lc_ctrl_pkg::Off
          inst_name: lc_ctrl
          domain: Main
          top_signame: lc_ctrl_lc_clk_byp_ack
          index: -1
        }
        {
          name: lc_clk_byp_ack
          struct: lc_tx
          package: lc_ctrl_pkg
          type: uni
          act: rcv
          width: 1
          default: lc_ctrl_pkg::Off
          inst_name: lc_ctrl
          end_idx: -1
          top_type: broadcast
          top_signame: lc_ctrl_lc_clk_byp_ack
          index: -1
        }
        {
          name: lc_nvm_rma_req
          struct: lc_tx
          package: lc_ctrl_pkg
          type: uni
          act: req
          width: 1
          default: lc_ctrl_pkg::Off
          inst_name: lc_ctrl
          end_idx: -1
          top_type: broadcast
          top_signame: lc_ctrl_lc_nvm_rma_req
          index: -1
        }
        {
          name: lc_nvm_rma_ack
          struct: lc_tx
          package: lc_ctrl_pkg
          type: uni
          act: rcv
          width: 2
          default: lc_ctrl_pkg::On
          inst_name: lc_ctrl
          domain: Main
          top_signame: otbn_lc_rma_ack
          index: -1
        }
        {
          name: lc_nvm_rma_seed
          struct: lc_nvm_rma_seed
          package: lc_ctrl_pkg
          type: uni
          act: req
          width: 1
          default: "'0"
          inst_name: lc_ctrl
          index: -1
        }
        {
          name: lc_check_byp_en
          struct: lc_tx
          package: lc_ctrl_pkg
          type: uni
          act: req
          width: 1
          default: lc_ctrl_pkg::Off
          inst_name: lc_ctrl
          end_idx: -1
          top_type: broadcast
          top_signame: lc_ctrl_lc_check_byp_en
          index: -1
        }
        {
          name: lc_creator_seed_sw_rw_en
          struct: lc_tx
          package: lc_ctrl_pkg
          type: uni
          act: req
          width: 1
          default: lc_ctrl_pkg::Off
          inst_name: lc_ctrl
          end_idx: -1
          top_type: broadcast
          top_signame: lc_ctrl_lc_creator_seed_sw_rw_en
          index: -1
        }
        {
          name: lc_owner_seed_sw_rw_en
          struct: lc_tx
          package: lc_ctrl_pkg
          type: uni
          act: req
          width: 1
          default: lc_ctrl_pkg::Off
          inst_name: lc_ctrl
          end_idx: -1
          top_type: broadcast
          top_signame: lc_ctrl_lc_owner_seed_sw_rw_en
          index: -1
        }
        {
          name: lc_iso_part_sw_rd_en
          struct: lc_tx
          package: lc_ctrl_pkg
          type: uni
          act: req
          width: 1
          default: lc_ctrl_pkg::Off
          inst_name: lc_ctrl
          index: -1
        }
        {
          name: lc_iso_part_sw_wr_en
          struct: lc_tx
          package: lc_ctrl_pkg
          type: uni
          act: req
          width: 1
          default: lc_ctrl_pkg::Off
          inst_name: lc_ctrl
          index: -1
        }
        {
          name: lc_seed_hw_rd_en
          struct: lc_tx
          package: lc_ctrl_pkg
          type: uni
          act: req
          width: 1
          default: lc_ctrl_pkg::Off
          inst_name: lc_ctrl
          end_idx: -1
          top_type: broadcast
          top_signame: lc_ctrl_lc_seed_hw_rd_en
          index: -1
        }
        {
          name: lc_rma_state
          struct: lc_tx
          package: lc_ctrl_pkg
          type: uni
          act: req
          width: 1
          default: lc_ctrl_pkg::Off
          inst_name: lc_ctrl
          end_idx: -1
          top_type: broadcast
          top_signame: lc_ctrl_lc_rma_state
          index: -1
        }
        {
          name: lc_keymgr_div
          struct: lc_keymgr_div
          package: lc_ctrl_pkg
          type: uni
          act: req
          width: 1
          default: "'0"
          inst_name: lc_ctrl
          end_idx: -1
          top_type: broadcast
          top_signame: lc_ctrl_lc_keymgr_div
          index: -1
        }
        {
          name: otp_device_id
          struct: otp_device_id
          package: otp_ctrl_pkg
          type: uni
          act: rcv
          width: 1
          default: "'0"
          inst_name: lc_ctrl
          top_signame: lc_ctrl_otp_device_id
          index: -1
        }
        {
          name: otp_manuf_state
          struct: otp_manuf_state
          package: otp_ctrl_pkg
          type: uni
          act: rcv
          width: 1
          default: "'0"
          inst_name: lc_ctrl
          top_signame: lc_ctrl_otp_manuf_state
          index: -1
        }
        {
          name: hw_rev
          struct: lc_hw_rev
          package: lc_ctrl_pkg
          type: uni
          act: req
          width: 1
          default: "'0"
          inst_name: lc_ctrl
          index: -1
        }
        {
          name: strap_en_override
          desc:
            '''
            This signal transitions from 0 -> 1 by the lc_ctrl manager after volatile RAW_UNLOCK in order to re-sample the HW straps.
            The signal stays at 1 until reset.
            Note that this is only used in test chips when SecVolatileRawUnlockEn = 1.
            Otherwise this signal is tied off to 0.
            '''
          struct: logic
          type: uni
          act: req
          width: 1
          default: 1'b0
          inst_name: lc_ctrl
          package: ""
          end_idx: -1
          top_type: broadcast
          top_signame: lc_ctrl_strap_en_override
          index: -1
        }
        {
          name: regs_tl
          struct: tl
          package: tlul_pkg
          type: req_rsp
          act: rsp
          width: 1
          inst_name: lc_ctrl
          default: ""
          end_idx: -1
          top_type: one-to-one
          top_signame: lc_ctrl_regs_tl
          index: -1
        }
        {
          name: dmi_tl
          struct: tl
          package: tlul_pkg
          type: req_rsp
          act: rsp
          width: 1
          inst_name: lc_ctrl
          default: ""
          end_idx: -1
          top_type: one-to-one
          top_signame: lc_ctrl_dmi_tl
          index: -1
        }
      ]
      generate_dif: true
    }
    {
      name: alert_handler
      type: alert_handler
      template_type: alert_handler
      clock_srcs:
      {
        clk_i: io
        clk_edn_i: main
      }
      clock_group: secure
      reset_connections:
      {
        rst_ni:
        {
          name: lc_io
          domain: Main
        }
        rst_edn_ni:
        {
          name: lc
          domain: Main
        }
      }
      param_decl:
      {
        EscNumSeverities: "4"
        EscPingCountWidth: "16"
      }
      attr: ipgen
      domain: Main
      clock_connections:
      {
        clk_i: clkmgr_clocks_i.clk_io_secure
        clk_edn_i: clkmgr_clocks_i.clk_main_secure
      }
      memory: {}
      param_list:
      [
        {
          name: EscNumSeverities
          desc: Number of escalation severities as regular parameter
          type: int
          default: "4"
          local: "false"
          expose: "true"
          name_top: AlertHandlerEscNumSeverities
        }
        {
          name: EscPingCountWidth
          desc: Width of ping counter as regular parameter
          type: int
          default: "16"
          local: "false"
          expose: "true"
          name_top: AlertHandlerEscPingCountWidth
        }
      ]
      inter_signal_list:
      [
        {
          name: crashdump
          struct: alert_crashdump
          package: alert_handler_pkg
          type: uni
          act: req
          width: 1
          inst_name: alert_handler
          default: ""
          end_idx: -1
          top_type: broadcast
          top_signame: alert_handler_crashdump
          index: -1
          external: true
          conn_type: false
        }
        {
          name: edn
          struct: edn
          package: edn_pkg
          type: req_rsp
          act: req
          width: 1
          inst_name: alert_handler
          default: ""
          domain: Main
          top_signame: edn0_edn
          index: 3
        }
        {
          name: esc_rx
          struct: esc_rx
          package: prim_esc_pkg
          type: uni
          act: rcv
          width: 4
          inst_name: alert_handler
          default: ""
          end_idx: -1
          top_type: one-to-N
          top_signame: alert_handler_esc_rx
          index: 3
          external: true
          conn_type: true
        }
        {
          name: esc_tx
          struct: esc_tx
          package: prim_esc_pkg
          type: uni
          act: req
          width: 4
          inst_name: alert_handler
          default: ""
          end_idx: -1
          top_type: one-to-N
          top_signame: alert_handler_esc_tx
          index: 3
          external: true
          conn_type: true
        }
        {
          name: tl
          struct: tl
          package: tlul_pkg
          type: req_rsp
          act: rsp
          width: 1
          inst_name: alert_handler
          default: ""
          end_idx: -1
          top_type: one-to-one
          top_signame: alert_handler_tl
          index: -1
        }
      ]
      base_addrs:
      {
        null:
        {
          hart: 0x30160000
        }
      }
      generate_dif: true
    }
    {
      name: spi_host0
      type: spi_host
      clock_srcs:
      {
        clk_i: io
      }
      clock_group: peri
      reset_connections:
      {
        rst_ni:
        {
          name: spi_host0
          domain: Main
        }
      }
      domain: Main
      clock_connections:
      {
        clk_i: clkmgr_clocks_i.clk_io_peri
      }
      param_decl: {}
      memory: {}
      param_list:
      [
        {
          name: NumCS
          desc: The number of active-low chip select (cs_n) lines to create.
          type: int
          default: "1"
          local: "true"
          expose: "true"
          name_top: SpiHost0NumCS
        }
      ]
      inter_signal_list:
      [
        {
          name: passthrough
          struct: passthrough
          package: spi_device_pkg
          type: req_rsp
          act: rsp
          width: 1
          inst_name: spi_host0
          default: ""
          domain: Main
          top_signame: spi_device_passthrough
          index: -1
        }
        {
          name: lsio_trigger
          desc:
            '''
            Self-clearing status trigger for the DMA.
            Set when RX or TX FIFOs are past their configured watermarks matching watermark interrupt behaviour.
            '''
          struct: logic
          type: uni
          act: req
          width: 1
          inst_name: spi_host0
          default: ""
          package: ""
          end_idx: -1
          top_type: broadcast
          top_signame: spi_host0_lsio_trigger
          index: -1
          external: true
          conn_type: false
        }
        {
          name: racl_policies
          desc:
            '''
            Incoming RACL policy vector from a racl_ctrl instance.
            The policy selection vector (parameter) selects the policy for each register.
            '''
          struct: racl_policy_vec
          package: top_racl_pkg
          type: uni
          act: rcv
          width: 1
          inst_name: spi_host0
          index: -1
        }
        {
          name: racl_error
          desc: RACL error log information of this module.
          struct: racl_error_log
          package: top_racl_pkg
          type: uni
          act: req
          width: 1
          inst_name: spi_host0
          index: -1
        }
        {
          name: tl
          struct: tl
          package: tlul_pkg
          type: req_rsp
          act: rsp
          width: 1
          inst_name: spi_host0
          default: ""
          end_idx: -1
          top_type: one-to-one
          top_signame: spi_host0_tl
          index: -1
        }
      ]
      base_addrs:
      {
        null:
        {
          hart: 0x30300000
        }
      }
      generate_dif: true
    }
    {
      name: pwrmgr
      type: pwrmgr
      template_type: pwrmgr
      clock_group: powerup
      clock_srcs:
      {
        clk_i: io
        clk_slow_i: aon
        clk_lc_i: io
        clk_esc_i:
        {
          clock: io
          group: secure
        }
      }
      reset_connections:
      {
        rst_ni:
        {
          name: por_io
          domain: Aon
        }
        rst_main_ni:
        {
          name: por_aon
          domain: Main
        }
        rst_lc_ni:
        {
          name: lc_io
          domain: Aon
        }
        rst_esc_ni:
        {
          name: lc_io
          domain: Aon
        }
        rst_slow_ni:
        {
          name: por_aon
          domain: Aon
        }
      }
      domain: Aon
      param_decl:
      {
        EscNumSeverities: AlertHandlerEscNumSeverities
        EscPingCountWidth: AlertHandlerEscPingCountWidth
      }
      attr: ipgen
      clock_connections:
      {
        clk_i: clkmgr_clocks.clk_io_powerup
        clk_slow_i: clkmgr_clocks.clk_aon_powerup
        clk_lc_i: clkmgr_clocks.clk_io_powerup
        clk_esc_i: clkmgr_clocks.clk_io_secure
      }
      memory: {}
      param_list:
      [
        {
          name: EscNumSeverities
          desc: Number of escalation severities
          type: int
          default: AlertHandlerEscNumSeverities
          local: "false"
          expose: "false"
          name_top: PwrmgrEscNumSeverities
        }
        {
          name: EscPingCountWidth
          desc: Width of ping count for the escalation receiver
          type: int
          default: AlertHandlerEscPingCountWidth
          local: "false"
          expose: "false"
          name_top: PwrmgrEscPingCountWidth
        }
      ]
      inter_signal_list:
      [
        {
          name: boot_status
          struct: pwr_boot_status
          package: pwrmgr_pkg
          type: uni
          act: req
          width: 1
          inst_name: pwrmgr
          default: ""
          end_idx: -1
          top_type: broadcast
          top_signame: pwrmgr_boot_status
          index: -1
          external: true
          conn_type: true
        }
        {
          name: ext_rst_ack
          struct: logic
          type: uni
          act: rcv
          width: 1
          inst_name: pwrmgr
          default: ""
          package: ""
          external: true
          conn_type: false
          index: -1
          top_signame: pwrmgr_ext_rst_ack
        }
        {
          name: pwr_ast
          struct: pwr_ast
          package: pwrmgr_pkg
          type: req_rsp
          act: req
          width: 1
          inst_name: pwrmgr
          default: ""
          external: true
          conn_type: false
          index: -1
          top_signame: pwrmgr_ast
        }
        {
          name: pwr_rst
          struct: pwr_rst
          package: pwrmgr_pkg
          type: req_rsp
          act: req
          width: 1
          inst_name: pwrmgr
          default: ""
          end_idx: -1
          top_type: one-to-one
          top_signame: pwrmgr_pwr_rst
          index: -1
        }
        {
          name: pwr_clk
          struct: pwr_clk
          package: pwrmgr_pkg
          type: req_rsp
          act: req
          width: 1
          inst_name: pwrmgr
          default: ""
          end_idx: -1
          top_type: one-to-one
          top_signame: pwrmgr_pwr_clk
          index: -1
        }
        {
          name: pwr_otp
          struct: pwr_otp
          package: pwrmgr_pkg
          type: req_rsp
          act: req
          width: 1
          inst_name: pwrmgr
          default: ""
          end_idx: -1
          top_type: one-to-one
          top_signame: pwrmgr_pwr_otp
          index: -1
          external: true
          conn_type: false
        }
        {
          name: pwr_lc
          struct: pwr_lc
          package: lc_ctrl_pkg
          type: req_rsp
          act: req
          width: 1
          inst_name: pwrmgr
          default: ""
          end_idx: -1
          top_type: one-to-one
          top_signame: pwrmgr_pwr_lc
          index: -1
          external: true
          conn_type: false
        }
        {
          name: pwr_nvm
          struct: pwr_nvm
          package: pwrmgr_pkg
          type: uni
          act: rcv
          width: 1
          inst_name: pwrmgr
          index: -1
        }
        {
          name: esc_rst_tx
          struct: esc_tx
          package: prim_esc_pkg
          type: uni
          act: rcv
          width: 1
          inst_name: pwrmgr
          default: ""
          domain: Aon
          top_signame: alert_handler_esc_tx
          index: -1
          external: true
          conn_type: false
        }
        {
          name: esc_rst_rx
          struct: esc_rx
          package: prim_esc_pkg
          type: uni
          act: req
          width: 1
          inst_name: pwrmgr
          default: ""
          domain: Aon
          top_signame: alert_handler_esc_rx
          index: -1
          external: true
          conn_type: false
        }
        {
          name: pwr_cpu
          struct: cpu_pwrmgr
          package: rv_core_ibex_pkg
          type: uni
          act: rcv
          width: 1
          inst_name: pwrmgr
          default: ""
          domain: Aon
          top_signame: rv_core_ibex_pwrmgr
          index: -1
          external: true
          conn_type: false
        }
        {
          name: wakeups
          struct: logic
          type: uni
          act: rcv
          width: 3
          inst_name: pwrmgr
          default: ""
          package: ""
          end_idx: -1
          top_type: one-to-N
          top_signame: pwrmgr_wakeups
          index: 0
          external: true
          conn_type: true
        }
        {
          name: rstreqs
          struct: logic
          type: uni
          act: rcv
          width: 2
          inst_name: pwrmgr
          default: ""
          package: ""
          end_idx: -1
          top_type: one-to-N
          top_signame: pwrmgr_rstreqs
          index: -1
        }
        {
          name: ndmreset_req
          struct: logic
          type: uni
          act: rcv
          width: 1
          inst_name: pwrmgr
          default: ""
          package: ""
          domain: Aon
          top_signame: rv_dm_ndmreset_req
          index: -1
          external: true
          conn_type: false
        }
        {
          name: strap
          struct: logic
          type: uni
          act: req
          width: 1
          inst_name: pwrmgr
          default: ""
          package: ""
          end_idx: -1
          top_type: broadcast
          top_signame: pwrmgr_strap
          index: -1
          external: true
          conn_type: false
        }
        {
          name: low_power
          struct: logic
          type: uni
          act: req
          width: 1
          inst_name: pwrmgr
          default: ""
          package: ""
          end_idx: -1
          top_type: broadcast
          top_signame: pwrmgr_low_power
          index: -1
          external: true
          conn_type: true
        }
        {
          name: rom_ctrl
          struct: pwrmgr_data
          package: rom_ctrl_pkg
          type: uni
          act: rcv
          width: 3
          default: rom_ctrl_pkg::PWRMGR_DATA_DEFAULT
          inst_name: pwrmgr
          end_idx: -1
          top_type: one-to-N
          top_signame: pwrmgr_rom_ctrl
          index: -1
          external: true
          conn_type: false
        }
        {
          name: fetch_en
          struct: lc_tx
          package: lc_ctrl_pkg
          type: uni
          act: req
          width: 1
          inst_name: pwrmgr
          default: ""
          end_idx: -1
          top_type: broadcast
          top_signame: pwrmgr_fetch_en
          index: -1
          external: true
          conn_type: false
        }
        {
          name: lc_dft_en
          struct: lc_tx
          package: lc_ctrl_pkg
          type: uni
          act: rcv
          width: 1
          inst_name: pwrmgr
          default: ""
          domain: Aon
          top_signame: lc_ctrl_lc_dft_en
          index: -1
          external: true
          conn_type: false
        }
        {
          name: lc_hw_debug_en
          struct: lc_tx
          package: lc_ctrl_pkg
          type: uni
          act: rcv
          width: 1
          inst_name: pwrmgr
          default: ""
          domain: Aon
          top_signame: lc_ctrl_lc_hw_debug_en
          index: -1
          external: true
          conn_type: false
        }
        {
          name: sw_rst_req
          struct: mubi4
          package: prim_mubi_pkg
          type: uni
          act: rcv
          width: 1
          inst_name: pwrmgr
          default: ""
          domain: Aon
          top_signame: rstmgr_sw_rst_req
          index: -1
        }
        {
          name: tl
          struct: tl
          package: tlul_pkg
          type: req_rsp
          act: rsp
          width: 1
          inst_name: pwrmgr
          default: ""
          end_idx: -1
          top_type: one-to-one
          top_signame: pwrmgr_tl
          index: -1
          external: true
          conn_type: false
        }
      ]
      base_addrs:
      {
        null:
        {
          hart: 0x30400000
        }
      }
      generate_dif: true
    }
    {
      name: rstmgr
      type: rstmgr
      template_type: rstmgr
      clock_srcs:
      {
        clk_i:
        {
          clock: io
          group: powerup
        }
        clk_por_i: io
        clk_aon_i: aon
        clk_main_i: main
        clk_io_i: io
      }
      clock_group: powerup
      reset_connections:
      {
        rst_ni:
        {
          name: lc_io
          domain: Aon
        }
        rst_por_ni:
        {
          name: por_io
          domain: Aon
        }
      }
      domain: Aon
      attr: ipgen
      clock_connections:
      {
        clk_i: clkmgr_clocks.clk_io_powerup
        clk_por_i: clkmgr_clocks.clk_io_powerup
        clk_aon_i: clkmgr_clocks.clk_aon_powerup
        clk_main_i: clkmgr_clocks.clk_main_powerup
        clk_io_i: clkmgr_clocks.clk_io_powerup
      }
      param_decl: {}
      memory: {}
      param_list:
      [
        {
          name: SecCheck
          desc:
            '''
            When 1, enable rstmgr reset consistency checks.
            When 0, there are no consistency checks.
            '''
          type: bit
          default: 1'b1
          local: "false"
          expose: "true"
          name_top: SecRstmgrCheck
        }
        {
          name: SecMaxSyncDelay
          desc: The maximum synchronization delay for parent / child reset checks.
          type: int
          default: "2"
          local: "false"
          expose: "true"
          name_top: SecRstmgrMaxSyncDelay
        }
      ]
      inter_signal_list:
      [
        {
          name: por_n
          desc:
            '''
            Root power on reset signals from ast.
            There is one root reset signal for each core power domain.
            '''
          struct: logic
          type: uni
          act: rcv
          width: 2
          inst_name: rstmgr
          default: ""
          package: ""
          external: true
          conn_type: false
          index: -1
          top_signame: por_n
        }
        {
          name: pwr
          desc:
            '''
            Reset request signals from power manager.
            Power manager can request for specific domains of the lc/sys reset tree to assert.
            '''
          struct: pwr_rst
          type: req_rsp
          act: rsp
          width: 1
          inst_name: rstmgr
          default: ""
          package: pwrmgr_pkg
          domain: Aon
          top_signame: pwrmgr_pwr_rst
          index: -1
        }
        {
          name: resets
          desc: Leaf resets fed to the system.
          struct: rstmgr_out
          package: rstmgr_pkg
          type: uni
          act: req
          width: 1
          inst_name: rstmgr
          default: ""
          top_signame: rstmgr_resets
          index: -1
          external: true
          conn_type: true
        }
        {
          name: rst_en
          desc: Low-power-group outputs used by alert handler.
          struct: rstmgr_rst_en
          package: rstmgr_pkg
          type: uni
          act: req
          width: 1
          inst_name: rstmgr
          default: ""
          top_signame: rstmgr_rst_en
          index: -1
          external: true
          conn_type: true
        }
        {
          name: alert_dump
          desc: Alert handler crash dump information.
          struct: alert_crashdump
          package: alert_handler_pkg
          type: uni
          act: rcv
          width: 1
          inst_name: rstmgr
          default: ""
          domain: Aon
          top_signame: alert_handler_crashdump
          index: -1
          external: true
          conn_type: false
        }
        {
          name: cpu_dump
          desc: Main processing element crash dump information.
          struct: cpu_crash_dump
          package: rv_core_ibex_pkg
          type: uni
          act: rcv
          width: 1
          inst_name: rstmgr
          default: ""
          domain: Aon
          top_signame: rv_core_ibex_crash_dump
          index: -1
          external: true
          conn_type: false
        }
        {
          name: sw_rst_req
          desc: Software requested system reset to pwrmgr.
          struct: mubi4
          package: prim_mubi_pkg
          type: uni
          act: req
          width: 1
          inst_name: rstmgr
          default: ""
          end_idx: -1
          top_type: broadcast
          top_signame: rstmgr_sw_rst_req
          index: -1
        }
        {
          name: tl
          struct: tl
          package: tlul_pkg
          type: req_rsp
          act: rsp
          width: 1
          inst_name: rstmgr
          default: ""
          end_idx: -1
          top_type: one-to-one
          top_signame: rstmgr_tl
          index: -1
          external: true
          conn_type: false
        }
      ]
      base_addrs:
      {
        null:
        {
          hart: 0x30410000
        }
      }
      generate_dif: true
    }
    {
      name: clkmgr
      type: clkmgr
      template_type: clkmgr
      clock_srcs:
      {
        clk_i: io
        clk_main_i:
        {
          group: ast
          clock: main
        }
        clk_io_i:
        {
          group: ast
          clock: io
        }
        clk_aon_i:
        {
          group: ast
          clock: aon
        }
      }
      clock_group: powerup
      reset_connections:
      {
        rst_ni:
        {
          name: lc_io
          domain: Aon
        }
        rst_aon_ni:
        {
          name: lc_aon
          domain: Aon
        }
        rst_io_ni:
        {
          name: lc_io
          domain: Aon
        }
        rst_main_ni:
        {
          name: lc
          domain: Aon
        }
        rst_root_ni:
        {
          name: por_io
          domain: Aon
        }
        rst_root_io_ni:
        {
          name: por_io
          domain: Aon
        }
        rst_root_main_ni:
        {
          name: por
          domain: Aon
        }
      }
      domain: Aon
      ipgen_params:
      {
        ext_clk_bypass: false
      }
      attr: ipgen
      clock_connections:
      {
        clk_i: clkmgr_clocks.clk_io_powerup
        clk_main_i: clk_main_i
        clk_io_i: clk_io_i
        clk_aon_i: clk_aon_i
      }
      param_decl: {}
      memory: {}
      param_list: []
      inter_signal_list:
      [
        {
          name: clocks
          struct: clkmgr_out
          package: clkmgr_pkg
          type: uni
          act: req
          width: 1
          inst_name: clkmgr
          default: ""
          top_signame: clkmgr_clocks
          index: -1
          external: true
          conn_type: true
        }
        {
          name: cg_en
          struct: clkmgr_cg_en
          package: clkmgr_pkg
          type: uni
          act: req
          width: 1
          inst_name: clkmgr
          default: ""
          top_signame: clkmgr_cg_en
          index: -1
          external: true
          conn_type: true
        }
        {
          name: jitter_en
          struct: mubi4
          package: prim_mubi_pkg
          type: uni
          act: req
          width: 1
          inst_name: clkmgr
          default: ""
          external: true
          conn_type: false
          index: -1
          top_signame: clk_main_jitter_en
        }
        {
          name: pwr
          struct: pwr_clk
          type: req_rsp
          act: rsp
          width: 1
          inst_name: clkmgr
          default: ""
          package: pwrmgr_pkg
          domain: Aon
          top_signame: pwrmgr_pwr_clk
          index: -1
        }
        {
          name: idle
          struct: mubi4
          package: prim_mubi_pkg
          type: uni
          act: rcv
          width: 4
          inst_name: clkmgr
          default: ""
          end_idx: -1
          top_type: one-to-N
          top_signame: clkmgr_idle
          index: -1
          external: true
          conn_type: false
        }
        {
          name: tl
          struct: tl
          package: tlul_pkg
          type: req_rsp
          act: rsp
          width: 1
          inst_name: clkmgr
          default: ""
          end_idx: -1
          top_type: one-to-one
          top_signame: clkmgr_tl
          index: -1
          external: true
          conn_type: false
        }
      ]
      base_addrs:
      {
        null:
        {
          hart: 0x30420000
        }
      }
      generate_dif: true
    }
    {
      name: pinmux
      type: pinmux
      template_type: pinmux
      clock_srcs:
      {
        clk_i: io
        clk_aon_i: aon
      }
      clock_group: powerup
      reset_connections:
      {
        rst_ni:
        {
          name: lc_io
          domain: Aon
        }
        rst_aon_ni:
        {
          name: lc_aon
          domain: Aon
        }
      }
      domain: Main
      attr: ipgen
      clock_connections:
      {
        clk_i: clkmgr_clocks_i.clk_io_powerup
        clk_aon_i: clkmgr_clocks_i.clk_aon_powerup
      }
      param_decl: {}
      memory: {}
      param_list:
      [
        {
          name: TargetCfg
          desc: Target specific pinmux configuration.
          type: pinmux_pkg::target_cfg_t
          default: pinmux_pkg::DefaultTargetCfg
          local: "false"
          expose: "true"
          name_top: PinmuxTargetCfg
        }
      ]
      inter_signal_list:
      [
        {
          name: sleep_en
          desc: Level signal that is asserted when the power manager enters sleep.
          struct: logic
          type: uni
          act: rcv
          width: 1
          default: 1'b0
          inst_name: pinmux
          package: ""
          domain: Main
          top_signame: pwrmgr_low_power
          index: -1
          external: true
          conn_type: false
        }
        {
          name: pin_wkup_req
          desc: Wakeup request from wakeup detectors, to the power manager, running on the AON clock.
          struct: logic
          type: uni
          act: req
          width: 1
          default: 1'b0
          inst_name: pinmux
          package: ""
          domain: Main
          top_signame: pwrmgr_wakeups
          index: -1
          external: true
          conn_type: false
        }
        {
          name: tl
          struct: tl
          package: tlul_pkg
          type: req_rsp
          act: rsp
          width: 1
          inst_name: pinmux
          default: ""
          end_idx: -1
          top_type: one-to-one
          top_signame: pinmux_tl
          index: -1
        }
      ]
      base_addrs:
      {
        null:
        {
          hart: 0x30460000
        }
      }
      generate_dif: true
    }
    {
      name: aon_timer
      type: aon_timer
      clock_srcs:
      {
        clk_i: io
        clk_aon_i: aon
      }
      clock_group: timers
      reset_connections:
      {
        rst_ni:
        {
          name: lc_io
          domain: Aon
        }
        rst_aon_ni:
        {
          name: lc_aon
          domain: Aon
        }
      }
      domain: Aon
      clock_connections:
      {
        clk_i: clkmgr_clocks.clk_io_timers
        clk_aon_i: clkmgr_clocks.clk_aon_timers
      }
      param_decl: {}
      memory: {}
      param_list: []
      inter_signal_list:
      [
        {
          name: nmi_wdog_timer_bark
          struct: logic
          type: uni
          act: req
          width: 1
          default: 1'b0
          inst_name: aon_timer
          package: ""
          end_idx: -1
          top_type: broadcast
          top_signame: aon_timer_nmi_wdog_timer_bark
          index: -1
          external: true
          conn_type: false
        }
        {
          name: wkup_req
          struct: logic
          type: uni
          act: req
          width: 1
          default: 1'b0
          inst_name: aon_timer
          package: ""
          domain: Aon
          top_signame: pwrmgr_wakeups
          index: 1
        }
        {
          name: aon_timer_rst_req
          struct: logic
          type: uni
          act: req
          width: 1
          default: 1'b0
          inst_name: aon_timer
          package: ""
          domain: Aon
          top_signame: pwrmgr_rstreqs
          index: 0
        }
        {
          name: lc_escalate_en
          struct: lc_tx
          package: lc_ctrl_pkg
          type: uni
          act: rcv
          width: 1
          default: lc_ctrl_pkg::Off
          inst_name: aon_timer
          domain: Aon
          top_signame: lc_ctrl_lc_escalate_en
          index: -1
          external: true
          conn_type: false
        }
        {
          name: sleep_mode
          struct: logic
          type: uni
          act: rcv
          width: 1
          inst_name: aon_timer
          default: ""
          package: ""
          domain: Aon
          top_signame: pwrmgr_low_power
          index: -1
        }
        {
          name: racl_policies
          desc:
            '''
            Incoming RACL policy vector from a racl_ctrl instance.
            The policy selection vector (parameter) selects the policy for each register.
            '''
          struct: racl_policy_vec
          package: top_racl_pkg
          type: uni
          act: rcv
          width: 1
          inst_name: aon_timer
          index: -1
        }
        {
          name: racl_error
          desc: RACL error log information of this module.
          struct: racl_error_log
          package: top_racl_pkg
          type: uni
          act: req
          width: 1
          inst_name: aon_timer
          index: -1
        }
        {
          name: tl
          struct: tl
          package: tlul_pkg
          type: req_rsp
          act: rsp
          width: 1
          inst_name: aon_timer
          default: ""
          end_idx: -1
          top_type: one-to-one
          top_signame: aon_timer_tl
          index: -1
          external: true
          conn_type: false
        }
      ]
      base_addrs:
      {
        null:
        {
          hart: 0x30470000
        }
      }
      generate_dif: true
    }
    {
      name: ast
      type: ast
      clock_srcs:
      {
        clk_ast_tlul_i:
        {
          clock: io
          group: infra
        }
        clk_ast_alert_i:
        {
          clock: io
          group: secure
        }
        clk_ast_rng_i:
        {
          clock: main
          group: secure
        }
      }
      clock_group: secure
      reset_connections:
      {
        rst_ast_tlul_ni:
        {
          name: lc_io
          domain: Main
        }
        rst_ast_alert_ni:
        {
          name: lc_io
          domain: Main
        }
        rst_ast_rng_ni:
        {
          name: lc
          domain: Main
        }
      }
      domain: Main
      attr: reggen_only
      clock_connections:
      {
        clk_ast_tlul_i: clkmgr_clocks_i.clk_io_infra
        clk_ast_alert_i: clkmgr_clocks_i.clk_io_secure
        clk_ast_rng_i: clkmgr_clocks_i.clk_main_secure
      }
      param_decl: {}
      memory: {}
      param_list: []
      inter_signal_list:
      [
        {
          name: tl
          struct: tl
          package: tlul_pkg
          type: req_rsp
          act: rsp
          width: 1
          inst_name: ast
          index: -1
        }
      ]
      base_addrs:
      {
        null:
        {
          hart: 0x30480000
        }
      }
      generate_dif: true
    }
    {
      name: soc_proxy
      type: soc_proxy
      clock_srcs:
      {
        clk_i: main
        clk_aon_i: aon
      }
      clock_group: infra
      reset_connections:
      {
        rst_ni:
        {
          name: lc
          domain: Main
        }
        rst_por_ni:
        {
          name: por_io
          domain: Aon
        }
      }
      domain: Aon
      base_addrs:
      {
        core:
        {
          hart: 0x22030000
        }
        ctn:
        {
          hart: 0x40000000
        }
      }
      attr: reggen_top
      memory:
      {
        ctn:
        {
          label: ctn
          swaccess: rw
          data_intg_passthru: "true"
          exec: True
          byte_write: True
          size: 0x80000000
        }
      }
      clock_connections:
      {
        clk_i: clkmgr_clocks.clk_main_infra
        clk_aon_i: clkmgr_clocks.clk_aon_infra
      }
      param_decl: {}
      param_list: []
      inter_signal_list:
      [
        {
          name: dma_tl_h2d
          desc: TL-UL host port for the DMA to egress into CTN (request part), synchronous
          struct: tl_h2d
          package: tlul_pkg
          type: uni
          act: rcv
          width: 1
          inst_name: soc_proxy
          default: ""
          end_idx: -1
          top_type: broadcast
          top_signame: soc_proxy_dma_tl_h2d
          index: -1
          external: true
          conn_type: false
        }
        {
          name: dma_tl_d2h
          desc: TL-UL host port for the DMA to egress into CTN (response part), synchronous
          struct: tl_d2h
          package: tlul_pkg
          type: uni
          act: req
          width: 1
          inst_name: soc_proxy
          default: ""
          end_idx: -1
          top_type: broadcast
          top_signame: soc_proxy_dma_tl_d2h
          index: -1
          external: true
          conn_type: false
        }
        {
          name: misc_tl_h2d
          desc: TL-UL host port for the MISC to egress into CTN (request part), synchronous
          struct: tl_h2d
          package: tlul_pkg
          type: uni
          act: rcv
          width: 1
          inst_name: soc_proxy
          default: ""
          external: true
          conn_type: false
          index: -1
          top_signame: ctn_misc_tl_h2d
        }
        {
          name: misc_tl_d2h
          desc: TL-UL host port for the MISC to egress into CTN (response part), synchronous
          struct: tl_d2h
          package: tlul_pkg
          type: uni
          act: req
          width: 1
          inst_name: soc_proxy
          default: ""
          external: true
          conn_type: false
          index: -1
          top_signame: ctn_misc_tl_d2h
        }
        {
          name: wkup_external_req
          struct: logic
          type: uni
          act: req
          width: 1
          inst_name: soc_proxy
          default: ""
          package: ""
          domain: Aon
          top_signame: pwrmgr_wakeups
          index: 2
        }
        {
          name: rst_req_external
          struct: logic
          type: uni
          act: req
          width: 1
          inst_name: soc_proxy
          default: ""
          package: ""
          domain: Aon
          top_signame: pwrmgr_rstreqs
          index: 1
        }
        {
          name: ctn_tl_h2d
          desc: TL-UL host port for egress into CTN (request part), synchronous
          struct: tl_h2d
          package: tlul_pkg
          type: uni
          act: req
          width: 1
          inst_name: soc_proxy
          default: ""
          end_idx: -1
          top_type: broadcast
          top_signame: soc_proxy_ctn_tl_h2d
          index: -1
          external: true
          conn_type: false
        }
        {
          name: ctn_tl_d2h
          desc: TL-UL host port for egress into CTN (response part), synchronous
          struct: tl_d2h
          package: tlul_pkg
          type: uni
          act: rcv
          width: 1
          inst_name: soc_proxy
          default: ""
          end_idx: -1
          top_type: broadcast
          top_signame: soc_proxy_ctn_tl_d2h
          index: -1
          external: true
          conn_type: false
        }
        {
          name: i2c_lsio_trigger
          desc: LSIO trigger signal from I2C
          struct: logic
          type: uni
          act: rcv
          width: 1
          inst_name: soc_proxy
          default: ""
          package: ""
          domain: Aon
          top_signame: i2c0_lsio_trigger
          index: -1
          external: true
          conn_type: false
        }
        {
          name: spi_host_lsio_trigger
          desc: LSIO trigger signal from SPI Host
          struct: logic
          type: uni
          act: rcv
          width: 1
          inst_name: soc_proxy
          default: ""
          package: ""
          domain: Aon
          top_signame: spi_host0_lsio_trigger
          index: -1
          external: true
          conn_type: false
        }
        {
          name: uart_lsio_trigger
          desc: LSIO trigger signal from UART
          struct: logic
          type: uni
          act: rcv
          width: 1
          inst_name: soc_proxy
          default: ""
          package: ""
          domain: Aon
          top_signame: uart0_lsio_trigger
          index: -1
          external: true
          conn_type: false
        }
        {
          name: soc_lsio_trigger
          desc: LSIO trigger signal from SoC, synchronous
          struct: logic
          type: uni
          act: rcv
          width: 8
          inst_name: soc_proxy
          default: ""
          package: ""
          external: true
          conn_type: false
          index: -1
          top_signame: soc_lsio_trigger
        }
        {
          name: dma_lsio_trigger
          desc: Collated synchronous LSIO trigger signals for DMA
          struct: lsio_trigger
          package: dma_pkg
          type: uni
          act: req
          width: 1
          inst_name: soc_proxy
          default: ""
          domain: Aon
          top_signame: dma_lsio_trigger
          index: -1
          external: true
          conn_type: false
        }
        {
          name: soc_wkup_async
          desc: Wakeup request from SoC, asynchronous, level-encoded
          struct: logic
          type: uni
          act: rcv
          width: 1
          inst_name: soc_proxy
          default: ""
          package: ""
          external: true
          conn_type: false
          index: -1
          top_signame: soc_wkup_async
        }
        {
          name: soc_rst_req_async
          desc: Reset request from SoC, asynchronous, level-encoded
          struct: logic
          type: uni
          act: rcv
          width: 1
          inst_name: soc_proxy
          default: ""
          package: ""
          external: true
          conn_type: false
          index: -1
          top_signame: soc_rst_req_async
        }
        {
          name: soc_gpi_async
          desc: GPI from SoC, async
          struct: logic
          type: uni
          act: req
          width: 16
          inst_name: soc_proxy
          default: ""
          package: ""
          external: true
          conn_type: false
          index: -1
          top_signame: soc_gpi_async
        }
        {
          name: soc_gpo_async
          desc: GPO from SoC, async
          struct: logic
          type: uni
          act: rcv
          width: 16
          inst_name: soc_proxy
          default: ""
          package: ""
          external: true
          conn_type: false
          index: -1
          top_signame: soc_gpo_async
        }
        {
          name: integrator_id
          desc: Integrator ID signal used in BAT
          struct: logic
          type: uni
          act: rcv
          width: 4
          inst_name: soc_proxy
          default: ""
          package: ""
          external: true
          conn_type: false
          index: -1
          top_signame: integrator_id
        }
        {
          name: core_tl
          struct: tl
          package: tlul_pkg
          type: req_rsp
          act: rsp
          width: 1
          inst_name: soc_proxy
          default: ""
          end_idx: -1
          top_type: one-to-one
          top_signame: soc_proxy_core_tl
          index: -1
          external: true
          conn_type: false
        }
        {
          name: ctn_tl
          struct: tl
          package: tlul_pkg
          type: req_rsp
          act: rsp
          width: 1
          inst_name: soc_proxy
          default: ""
          end_idx: -1
          top_type: one-to-one
          top_signame: soc_proxy_ctn_tl
          index: -1
          external: true
          conn_type: false
        }
      ]
      generate_dif: true
    }
    {
      name: sram_ctrl_ret
      type: sram_ctrl
      clock_srcs:
      {
        clk_i: io
        clk_otp_i: io
      }
      clock_group: infra
      reset_connections:
      {
        rst_ni:
        {
          name: lc_io
          domain: Aon
        }
        rst_otp_ni:
        {
          name: lc_io
          domain: Aon
        }
      }
      domain: Aon
      param_decl:
      {
        InstrExec: "0"
        InstSize: 4096
      }
      base_addrs:
      {
        regs:
        {
          hart: 0x30500000
        }
        ram:
        {
          hart: 0x30600000
        }
      }
      memory:
      {
        ram:
        {
          label: ram_ret_aon
          swaccess: rw
          data_intg_passthru: "true"
          exec: True
          byte_write: True
          size: 0x1000
        }
      }
      clock_connections:
      {
        clk_i: clkmgr_clocks.clk_io_infra
        clk_otp_i: clkmgr_clocks.clk_io_infra
      }
      param_list:
      [
        {
          name: MemSizeRam
          desc:
            '''
            Memory size of the RAM (in bytes).
            If address scrambling is enabled, this must be a power of 2 or a multiple of
            2 KiB, and non-power-of-2 sizes that are not a multiple of 16 KiB trigger a lint
            error.
            For details, check the SRAM scrambling primitive (prim_ram_1p_scr).
            '''
          type: int
          name_top: MemSizeSramCtrlRetRam
          default: 4096
        }
        {
          name: InstSize
          desc: Memory size of a single RAM tile (in bytes).
          type: int
          default: 4096
          local: "false"
          expose: "true"
          name_top: SramCtrlRetInstSize
        }
        {
          name: NumRamInst
          desc: Number of internal RAM instances. Must be the same as ceil(MemSizeRam / InstSize) .
          type: int
          default: 1
          local: "false"
          expose: "true"
          name_top: SramCtrlRetNumRamInst
        }
        {
          name: InstrExec
          desc: Support execution from SRAM
          type: bit
          default: "0"
          local: "false"
          expose: "true"
          name_top: SramCtrlRetInstrExec
        }
        {
          name: NumPrinceRoundsHalf
          desc: Number of PRINCE half rounds for the SRAM scrambling feature
          type: int
          default: "3"
          local: "false"
          expose: "true"
          name_top: SramCtrlRetNumPrinceRoundsHalf
        }
        {
          name: NumAddrScrRounds
          desc: Number of address scrambling rounds. 0 disables address scrambling.
          type: int
          default: "2"
          local: "false"
          expose: "true"
          name_top: SramCtrlRetNumAddrScrRounds
        }
        {
          name: Outstanding
          desc: Number of outstanding TLUL transactions
          type: int
          default: "2"
          local: "true"
          expose: "true"
          name_top: SramCtrlRetOutstanding
        }
        {
          name: EccCorrection
          desc: Enable single-bit error correction and error logging
          type: bit
          default: "0"
          local: "false"
          expose: "true"
          name_top: SramCtrlRetEccCorrection
        }
        {
          name: SecZeroInit
          desc: Initialize the memory with zeros instead of pseudo-random data.
          type: bit
          default: "0"
          local: "false"
          expose: "true"
          name_top: SecSramCtrlRetZeroInit
        }
      ]
      inter_signal_list:
      [
        {
          name: sram_otp_key
          struct: sram_otp_key
          package: otp_ctrl_pkg
          type: req_rsp
          act: req
          width: 1
          inst_name: sram_ctrl_ret
          default: ""
          domain: Aon
          top_signame: otp_ctrl_sram_otp_key
          index: -1
          external: true
          conn_type: false
        }
        {
          name: ram_cfg
          struct: ram_1p_cfg
          package: prim_ram_1p_pkg
          type: req_rsp
          act: rsp
          width:
          {
            name: NumRamInst
            desc: Number of internal RAM instances. Must be the same as ceil(MemSizeRam / InstSize) .
            param_type: int
            unpacked_dimensions: null
            default: 1
            local: false
            expose: true
            name_top: SramCtrlRetNumRamInst
          }
          inst_name: sram_ctrl_ret
          default: ""
          external: true
          conn_type: false
          index: -1
          top_signame: sram_ctrl_ret_ram_cfg
        }
        {
          name: lc_escalate_en
          struct: lc_tx
          package: lc_ctrl_pkg
          type: uni
          act: rcv
          width: 1
          default: lc_ctrl_pkg::Off
          inst_name: sram_ctrl_ret
          domain: Aon
          top_signame: lc_ctrl_lc_escalate_en
          index: -1
          external: true
          conn_type: false
        }
        {
          name: lc_hw_debug_en
          struct: lc_tx
          package: lc_ctrl_pkg
          type: uni
          act: rcv
          width: 1
          default: lc_ctrl_pkg::Off
          inst_name: sram_ctrl_ret
          index: -1
        }
        {
          name: otp_en_sram_ifetch
          struct: mubi8
          package: prim_mubi_pkg
          type: uni
          act: rcv
          width: 1
          default: prim_mubi_pkg::MuBi8False
          inst_name: sram_ctrl_ret
          index: -1
        }
        {
          name: racl_policies
          desc:
            '''
            Incoming RACL policy vector from a racl_ctrl instance.
            The policy selection vector (parameter) selects the policy for each register.
            '''
          struct: racl_policy_vec
          package: top_racl_pkg
          type: uni
          act: rcv
          width: 1
          inst_name: sram_ctrl_ret
          index: -1
        }
        {
          name: racl_error
          desc: RACL error log information of this module.
          struct: racl_error_log
          package: top_racl_pkg
          type: uni
          act: req
          width: 1
          inst_name: sram_ctrl_ret
          index: -1
        }
        {
          name: sram_rerror
          desc: SRAM read error indicating correctable and uncorrectable ECC errors.
          struct: sram_error_t
          package: sram_ctrl_pkg
          type: uni
          act: req
          width: 1
          inst_name: sram_ctrl_ret
          index: -1
        }
        {
          name: regs_tl
          struct: tl
          package: tlul_pkg
          type: req_rsp
          act: rsp
          width: 1
          inst_name: sram_ctrl_ret
          default: ""
          end_idx: -1
          top_type: one-to-one
          top_signame: sram_ctrl_ret_regs_tl
          index: -1
          external: true
          conn_type: false
        }
        {
          name: ram_tl
          struct: tl
          package: tlul_pkg
          type: req_rsp
          act: rsp
          width: 1
          inst_name: sram_ctrl_ret
          default: ""
          end_idx: -1
          top_type: one-to-one
          top_signame: sram_ctrl_ret_ram_tl
          index: -1
          external: true
          conn_type: false
        }
      ]
      generate_dif: true
    }
    {
      name: rv_dm
      type: rv_dm
      clock_srcs:
      {
        clk_i: main
        clk_lc_i: main
      }
      clock_group: infra
      reset_connections:
      {
        rst_ni:
        {
          name: sys
          domain: Main
        }
        rst_lc_ni:
        {
          name: lc
          domain: Main
        }
      }
      base_addrs:
      {
        mem:
        {
          hart: 0x00040000
        }
        regs:
        {
          hart: 0x21200000
        }
        dbg:
        {
          soc_dbg: 0x00000000
        }
      }
      param_decl:
      {
        SecVolatileRawUnlockEn: top_pkg::SecVolatileRawUnlockEn
        UseDmiInterface: "1"
      }
      generate_dif: false
      domain: Main
      clock_connections:
      {
        clk_i: clkmgr_clocks_i.clk_main_infra
        clk_lc_i: clkmgr_clocks_i.clk_main_infra
      }
      memory: {}
      param_list:
      [
        {
          name: IdcodeValue
          desc: RISC-V debug module JTAG ID code.
          type: logic [31:0]
          default: 32'h 0000_0001
          local: "false"
          expose: "true"
          name_top: RvDmIdcodeValue
        }
        {
          name: UseDmiInterface
          desc: When 1, a TLUL-based DMI interface is used. When 0, a JTAG TAP is used.
          type: bit
          default: "1"
          local: "false"
          expose: "true"
          name_top: RvDmUseDmiInterface
        }
        {
          name: CheriotSupport
          desc: When 1, cheriot_ena can select CHERIoT mode. When 0, the CHERIoT logic is removed.
          type: bit
          default: "0"
          local: "false"
          expose: "true"
          name_top: RvDmCheriotSupport
        }
        {
          name: SecVolatileRawUnlockEn
          desc:
            '''
            Disable (0) or enable (1) volatile RAW UNLOCK capability.
            If enabled, the strap_en_override_i input can be used to re-sample the straps at runtime.
            IMPORTANT NOTE: This should only be used in test chips. The parameter must be set
            to 0 in production tapeouts since this weakens the security posture of the RAW
            UNLOCK mechanism.
            '''
          type: bit
          default: top_pkg::SecVolatileRawUnlockEn
          local: "false"
          expose: "true"
          name_top: SecRvDmVolatileRawUnlockEn
        }
        {
          name: TlulHostUserRsvdBits
          desc: TLUL user bits sent on outgoing transfers.
          type: logic [tlul_pkg::RsvdWidth-1:0]
          default: "'0"
          local: "false"
          expose: "true"
          name_top: RvDmTlulHostUserRsvdBits
        }
      ]
      inter_signal_list:
      [
        {
          name: next_dm_addr
          desc:
            '''
            32bit word address of the next debug module.
            Set to 0x0 if this is the last debug module in the chain.
            '''
          struct: next_dm_addr
          package: rv_dm_pkg
          type: uni
          act: rcv
          width: 1
          default: "'0"
          inst_name: rv_dm
          external: true
          conn_type: false
          index: -1
          top_signame: rv_dm_next_dm_addr
        }
        {
          name: jtag
          desc: JTAG signals for the RISC-V TAP.
          struct: jtag
          package: jtag_pkg
          type: req_rsp
          act: rsp
          width: 1
          inst_name: rv_dm
          index: -1
        }
        {
          name: cheriot_ena
          desc:
            '''
            CHERIoT mode enable.
            Selects which ROM and which abstract command encodings the debug module uses.
            Ignored unless CheriotSupport is set.
            '''
          struct: mubi4
          package: prim_mubi_pkg
          type: uni
          act: rcv
          width: 1
          default: prim_mubi_pkg::MuBi4False
          inst_name: rv_dm
          index: -1
        }
        {
          name: lc_init_done
          desc: Lifecycle initialization done signal coming from life cycle controller.
          struct: lc_tx
          package: lc_ctrl_pkg
          type: uni
          act: rcv
          width: 1
          default: lc_ctrl_pkg::Off
          inst_name: rv_dm
          domain: Main
          top_signame: lc_ctrl_lc_init_done
          index: -1
        }
        {
          name: lc_hw_debug_clr
          desc:
            '''
            Multibit life cycle hardware debug clear signal coming from life cycle controller,
            asserted when the hardware debug mechanism was enabled and gets disabled.
            '''
          struct: lc_tx
          package: lc_ctrl_pkg
          type: uni
          act: rcv
          width: 1
          default: lc_ctrl_pkg::Off
          inst_name: rv_dm
          domain: Main
          top_signame: lc_ctrl_lc_hw_debug_clr
          index: -1
        }
        {
          name: lc_hw_debug_en
          desc:
            '''
            Multibit life cycle hardware debug enable signal coming from life cycle controller,
            asserted when the hardware debug mechanisms are enabled in the system.
            '''
          struct: lc_tx
          package: lc_ctrl_pkg
          type: uni
          act: rcv
          width: 1
          default: lc_ctrl_pkg::Off
          inst_name: rv_dm
          domain: Main
          top_signame: lc_ctrl_lc_hw_debug_en
          index: -1
        }
        {
          name: lc_dft_en
          desc:
            '''
            Multibit life cycle hardware debug enable signal coming from life cycle controller,
            asserted when the DFT mechanisms are enabled in the system.
            '''
          struct: lc_tx
          package: lc_ctrl_pkg
          type: uni
          act: rcv
          width: 1
          default: lc_ctrl_pkg::Off
          inst_name: rv_dm
          domain: Main
          top_signame: lc_ctrl_lc_dft_en
          index: -1
        }
        {
          name: pinmux_hw_debug_en
          desc:
            '''
            Multibit life cycle hardware debug enable signal coming from pinmux.
            This is a latched version of the lc_hw_debug_en signal and is only used to
            gate the JTAG / TAP side of the RV_DM. It is used to keep a debug session live
            while the rest of the system undergoes an NDM reset.
            '''
          struct: lc_tx
          package: lc_ctrl_pkg
          type: uni
          act: rcv
          width: 1
          default: lc_ctrl_pkg::Off
          inst_name: rv_dm
          index: -1
        }
        {
          name: otp_dis_rv_dm_late_debug
          struct: mubi8
          package: prim_mubi_pkg
          type: uni
          act: rcv
          width: 1
          default: prim_mubi_pkg::MuBi8False
          inst_name: rv_dm
          top_signame: rv_dm_otp_dis_rv_dm_late_debug
          index: -1
        }
        {
          name: unavailable
          desc:
            '''
            This signal indicates to the debug module that the main processor is not available
            for debug (e.g. due to a low-power state).
            '''
          struct: logic
          type: uni
          act: rcv
          width: 1
          default: 1'b0
          inst_name: rv_dm
          index: -1
        }
        {
          name: ndmreset_req
          desc: Non-debug module reset request going to the system reset infrastructure.
          struct: logic
          type: uni
          act: req
          width: 1
          inst_name: rv_dm
          default: ""
          package: ""
          end_idx: -1
          top_type: broadcast
          top_signame: rv_dm_ndmreset_req
          index: -1
          external: true
          conn_type: false
        }
        {
          name: dmactive
          desc:
            '''
            This signal indicates whether the debug module is active and can be used to prevent
            power down of the core and bus-attached peripherals.
            '''
          struct: logic
          type: uni
          act: req
          width: 1
          inst_name: rv_dm
          index: -1
        }
        {
          name: debug_req
          desc: This is the debug request interrupt going to the main processor.
          struct: logic [rv_dm_reg_pkg::NrHarts-1:0]
          type: uni
          act: req
          width: 1
          inst_name: rv_dm
          default: ""
          package: ""
          end_idx: -1
          top_type: broadcast
          top_signame: rv_dm_debug_req
          index: -1
        }
        {
          name: lc_escalate_en
          desc:
            '''
            Escalation enable signal coming from life cycle controller, used for invalidating
            the latched lc_hw_debug_en state inside the strap sampling logic.
            '''
          struct: lc_tx
          package: lc_ctrl_pkg
          type: uni
          act: rcv
          width: 1
          default: lc_ctrl_pkg::Off
          inst_name: rv_dm
          domain: Main
          top_signame: lc_ctrl_lc_escalate_en
          index: -1
        }
        {
          name: lc_check_byp_en
          desc:
            '''
            Check bypass enable signal coming from life cycle controller, used for invalidating
            the latched lc_hw_debug_en state inside the strap sampling logic. This signal is asserted
            whenever the life cycle controller performs a life cycle transition. Its main use is
            to skip any background checks inside the life cycle partition of the OTP controller while
            a life cycle transition is in progress.
            '''
          struct: lc_tx
          package: lc_ctrl_pkg
          type: uni
          act: rcv
          width: 1
          default: lc_ctrl_pkg::Off
          inst_name: rv_dm
          domain: Main
          top_signame: lc_ctrl_lc_check_byp_en
          index: -1
        }
        {
          name: strap_en
          desc: This signal is pulsed high by the power manager after reset in order to sample the HW straps.
          struct: logic
          type: uni
          act: rcv
          width: 1
          default: 1'b0
          inst_name: rv_dm
          package: ""
          domain: Main
          top_signame: pwrmgr_strap
          index: -1
          external: true
          conn_type: false
        }
        {
          name: strap_en_override
          desc:
            '''
            This signal transitions from 0 -> 1 by the lc_ctrl manager after volatile RAW_UNLOCK in order to re-sample the HW straps.
            The signal must stay at 1 until reset.
            Note that this is only used in test chips when SecVolatileRawUnlockEn = 1.
            Otherwise this signal is unused.
            '''
          struct: logic
          type: uni
          act: rcv
          width: 1
          default: 1'b0
          inst_name: rv_dm
          package: ""
          domain: Main
          top_signame: lc_ctrl_strap_en_override
          index: -1
        }
        {
          name: racl_policies
          desc:
            '''
            Incoming RACL policy vector from a racl_ctrl instance.
            The policy selection vector (parameter) selects the policy for each register.
            '''
          struct: racl_policy_vec
          package: top_racl_pkg
          type: uni
          act: rcv
          width: 1
          inst_name: rv_dm
          index: -1
        }
        {
          name: racl_error
          desc: RACL error log information of this module.
          struct: racl_error_log
          package: top_racl_pkg
          type: uni
          act: req
          width: 1
          inst_name: rv_dm
          index: -1
        }
        {
          name: sba_tl_h
          struct: tl
          package: tlul_pkg
          type: req_rsp
          act: req
          width: 1
          inst_name: rv_dm
          default: ""
          domain: Main
          top_signame: main_tl_rv_dm__sba
          index: -1
        }
        {
          name: regs_tl_d
          struct: tl
          package: tlul_pkg
          type: req_rsp
          act: rsp
          width: 1
          inst_name: rv_dm
          default: ""
          end_idx: -1
          top_type: one-to-one
          top_signame: rv_dm_regs_tl_d
          index: -1
        }
        {
          name: mem_tl_d
          struct: tl
          package: tlul_pkg
          type: req_rsp
          act: rsp
          width: 1
          inst_name: rv_dm
          default: ""
          end_idx: -1
          top_type: one-to-one
          top_signame: rv_dm_mem_tl_d
          index: -1
        }
        {
          name: dbg_tl_d
          struct: tl
          package: tlul_pkg
          type: req_rsp
          act: rsp
          width: 1
          inst_name: rv_dm
          default: ""
          end_idx: -1
          top_type: one-to-one
          top_signame: rv_dm_dbg_tl_d
          index: -1
        }
      ]
    }
    {
      name: rv_plic
      type: rv_plic
      template_type: rv_plic
      clock_srcs:
      {
        clk_i: main
      }
      clock_group: secure
      reset_connections:
      {
        rst_ni:
        {
          name: lc
          domain: Main
        }
      }
      attr: ipgen
      targets:
      [
        rv_core_ibex
      ]
      domain: Main
      clock_connections:
      {
        clk_i: clkmgr_clocks_i.clk_main_secure
      }
      param_decl: {}
      memory: {}
      param_list: []
      inter_signal_list:
      [
        {
          name: irq
          struct: logic
          type: uni
          act: req
          width: 1
          inst_name: rv_plic
          default: ""
          package: ""
          end_idx: -1
          top_type: broadcast
          top_signame: rv_plic_irq
          index: -1
        }
        {
          name: irq_id
          struct: logic
          type: uni
          act: req
          width: 1
          inst_name: rv_plic
          index: -1
        }
        {
          name: msip
          struct: logic
          type: uni
          act: req
          width: 1
          inst_name: rv_plic
          default: ""
          package: ""
          end_idx: -1
          top_type: broadcast
          top_signame: rv_plic_msip
          index: -1
        }
        {
          name: tl
          struct: tl
          package: tlul_pkg
          type: req_rsp
          act: rsp
          width: 1
          inst_name: rv_plic
          default: ""
          end_idx: -1
          top_type: one-to-one
          top_signame: rv_plic_tl
          index: -1
        }
      ]
      base_addrs:
      {
        null:
        {
          hart: 0x28000000
        }
      }
      generate_dif: true
    }
    {
      name: aes
      type: aes
      clock_srcs:
      {
        clk_i: main
        clk_edn_i: main
      }
      clock_group: trans
      reset_connections:
      {
        rst_ni:
        {
          name: lc
          domain: Main
        }
        rst_edn_ni:
        {
          name: lc
          domain: Main
        }
      }
      param_decl:
      {
        AESGCMEnable: "1"
        SecMasking: "1"
        SecSBoxImpl: aes_pkg::SBoxImplDom
      }
      domain: Main
      clock_connections:
      {
        clk_i: clkmgr_clocks_i.clk_main_aes
        clk_edn_i: clkmgr_clocks_i.clk_main_aes
      }
      memory: {}
      param_list:
      [
        {
          name: AES192Enable
          desc: Disable (0) or enable (1) support for 192-bit key lengths (AES-192).
          type: bit
          default: 1'b1
          local: "false"
          expose: "false"
          name_top: AesAES192Enable
        }
        {
          name: AESGCMEnable
          desc: Disable (0) or enable (1) support for Galois/Counter Mode (GCM) in hardware.
          type: bit
          default: "1"
          local: "false"
          expose: "true"
          name_top: AesAESGCMEnable
        }
        {
          name: SecMasking
          desc:
            '''
            Disable (0) or enable (1) first-order masking of the AES cipher core and the GHASH operation of GCM.
            Masking requires the use of a masked S-Box, see SecSBoxImpl parameter.
            '''
          type: bit
          default: "1"
          local: "false"
          expose: "true"
          name_top: SecAesMasking
        }
        {
          name: SecSBoxImpl
          desc: Selection of the S-Box implementation. See aes_pkg.sv.
          type: aes_pkg::sbox_impl_e
          default: aes_pkg::SBoxImplDom
          local: "false"
          expose: "true"
          name_top: SecAesSBoxImpl
        }
        {
          name: SecStartTriggerDelay
          desc:
            '''
            Manual start trigger delay, useful for SCA measurements.
            A value of e.g. 40 allows the processor to go into sleep before AES starts operation.
            '''
          type: int unsigned
          default: "0"
          local: "false"
          expose: "true"
          name_top: SecAesStartTriggerDelay
        }
        {
          name: SecAllowForcingMasks
          desc:
            '''
            Forbid (0) or allow (1) forcing the masking PRNG output to a constant value via FORCE_MASKS bit in the Auxiliary Control Register.
            Useful for SCA measurements.
            Meaningful only if masking is enabled.
            '''
          type: bit
          default: 1'b0
          local: "false"
          expose: "true"
          name_top: SecAesAllowForcingMasks
        }
        {
          name: SecSkipPRNGReseeding
          desc:
            '''
            Perform (0) or skip (1) PRNG reseeding requests, useful for SCA measurements only.
            The current SCA setup doesn't provide sufficient resources to implement the infrastructure required for PRNG reseeding (CSRNG, EDN).
            To enable SCA resistance evaluations, we need to skip reseeding requests on the SCA platform.
            '''
          type: bit
          default: 1'b0
          local: "false"
          expose: "true"
          name_top: SecAesSkipPRNGReseeding
        }
      ]
      inter_signal_list:
      [
        {
          name: idle
          struct: mubi4
          package: prim_mubi_pkg
          type: uni
          act: req
          width: 1
          inst_name: aes
          default: ""
          domain: Main
          top_signame: clkmgr_idle
          index: 0
          external: true
          conn_type: false
        }
        {
          name: output_valid
          struct: logic
          type: uni
          act: req
          width: 1
          inst_name: aes
          index: -1
        }
        {
          name: input_ready
          struct: logic
          type: uni
          act: req
          width: 1
          inst_name: aes
          index: -1
        }
        {
          name: lc_escalate_en
          struct: lc_tx
          package: lc_ctrl_pkg
          type: uni
          act: rcv
          width: 1
          default: lc_ctrl_pkg::Off
          inst_name: aes
          domain: Main
          top_signame: lc_ctrl_lc_escalate_en
          index: -1
        }
        {
          name: edn
          struct: edn
          package: edn_pkg
          type: req_rsp
          act: req
          width: 1
          inst_name: aes
          default: ""
          domain: Main
          top_signame: edn0_edn
          index: 4
        }
        {
          name: keymgr_key
          struct: hw_key_req
          package: keymgr_dpe_pkg
          type: uni
          act: rcv
          width: 1
          inst_name: aes
          default: ""
          domain: Main
          top_signame: keymgr_dpe_aes_key
          index: -1
        }
        {
          name: tl
          struct: tl
          package: tlul_pkg
          type: req_rsp
          act: rsp
          width: 1
          inst_name: aes
          default: ""
          end_idx: -1
          top_type: one-to-one
          top_signame: aes_tl
          index: -1
        }
      ]
      base_addrs:
      {
        null:
        {
          hart: 0x21100000
        }
      }
      generate_dif: true
    }
    {
      name: hmac
      type: hmac
      clock_srcs:
      {
        clk_i: main
      }
      clock_group: trans
      reset_connections:
      {
        rst_ni:
        {
          name: lc
          domain: Main
        }
      }
      domain: Main
      clock_connections:
      {
        clk_i: clkmgr_clocks_i.clk_main_hmac
      }
      param_decl: {}
      memory: {}
      param_list: []
      inter_signal_list:
      [
        {
          name: idle
          struct: mubi4
          package: prim_mubi_pkg
          type: uni
          act: req
          width: 1
          inst_name: hmac
          default: ""
          domain: Main
          top_signame: clkmgr_idle
          index: 1
          external: true
          conn_type: false
        }
        {
          name: keymgr_key
          struct: wide_hw_key_req
          package: keymgr_dpe_pkg
          type: uni
          act: rcv
          width: 1
          inst_name: hmac
          default: ""
          domain: Main
          top_signame: keymgr_dpe_hmac_key
          index: -1
        }
        {
          name: tl
          struct: tl
          package: tlul_pkg
          type: req_rsp
          act: rsp
          width: 1
          inst_name: hmac
          default: ""
          end_idx: -1
          top_type: one-to-one
          top_signame: hmac_tl
          index: -1
        }
      ]
      base_addrs:
      {
        null:
        {
          hart: 0x21110000
        }
      }
      generate_dif: true
    }
    {
      name: kmac
      type: kmac
      param_decl:
      {
        EnMasking: "1"
        NumAppIntf: 4
        AppCfg:
          '''
          '{kmac_pkg::AppCfgKeyMgr,
                  kmac_pkg::AppCfgLcCtrl,
                  kmac_pkg::AppCfgRomCtrl,
                  kmac_pkg::AppCfgRomCtrl}
          '''
      }
      clock_srcs:
      {
        clk_i: main
        clk_edn_i: main
      }
      clock_group: trans
      reset_connections:
      {
        rst_ni:
        {
          name: lc
          domain: Main
        }
        rst_edn_ni:
        {
          name: lc
          domain: Main
        }
      }
      domain: Main
      clock_connections:
      {
        clk_i: clkmgr_clocks_i.clk_main_kmac
        clk_edn_i: clkmgr_clocks_i.clk_main_kmac
      }
      memory: {}
      param_list:
      [
        {
          name: EnMasking
          desc: Disable(0) or enable(1) first-order masking of Keccak round.
          type: bit
          default: "1"
          local: "false"
          expose: "true"
          name_top: KmacEnMasking
        }
        {
          name: EnFullKmac
          desc:
            '''
            Disable(0) or enable(1) the full KMAC functionality.
            If disabled, the module is stripped down to only support SHA3, SHAKE and cSHAKE.
            '''
          type: bit
          default: "1"
          local: "false"
          expose: "true"
          name_top: KmacEnFullKmac
        }
        {
          name: SwKeyMasked
          desc:
            '''
            Disable(0) or enable(1) software key masking in case masking is disabled (EnMasking == 0).
            If masking is enabled, this parameter has no effect.
            Mainly useful for software interface compatibility between the masked and unmasked design.
            Mostly relevant for SCA measurements.
            '''
          type: bit
          default: "0"
          local: "false"
          expose: "true"
          name_top: KmacSwKeyMasked
        }
        {
          name: SecCmdDelay
          desc:
            '''
            Command delay, useful for SCA measurements only.
            A value of e.g. 40 allows the processor to go into sleep before KMAC starts operation.
            If a value greater than 0 is chosen, software can pass two commands in series.
            The second command is buffered internally and will be presented to the hardware SecCmdDelay number of cycles after the first one.
            '''
          type: int
          default: "0"
          local: "false"
          expose: "true"
          name_top: SecKmacCmdDelay
        }
        {
          name: SecIdleAcceptSwMsg
          desc:
            '''
            If enabled (1), software writes to the message FIFO before having received a START command are not ignored.
            Disabled (0) by default.
            Useful for SCA measurements only.
            '''
          type: bit
          default: "0"
          local: "false"
          expose: "true"
          name_top: SecKmacIdleAcceptSwMsg
        }
        {
          name: NumAppIntf
          desc: Number of application interfaces
          type: int
          default: 4
          local: "false"
          expose: "true"
          name_top: KmacNumAppIntf
        }
        {
          name: AppCfg
          desc:
            '''
            Application interface configuration.
            Top-level connection to the application interface must follow this definition.
            '''
          type: kmac_pkg::app_config_t
          unpacked_dimensions: "[KmacNumAppIntf]"
          default:
            '''
            '{kmac_pkg::AppCfgKeyMgr,
                    kmac_pkg::AppCfgLcCtrl,
                    kmac_pkg::AppCfgRomCtrl,
                    kmac_pkg::AppCfgRomCtrl}
            '''
          local: "false"
          expose: "true"
          name_top: KmacAppCfg
        }
        {
          name: AppIdxKeyMgr
          desc: Index of the keymgr app interface
          type: int
          default: "0"
          local: "false"
          expose: "true"
          name_top: KmacAppIdxKeyMgr
        }
      ]
      inter_signal_list:
      [
        {
          name: keymgr_key
          struct: hw_key_req
          package: keymgr_dpe_pkg
          type: uni
          act: rcv
          width: 1
          inst_name: kmac
          default: ""
          domain: Main
          top_signame: keymgr_dpe_kmac_key
          index: -1
        }
        {
          name: app
          struct: app
          package: kmac_pkg
          type: req_rsp
          act: rsp
          width:
          {
            name: NumAppIntf
            desc: Number of application interfaces
            param_type: int
            unpacked_dimensions: null
            default: 4
            local: false
            expose: true
            name_top: KmacNumAppIntf
          }
          default: kmac_pkg::APP_REQ_DEFAULT
          inst_name: kmac
          end_idx: -1
          top_type: one-to-N
          top_signame: kmac_app
          index: -1
        }
        {
          name: keymgr_sensitive_key
          struct: mubi4
          package: prim_mubi_pkg
          type: uni
          act: rcv
          width: 1
          default: prim_mubi_pkg::MuBi4False
          inst_name: kmac
          end_idx: -1
          top_type: broadcast
          top_signame: kmac_keymgr_sensitive_key
          index: -1
        }
        {
          name: entropy
          struct: edn
          package: edn_pkg
          type: req_rsp
          act: req
          width: 1
          inst_name: kmac
          default: ""
          domain: Main
          top_signame: edn0_edn
          index: 2
        }
        {
          name: idle
          struct: mubi4
          package: prim_mubi_pkg
          type: uni
          act: req
          width: 1
          inst_name: kmac
          default: ""
          domain: Main
          top_signame: clkmgr_idle
          index: 2
          external: true
          conn_type: false
        }
        {
          name: en_masking
          struct: logic
          type: uni
          act: req
          width: 1
          inst_name: kmac
          default: ""
          package: ""
          end_idx: -1
          top_type: broadcast
          top_signame: kmac_en_masking
          index: -1
        }
        {
          name: lc_escalate_en
          struct: lc_tx
          package: lc_ctrl_pkg
          type: uni
          act: rcv
          width: 1
          default: lc_ctrl_pkg::Off
          inst_name: kmac
          domain: Main
          top_signame: lc_ctrl_lc_escalate_en
          index: -1
        }
        {
          name: tl
          struct: tl
          package: tlul_pkg
          type: req_rsp
          act: rsp
          width: 1
          inst_name: kmac
          default: ""
          end_idx: -1
          top_type: one-to-one
          top_signame: kmac_tl
          index: -1
        }
      ]
      base_addrs:
      {
        null:
        {
          hart: 0x21120000
        }
      }
      generate_dif: true
    }
    {
      name: otbn
      type: otbn
      clock_srcs:
      {
        clk_i:
        {
          clock: main
          group: trans
        }
        clk_edn_i:
        {
          clock: main
          group: secure
        }
        clk_otp_i:
        {
          clock: io
          group: secure
        }
      }
      clock_group: trans
      reset_connections:
      {
        rst_ni:
        {
          name: lc
          domain: Main
        }
        rst_edn_ni:
        {
          name: lc
          domain: Main
        }
        rst_otp_ni:
        {
          name: lc_io
          domain: Main
        }
      }
      domain: Main
      clock_connections:
      {
        clk_i: clkmgr_clocks_i.clk_main_otbn
        clk_edn_i: clkmgr_clocks_i.clk_main_secure
        clk_otp_i: clkmgr_clocks_i.clk_io_secure
      }
      param_decl: {}
      memory: {}
      param_list:
      [
        {
          name: Stub
          desc: Stub out the core of Otbn logic
          type: bit
          default: "0"
          local: "false"
          expose: "true"
          name_top: OtbnStub
        }
        {
          name: RegFile
          desc: Selection of the register file implementation. See otbn_pkg.sv.
          type: otbn_pkg::regfile_e
          default: otbn_pkg::RegFileFF
          local: "false"
          expose: "true"
          name_top: OtbnRegFile
        }
        {
          name: SecFixMaiOpSeq
          desc:
            '''
            If enabled (1), masking accelerator interface will not randomize operand start indexes.
            Disabled (0) by default.
            Useful for SCA measurements only.
            '''
          type: bit
          default: "0"
          local: "false"
          expose: "true"
          name_top: SecOtbnFixMaiOpSeq
        }
        {
          name: SecFixMacOpSeq
          desc:
            '''
            If enabled (1), the BN MAC will not randomize the order in which the vector elements are processed for vectorized multiplication instructions.
            Disabled (0) by default.
            Useful for SCA measurements only.
            '''
          type: bit
          default: "0"
          local: "false"
          expose: "true"
          name_top: SecOtbnFixMacOpSeq
        }
        {
          name: SecSkipUrndReseedAtStart
          desc:
            '''
            If enabled (1), URND reseed is skipped at the start of an operation.
            Disabled (0) by default.
            Useful for SCA measurements only.
            '''
          type: bit
          default: "0"
          local: "false"
          expose: "true"
          name_top: SecOtbnSkipUrndReseedAtStart
        }
        {
          name: FeatStubMai
          desc:
            '''
            If enabled (1), MAI and mask accelerator are not preset in the design.
            Disabled (0) by default.
            Useful for resource-bound targets only. Can break software setups and DV.
            '''
          type: bit
          default: "0"
          local: "false"
          expose: "true"
          name_top: OtbnFeatStubMai
        }
      ]
      inter_signal_list:
      [
        {
          name: otbn_otp_key
          struct: otbn_otp_key
          package: otp_ctrl_pkg
          type: req_rsp
          act: req
          width: 1
          default: "'0"
          inst_name: otbn
          domain: Main
          top_signame: otp_ctrl_otbn_otp_key
          index: -1
        }
        {
          name: edn_rnd
          struct: edn
          package: edn_pkg
          type: req_rsp
          act: req
          width: 1
          inst_name: otbn
          default: ""
          domain: Main
          top_signame: edn1_edn
          index: 0
        }
        {
          name: edn_urnd
          struct: edn
          package: edn_pkg
          type: req_rsp
          act: req
          width: 1
          inst_name: otbn
          default: ""
          domain: Main
          top_signame: edn0_edn
          index: 5
        }
        {
          name: idle
          struct: mubi4
          package: prim_mubi_pkg
          type: uni
          act: req
          width: 1
          inst_name: otbn
          default: ""
          domain: Main
          top_signame: clkmgr_idle
          index: 3
          external: true
          conn_type: false
        }
        {
          name: ram_cfg_imem
          struct: ram_1p_cfg
          package: prim_ram_1p_pkg
          type: req_rsp
          act: rsp
          width: 1
          inst_name: otbn
          default: ""
          external: true
          conn_type: false
          index: -1
          top_signame: otbn_imem_ram_cfg
        }
        {
          name: ram_cfg_dmem
          struct: ram_1p_cfg
          package: prim_ram_1p_pkg
          type: req_rsp
          act: rsp
          width: 1
          inst_name: otbn
          default: ""
          external: true
          conn_type: false
          index: -1
          top_signame: otbn_dmem_ram_cfg
        }
        {
          name: lc_escalate_en
          struct: lc_tx
          package: lc_ctrl_pkg
          type: uni
          act: rcv
          width: 1
          default: lc_ctrl_pkg::Off
          inst_name: otbn
          domain: Main
          top_signame: lc_ctrl_lc_escalate_en
          index: -1
        }
        {
          name: lc_rma_req
          struct: lc_tx
          package: lc_ctrl_pkg
          type: uni
          act: rcv
          width: 1
          default: lc_ctrl_pkg::Off
          inst_name: otbn
          domain: Main
          top_signame: lc_ctrl_lc_nvm_rma_req
          index: -1
        }
        {
          name: lc_rma_ack
          struct: lc_tx
          package: lc_ctrl_pkg
          type: uni
          act: req
          width: 1
          default: lc_ctrl_pkg::Off
          inst_name: otbn
          end_idx: -1
          top_type: broadcast
          top_signame: otbn_lc_rma_ack
          index: -1
        }
        {
          name: keymgr_key
          struct: wide_hw_key_req
          package: keymgr_dpe_pkg
          type: uni
          act: rcv
          width: 1
          inst_name: otbn
          default: ""
          domain: Main
          top_signame: keymgr_dpe_otbn_key
          index: -1
        }
        {
          name: kmac_app
          struct: app
          package: kmac_pkg
          type: req_rsp
          act: req
          width: 1
          inst_name: otbn
          index: -1
        }
        {
          name: keymgr_app
          struct: app
          package: kmac_pkg
          type: req_rsp
          act: rsp
          width: 1
          inst_name: otbn
          default: ""
          end_idx: -1
          top_type: one-to-one
          top_signame: otbn_keymgr_app
          index: -1
        }
        {
          name: keymgr_sensitive_key
          struct: mubi4
          package: prim_mubi_pkg
          type: uni
          act: rcv
          width: 1
          default: prim_mubi_pkg::MuBi4False
          inst_name: otbn
          end_idx: -1
          top_type: broadcast
          top_signame: otbn_keymgr_sensitive_key
          index: -1
        }
        {
          name: tl
          struct: tl
          package: tlul_pkg
          type: req_rsp
          act: rsp
          width: 1
          inst_name: otbn
          default: ""
          end_idx: -1
          top_type: one-to-one
          top_signame: otbn_tl
          index: -1
        }
      ]
      base_addrs:
      {
        null:
        {
          hart: 0x21130000
        }
      }
      generate_dif: true
    }
    {
      name: keymgr_dpe
      type: keymgr_dpe
      clock_srcs:
      {
        clk_i: main
        clk_edn_i: main
      }
      clock_group: secure
      reset_connections:
      {
        rst_ni:
        {
          name: lc
          domain: Main
        }
        rst_edn_ni:
        {
          name: lc
          domain: Main
        }
      }
      param_decl:
      {
        NumInstHwSlot: "8"
        NumBootStages: "2"
        NumRomDigestInputs: "2"
        KdfEngineSel: keymgr_dpe_pkg::KdfEngineBoth
      }
      domain: Main
      clock_connections:
      {
        clk_i: clkmgr_clocks_i.clk_main_secure
        clk_edn_i: clkmgr_clocks_i.clk_main_secure
      }
      memory: {}
      param_list:
      [
        {
          name: KmacEnMasking
          desc: Flag indicating with kmac masking is enabled
          type: bit
          default: "1"
          local: "false"
          expose: "true"
          name_top: KeymgrDpeKmacEnMasking
        }
        {
          name: NumInstHwSlot
          desc: Number of instantiated HW slots
          type: int
          default: "8"
          local: "true"
          expose: "true"
          name_top: KeymgrDpeNumInstHwSlot
        }
        {
          name: NumBootStages
          desc: Number of available boot stages. Supported values are 2 and 4.
          type: int
          default: "2"
          local: "true"
          expose: "true"
          name_top: KeymgrDpeNumBootStages
        }
        {
          name: NumRomDigestInputs
          desc: Number of digest inputs from ROM_CTRL
          type: int
          default: "2"
          local: "true"
          expose: "true"
          name_top: KeymgrDpeNumRomDigestInputs
        }
        {
          name: KdfEngineSel
          desc:
            '''
            Determines the possible KDF engines for the keymgr_dpe.
            Supported options are:
            - KdfEngineKmac: Uses exclusively `kmac` as kdf engine.
            - KdfEngineOtbn: Uses exclusively `otbn` as kdf engine.
            - KdfEngineBoth: The register !!KDF_ENGINE_SHADOWED selects if either the `kmac` or the `otbn` is used.
            '''
          type: keymgr_dpe_pkg::kdf_engine_sel_e
          default: keymgr_dpe_pkg::KdfEngineBoth
          local: "true"
          expose: "true"
          name_top: KeymgrDpeKdfEngineSel
        }
      ]
      inter_signal_list:
      [
        {
          name: edn
          struct: edn
          package: edn_pkg
          type: req_rsp
          act: req
          width: 1
          inst_name: keymgr_dpe
          default: ""
          domain: Main
          top_signame: edn0_edn
          index: 0
        }
        {
          name: aes_key
          struct: hw_key_req
          package: keymgr_dpe_pkg
          type: uni
          act: req
          width: 1
          inst_name: keymgr_dpe
          default: ""
          end_idx: -1
          top_type: broadcast
          top_signame: keymgr_dpe_aes_key
          index: -1
        }
        {
          name: kmac_key
          struct: hw_key_req
          package: keymgr_dpe_pkg
          type: uni
          act: req
          width: 1
          inst_name: keymgr_dpe
          default: ""
          end_idx: -1
          top_type: broadcast
          top_signame: keymgr_dpe_kmac_key
          index: -1
        }
        {
          name: hmac_key
          struct: wide_hw_key_req
          package: keymgr_dpe_pkg
          type: uni
          act: req
          width: 1
          inst_name: keymgr_dpe
          default: ""
          end_idx: -1
          top_type: broadcast
          top_signame: keymgr_dpe_hmac_key
          index: -1
        }
        {
          name: otbn_key
          struct: wide_hw_key_req
          package: keymgr_dpe_pkg
          type: uni
          act: req
          width: 1
          inst_name: keymgr_dpe
          default: ""
          end_idx: -1
          top_type: broadcast
          top_signame: keymgr_dpe_otbn_key
          index: -1
        }
        {
          name: kmac_app
          struct: app
          package: kmac_pkg
          type: req_rsp
          act: req
          width: 1
          inst_name: keymgr_dpe
          default: ""
          domain: Main
          top_signame: kmac_app
          index: 0
        }
        {
          name: kmac_sensitive_key
          struct: mubi4
          package: prim_mubi_pkg
          type: uni
          act: req
          width: 1
          default: prim_mubi_pkg::MuBi4False
          inst_name: keymgr_dpe
          domain: Main
          top_signame: kmac_keymgr_sensitive_key
          index: -1
        }
        {
          name: otbn_app
          struct: app
          package: kmac_pkg
          type: req_rsp
          act: req
          width: 1
          inst_name: keymgr_dpe
          default: ""
          domain: Main
          top_signame: otbn_keymgr_app
          index: -1
        }
        {
          name: otbn_sensitive_key
          struct: mubi4
          package: prim_mubi_pkg
          type: uni
          act: req
          width: 1
          default: prim_mubi_pkg::MuBi4False
          inst_name: keymgr_dpe
          domain: Main
          top_signame: otbn_keymgr_sensitive_key
          index: -1
        }
        {
          name: creator_root_key
          struct: keymgr_dpe_creator_root_key
          package: keymgr_dpe_pkg
          type: uni
          act: rcv
          width: 1
          inst_name: keymgr_dpe
          default: ""
          domain: Main
          top_signame: otp_ctrl_keymgr_creator_root_key
          index: -1
        }
        {
          name: secondary_root_key
          struct: keymgr_dpe_creator_root_key
          package: keymgr_dpe_pkg
          type: uni
          act: rcv
          width: 1
          default: keymgr_dpe_pkg::KEYMGR_DPE_SECONDARY_ROOT_KEY_DEFAULT
          inst_name: keymgr_dpe
          index: -1
        }
        {
          name: creator_seed
          struct: keymgr_dpe_creator_seed
          package: keymgr_dpe_pkg
          type: uni
          act: rcv
          width: 1
          inst_name: keymgr_dpe
          default: ""
          domain: Main
          top_signame: otp_ctrl_keymgr_creator_seed
          index: -1
        }
        {
          name: owner_seed
          struct: keymgr_dpe_owner_seed
          package: keymgr_dpe_pkg
          type: uni
          act: rcv
          width: 1
          inst_name: keymgr_dpe
          default: ""
          domain: Main
          top_signame: otp_ctrl_keymgr_owner_seed
          index: -1
        }
        {
          name: device_id
          struct: keymgr_dpe_device_id
          package: keymgr_dpe_pkg
          type: uni
          act: rcv
          width: 1
          inst_name: keymgr_dpe
          default: ""
          top_signame: keymgr_dpe_device_id
          index: -1
        }
        {
          name: field_entropy
          struct: keymgr_dpe_field_entropy
          package: keymgr_dpe_pkg
          type: uni
          act: rcv
          width: 1
          inst_name: keymgr_dpe
          index: -1
        }
        {
          name: lc_keymgr_en
          struct: lc_tx
          package: lc_ctrl_pkg
          type: uni
          act: rcv
          width: 1
          default: lc_ctrl_pkg::On
          inst_name: keymgr_dpe
          domain: Main
          top_signame: lc_ctrl_lc_keymgr_en
          index: -1
        }
        {
          name: lc_keymgr_div
          struct: lc_keymgr_div
          package: lc_ctrl_pkg
          type: uni
          act: rcv
          width: 1
          inst_name: keymgr_dpe
          default: ""
          domain: Main
          top_signame: lc_ctrl_lc_keymgr_div
          index: -1
        }
        {
          name: rom_digest
          struct: keymgr_data
          package: rom_ctrl_pkg
          type: uni
          act: rcv
          width:
          {
            name: NumRomDigestInputs
            desc: Number of digest inputs from ROM_CTRL
            param_type: int
            unpacked_dimensions: null
            default: 1
            local: true
            expose: true
            name_top: KeymgrDpeNumRomDigestInputs
          }
          default: rom_ctrl_pkg::KEYMGR_DATA_DEFAULT
          inst_name: keymgr_dpe
          end_idx: -1
          top_type: one-to-N
          top_signame: keymgr_dpe_rom_digest
          index: -1
        }
        {
          name: kmac_en_masking
          struct: logic
          type: uni
          act: rcv
          width: 1
          inst_name: keymgr_dpe
          default: ""
          package: ""
          domain: Main
          top_signame: kmac_en_masking
          index: -1
        }
        {
          name: tl
          struct: tl
          package: tlul_pkg
          type: req_rsp
          act: rsp
          width: 1
          inst_name: keymgr_dpe
          default: ""
          end_idx: -1
          top_type: one-to-one
          top_signame: keymgr_dpe_tl
          index: -1
        }
      ]
      base_addrs:
      {
        null:
        {
          hart: 0x21140000
        }
      }
      generate_dif: true
    }
    {
      name: csrng
      type: csrng
      clock_srcs:
      {
        clk_i: main
      }
      clock_group: secure
      reset_connections:
      {
        rst_ni:
        {
          name: lc
          domain: Main
        }
      }
      domain: Main
      clock_connections:
      {
        clk_i: clkmgr_clocks_i.clk_main_secure
      }
      param_decl: {}
      memory: {}
      param_list:
      [
        {
          name: SBoxImpl
          desc: Selection of the S-Box implementation. See aes_pkg.sv.
          type: aes_pkg::sbox_impl_e
          default: aes_pkg::SBoxImplCanright
          local: "false"
          expose: "true"
          name_top: CsrngSBoxImpl
        }
      ]
      inter_signal_list:
      [
        {
          name: csrng_cmd
          struct: csrng
          package: csrng_pkg
          type: req_rsp
          act: rsp
          width: 2
          inst_name: csrng
          default: ""
          end_idx: -1
          top_type: one-to-N
          top_signame: csrng_csrng_cmd
          index: -1
        }
        {
          name: entropy_src_hw_if
          struct: entropy_src_hw_if
          package: entropy_src_pkg
          type: req_rsp
          act: req
          width: 1
          inst_name: csrng
          default: ""
          end_idx: -1
          top_type: one-to-one
          top_signame: csrng_entropy_src_hw_if
          index: -1
        }
        {
          name: lc_hw_debug_en
          struct: lc_tx
          package: lc_ctrl_pkg
          type: uni
          act: rcv
          width: 1
          default: lc_ctrl_pkg::Off
          inst_name: csrng
          domain: Main
          top_signame: lc_ctrl_lc_hw_debug_en
          index: -1
        }
        {
          name: tl
          struct: tl
          package: tlul_pkg
          type: req_rsp
          act: rsp
          width: 1
          inst_name: csrng
          default: ""
          end_idx: -1
          top_type: one-to-one
          top_signame: csrng_tl
          index: -1
        }
      ]
      base_addrs:
      {
        null:
        {
          hart: 0x21150000
        }
      }
      generate_dif: true
    }
    {
      name: entropy_src
      type: entropy_src
      clock_srcs:
      {
        clk_i: main
      }
      clock_group: secure
      reset_connections:
      {
        rst_ni:
        {
          name: lc
          domain: Main
        }
      }
      param_decl:
      {
        RngBusWidth: "16"
        RngBusBitSelWidth: "4"
        HealthTestWindowWidth: "20"
        DistrFifoDepth: "11"
      }
      domain: Main
      clock_connections:
      {
        clk_i: clkmgr_clocks_i.clk_main_secure
      }
      memory: {}
      param_list:
      [
        {
          name: RngBusWidth
          desc:
            '''
            Defines the bit-width of the noise source data.
            Must be between 4 and 256 (inclusive) and divisible by 4.
            The divisibility by 4 is a prerequisite for the bucket health test.
            '''
          type: int
          default: "16"
          local: "false"
          expose: "true"
          name_top: EntropySrcRngBusWidth
        }
        {
          name: RngBusBitSelWidth
          desc: Explicit parameter defining the width of the RNG bit selection vector (log2(RngBusWidth))
          type: int
          default: "4"
          local: "false"
          expose: "true"
          name_top: EntropySrcRngBusBitSelWidth
        }
        {
          name: HealthTestWindowWidth
          desc: Explicit parameter defining the width of the health test window (16 + log2(RngBusWidth))
          type: int
          default: "20"
          local: "false"
          expose: "true"
          name_top: EntropySrcHealthTestWindowWidth
        }
        {
          name: EsFifoDepth
          desc: Number of 384-bit entries in the esfinal FIFO
          type: int
          default: "3"
          local: "true"
          expose: "true"
          name_top: EntropySrcEsFifoDepth
        }
        {
          name: DistrFifoDepth
          desc: Number of 32-bit entries in the distr FIFO
          type: int unsigned
          default: "11"
          local: "true"
          expose: "true"
          name_top: EntropySrcDistrFifoDepth
        }
        {
          name: Stub
          desc: Stub out the core of entropy_src logic
          type: bit
          default: "0"
          local: "false"
          expose: "true"
          name_top: EntropySrcStub
        }
      ]
      inter_signal_list:
      [
        {
          name: entropy_src_hw_if
          struct: entropy_src_hw_if
          package: entropy_src_pkg
          type: req_rsp
          act: rsp
          width: 1
          inst_name: entropy_src
          default: ""
          domain: Main
          top_signame: csrng_entropy_src_hw_if
          index: -1
        }
        {
          name: entropy_src_rng_enable
          desc:
            '''
            Signal through which entropy_src enables the noise source.
            entropy_src will keep this signal high as long as it expects the noise source to operate.
            This is *not* a flow control signal through which entropy_src would exert backpressure on the noise source; rather this signal stays high while entropy_src is enabled.
            '''
          struct: logic
          type: uni
          act: req
          width: 1
          inst_name: entropy_src
          default: ""
          package: ""
          external: true
          conn_type: false
          index: -1
          top_signame: es_rng_enable
        }
        {
          name: entropy_src_rng_valid
          desc:
            '''
            Acknowledgement signal from the noise source.
            When '1', it indicates that the `entropy_src_rng_bit` data is valid and ready to be consumed.
            '''
          struct: logic
          type: uni
          act: rcv
          width: 1
          inst_name: entropy_src
          default: ""
          package: ""
          external: true
          conn_type: false
          index: -1
          top_signame: es_rng_valid
        }
        {
          name: entropy_src_rng_bits
          desc:
            '''
            Output data bus carrying the raw entropy bits from the noise source.
            These bits are valid when `entropy_src_rng_valid` is asserted.
            The width is determined by `RngBusWidth` parametrization.
            '''
          struct: logic
          type: uni
          act: rcv
          width:
          {
            name: RngBusWidth
            desc:
              '''
              Defines the bit-width of the noise source data.
              Must be between 4 and 256 (inclusive) and divisible by 4.
              The divisibility by 4 is a prerequisite for the bucket health test.
              '''
            param_type: int
            unpacked_dimensions: null
            default: 4
            local: false
            expose: true
            name_top: EntropySrcRngBusWidth
          }
          inst_name: entropy_src
          default: ""
          package: ""
          external: true
          conn_type: false
          index: -1
          top_signame: es_rng_bit
        }
        {
          name: entropy_src_xht_valid
          desc:
            '''
            Valid signal for the external health test interface.
            When asserted, it indicates that `entropy_src_xht_bits`, `entropy_src_xht_bit_sel`, and `entropy_src_xht_meta` are valid for consumption by the external health test.
            '''
          struct: logic
          type: uni
          act: req
          width: 1
          inst_name: entropy_src
          index: -1
        }
        {
          name: entropy_src_xht_bits
          desc:
            '''
            Carries the raw entropy data from the entropy source to be consumed by the external health test module.
            The data on this bus is valid when `entropy_src_xht_valid` is asserted.
            The width is determined by `RngBusWidth` parametrization.
            '''
          struct: logic
          type: uni
          act: req
          width:
          {
            name: RngBusWidth
            desc:
              '''
              Defines the bit-width of the noise source data.
              Must be between 4 and 256 (inclusive) and divisible by 4.
              The divisibility by 4 is a prerequisite for the bucket health test.
              '''
            param_type: int
            unpacked_dimensions: null
            default: 4
            local: false
            expose: true
            name_top: EntropySrcRngBusWidth
          }
          inst_name: entropy_src
          index: -1
        }
        {
          name: entropy_src_xht_bit_sel
          desc:
            '''
            Provides bit selection information for the raw entropy data.
            It specifies which specific bit or subset of bits from `entropy_src_xht_bit` should be used.
            The width is determined by `RngBusBitSelWidth` parametrization.
            '''
          struct: logic
          type: uni
          act: req
          width:
          {
            name: RngBusBitSelWidth
            desc: Explicit parameter defining the width of the RNG bit selection vector (log2(RngBusWidth))
            param_type: int
            unpacked_dimensions: null
            default: 2
            local: false
            expose: true
            name_top: EntropySrcRngBusBitSelWidth
          }
          inst_name: entropy_src
          index: -1
        }
        {
          name: entropy_src_xht_health_test_window
          desc: Provides the window size of the health in bits.
          struct: logic
          type: uni
          act: req
          width:
          {
            name: HealthTestWindowWidth
            desc: Explicit parameter defining the width of the health test window (16 + log2(RngBusWidth))
            param_type: int
            unpacked_dimensions: null
            default: 18
            local: false
            expose: true
            name_top: EntropySrcHealthTestWindowWidth
          }
          inst_name: entropy_src
          index: -1
        }
        {
          name: entropy_src_xht_meta
          struct: entropy_src_xht_meta
          package: entropy_src_pkg
          type: req_rsp
          act: req
          width: 1
          inst_name: entropy_src
          index: -1
        }
        {
          name: rng_fips
          struct: logic
          type: uni
          act: req
          width: 1
          inst_name: entropy_src
          default: ""
          package: ""
          external: true
          conn_type: false
          index: -1
          top_signame: es_rng_fips
        }
        {
          name: tl
          struct: tl
          package: tlul_pkg
          type: req_rsp
          act: rsp
          width: 1
          inst_name: entropy_src
          default: ""
          end_idx: -1
          top_type: one-to-one
          top_signame: entropy_src_tl
          index: -1
        }
      ]
      base_addrs:
      {
        null:
        {
          hart: 0x21160000
        }
      }
      generate_dif: true
    }
    {
      name: edn0
      type: edn
      clock_srcs:
      {
        clk_i: main
      }
      clock_group: secure
      reset_connections:
      {
        rst_ni:
        {
          name: lc
          domain: Main
        }
      }
      param_decl:
      {
        NumEndPoints: "8"
      }
      domain: Main
      clock_connections:
      {
        clk_i: clkmgr_clocks_i.clk_main_secure
      }
      memory: {}
      param_list:
      [
        {
          name: NumEndPoints
          desc: Number of endpoints
          type: int unsigned
          default: "8"
          local: "true"
          expose: "true"
          name_top: Edn0NumEndPoints
        }
      ]
      inter_signal_list:
      [
        {
          name: csrng_cmd
          desc: EDN supports a single CSRNG application interface.
          struct: csrng
          package: csrng_pkg
          type: req_rsp
          act: req
          width: 1
          inst_name: edn0
          default: ""
          domain: Main
          top_signame: csrng_csrng_cmd
          index: 0
        }
        {
          name: edn
          desc: Every endpoint has its own peripheral port.
          struct: edn
          package: edn_pkg
          type: req_rsp
          act: rsp
          width:
          {
            name: NumEndPoints
            desc: Number of endpoints
            param_type: int unsigned
            unpacked_dimensions: null
            default: 8
            local: true
            expose: true
            name_top: Edn0NumEndPoints
          }
          default: "'0"
          inst_name: edn0
          end_idx: 7
          top_type: partial-one-to-N
          top_signame: edn0_edn
          index: -1
        }
        {
          name: tl
          struct: tl
          package: tlul_pkg
          type: req_rsp
          act: rsp
          width: 1
          inst_name: edn0
          default: ""
          end_idx: -1
          top_type: one-to-one
          top_signame: edn0_tl
          index: -1
        }
      ]
      base_addrs:
      {
        null:
        {
          hart: 0x21170000
        }
      }
      generate_dif: true
    }
    {
      name: edn1
      type: edn
      clock_srcs:
      {
        clk_i: main
      }
      clock_group: secure
      reset_connections:
      {
        rst_ni:
        {
          name: lc
          domain: Main
        }
      }
      param_decl:
      {
        NumEndPoints: "1"
      }
      domain: Main
      clock_connections:
      {
        clk_i: clkmgr_clocks_i.clk_main_secure
      }
      memory: {}
      param_list:
      [
        {
          name: NumEndPoints
          desc: Number of endpoints
          type: int unsigned
          default: "1"
          local: "true"
          expose: "true"
          name_top: Edn1NumEndPoints
        }
      ]
      inter_signal_list:
      [
        {
          name: csrng_cmd
          desc: EDN supports a single CSRNG application interface.
          struct: csrng
          package: csrng_pkg
          type: req_rsp
          act: req
          width: 1
          inst_name: edn1
          default: ""
          domain: Main
          top_signame: csrng_csrng_cmd
          index: 1
        }
        {
          name: edn
          desc: Every endpoint has its own peripheral port.
          struct: edn
          package: edn_pkg
          type: req_rsp
          act: rsp
          width:
          {
            name: NumEndPoints
            desc: Number of endpoints
            param_type: int unsigned
            unpacked_dimensions: null
            default: 8
            local: true
            expose: true
            name_top: Edn1NumEndPoints
          }
          default: "'0"
          inst_name: edn1
          end_idx: -1
          top_type: one-to-one
          top_signame: edn1_edn
          index: -1
        }
        {
          name: tl
          struct: tl
          package: tlul_pkg
          type: req_rsp
          act: rsp
          width: 1
          inst_name: edn1
          default: ""
          end_idx: -1
          top_type: one-to-one
          top_signame: edn1_tl
          index: -1
        }
      ]
      base_addrs:
      {
        null:
        {
          hart: 0x21180000
        }
      }
      generate_dif: true
    }
    {
      name: sram_ctrl_main
      type: sram_ctrl
      clock_srcs:
      {
        clk_i: main
        clk_otp_i: io
      }
      clock_group: infra
      reset_connections:
      {
        rst_ni:
        {
          name: lc
          domain: Main
        }
        rst_otp_ni:
        {
          name: lc_io
          domain: Main
        }
      }
      param_decl:
      {
        InstrExec: "1"
        InstSize: 65536
      }
      base_addrs:
      {
        regs:
        {
          hart: 0x211c0000
        }
        ram:
        {
          hart: 0x10000000
        }
      }
      memory:
      {
        ram:
        {
          label: ram_main
          swaccess: rw
          data_intg_passthru: "true"
          exec: True
          byte_write: True
          size: 0x10000
        }
      }
      domain: Main
      clock_connections:
      {
        clk_i: clkmgr_clocks_i.clk_main_infra
        clk_otp_i: clkmgr_clocks_i.clk_io_infra
      }
      param_list:
      [
        {
          name: MemSizeRam
          desc:
            '''
            Memory size of the RAM (in bytes).
            If address scrambling is enabled, this must be a power of 2 or a multiple of
            2 KiB, and non-power-of-2 sizes that are not a multiple of 16 KiB trigger a lint
            error.
            For details, check the SRAM scrambling primitive (prim_ram_1p_scr).
            '''
          type: int
          name_top: MemSizeSramCtrlMainRam
          default: 65536
        }
        {
          name: InstSize
          desc: Memory size of a single RAM tile (in bytes).
          type: int
          default: 65536
          local: "false"
          expose: "true"
          name_top: SramCtrlMainInstSize
        }
        {
          name: NumRamInst
          desc: Number of internal RAM instances. Must be the same as ceil(MemSizeRam / InstSize) .
          type: int
          default: 1
          local: "false"
          expose: "true"
          name_top: SramCtrlMainNumRamInst
        }
        {
          name: InstrExec
          desc: Support execution from SRAM
          type: bit
          default: "1"
          local: "false"
          expose: "true"
          name_top: SramCtrlMainInstrExec
        }
        {
          name: NumPrinceRoundsHalf
          desc: Number of PRINCE half rounds for the SRAM scrambling feature
          type: int
          default: "3"
          local: "false"
          expose: "true"
          name_top: SramCtrlMainNumPrinceRoundsHalf
        }
        {
          name: NumAddrScrRounds
          desc: Number of address scrambling rounds. 0 disables address scrambling.
          type: int
          default: "2"
          local: "false"
          expose: "true"
          name_top: SramCtrlMainNumAddrScrRounds
        }
        {
          name: Outstanding
          desc: Number of outstanding TLUL transactions
          type: int
          default: "2"
          local: "true"
          expose: "true"
          name_top: SramCtrlMainOutstanding
        }
        {
          name: EccCorrection
          desc: Enable single-bit error correction and error logging
          type: bit
          default: "0"
          local: "false"
          expose: "true"
          name_top: SramCtrlMainEccCorrection
        }
        {
          name: SecZeroInit
          desc: Initialize the memory with zeros instead of pseudo-random data.
          type: bit
          default: "0"
          local: "false"
          expose: "true"
          name_top: SecSramCtrlMainZeroInit
        }
      ]
      inter_signal_list:
      [
        {
          name: sram_otp_key
          struct: sram_otp_key
          package: otp_ctrl_pkg
          type: req_rsp
          act: req
          width: 1
          inst_name: sram_ctrl_main
          default: ""
          domain: Main
          top_signame: otp_ctrl_sram_otp_key
          index: 0
        }
        {
          name: ram_cfg
          struct: ram_1p_cfg
          package: prim_ram_1p_pkg
          type: req_rsp
          act: rsp
          width:
          {
            name: NumRamInst
            desc: Number of internal RAM instances. Must be the same as ceil(MemSizeRam / InstSize) .
            param_type: int
            unpacked_dimensions: null
            default: 1
            local: false
            expose: true
            name_top: SramCtrlMainNumRamInst
          }
          inst_name: sram_ctrl_main
          default: ""
          external: true
          conn_type: false
          index: -1
          top_signame: sram_ctrl_main_ram_cfg
        }
        {
          name: lc_escalate_en
          struct: lc_tx
          package: lc_ctrl_pkg
          type: uni
          act: rcv
          width: 1
          default: lc_ctrl_pkg::Off
          inst_name: sram_ctrl_main
          domain: Main
          top_signame: lc_ctrl_lc_escalate_en
          index: -1
        }
        {
          name: lc_hw_debug_en
          struct: lc_tx
          package: lc_ctrl_pkg
          type: uni
          act: rcv
          width: 1
          default: lc_ctrl_pkg::Off
          inst_name: sram_ctrl_main
          domain: Main
          top_signame: lc_ctrl_lc_hw_debug_en
          index: -1
        }
        {
          name: otp_en_sram_ifetch
          struct: mubi8
          package: prim_mubi_pkg
          type: uni
          act: rcv
          width: 1
          default: prim_mubi_pkg::MuBi8False
          inst_name: sram_ctrl_main
          top_signame: sram_ctrl_main_otp_en_sram_ifetch
          index: -1
        }
        {
          name: racl_policies
          desc:
            '''
            Incoming RACL policy vector from a racl_ctrl instance.
            The policy selection vector (parameter) selects the policy for each register.
            '''
          struct: racl_policy_vec
          package: top_racl_pkg
          type: uni
          act: rcv
          width: 1
          inst_name: sram_ctrl_main
          index: -1
        }
        {
          name: racl_error
          desc: RACL error log information of this module.
          struct: racl_error_log
          package: top_racl_pkg
          type: uni
          act: req
          width: 1
          inst_name: sram_ctrl_main
          index: -1
        }
        {
          name: sram_rerror
          desc: SRAM read error indicating correctable and uncorrectable ECC errors.
          struct: sram_error_t
          package: sram_ctrl_pkg
          type: uni
          act: req
          width: 1
          inst_name: sram_ctrl_main
          index: -1
        }
        {
          name: regs_tl
          struct: tl
          package: tlul_pkg
          type: req_rsp
          act: rsp
          width: 1
          inst_name: sram_ctrl_main
          default: ""
          end_idx: -1
          top_type: one-to-one
          top_signame: sram_ctrl_main_regs_tl
          index: -1
        }
        {
          name: ram_tl
          struct: tl
          package: tlul_pkg
          type: req_rsp
          act: rsp
          width: 1
          inst_name: sram_ctrl_main
          default: ""
          end_idx: -1
          top_type: one-to-one
          top_signame: sram_ctrl_main_ram_tl
          index: -1
        }
      ]
      generate_dif: true
    }
    {
      name: sram_ctrl_mbox
      type: sram_ctrl
      clock_srcs:
      {
        clk_i: main
        clk_otp_i: io
      }
      clock_group: infra
      reset_connections:
      {
        rst_ni:
        {
          name: lc
          domain: Main
        }
        rst_otp_ni:
        {
          name: lc_io
          domain: Main
        }
      }
      param_decl:
      {
        InstrExec: "0"
        InstSize: 4096
      }
      base_addrs:
      {
        regs:
        {
          hart: 0x211d0000
        }
        ram:
        {
          hart: 0x11000000
        }
      }
      memory:
      {
        ram:
        {
          label: ram_mbox
          swaccess: rw
          data_intg_passthru: "true"
          exec: False
          byte_write: True
          size: 0x1000
        }
      }
      domain: Main
      clock_connections:
      {
        clk_i: clkmgr_clocks_i.clk_main_infra
        clk_otp_i: clkmgr_clocks_i.clk_io_infra
      }
      param_list:
      [
        {
          name: MemSizeRam
          desc:
            '''
            Memory size of the RAM (in bytes).
            If address scrambling is enabled, this must be a power of 2 or a multiple of
            2 KiB, and non-power-of-2 sizes that are not a multiple of 16 KiB trigger a lint
            error.
            For details, check the SRAM scrambling primitive (prim_ram_1p_scr).
            '''
          type: int
          name_top: MemSizeSramCtrlMboxRam
          default: 4096
        }
        {
          name: InstSize
          desc: Memory size of a single RAM tile (in bytes).
          type: int
          default: 4096
          local: "false"
          expose: "true"
          name_top: SramCtrlMboxInstSize
        }
        {
          name: NumRamInst
          desc: Number of internal RAM instances. Must be the same as ceil(MemSizeRam / InstSize) .
          type: int
          default: 1
          local: "false"
          expose: "true"
          name_top: SramCtrlMboxNumRamInst
        }
        {
          name: InstrExec
          desc: Support execution from SRAM
          type: bit
          default: "0"
          local: "false"
          expose: "true"
          name_top: SramCtrlMboxInstrExec
        }
        {
          name: NumPrinceRoundsHalf
          desc: Number of PRINCE half rounds for the SRAM scrambling feature
          type: int
          default: "3"
          local: "false"
          expose: "true"
          name_top: SramCtrlMboxNumPrinceRoundsHalf
        }
        {
          name: NumAddrScrRounds
          desc: Number of address scrambling rounds. 0 disables address scrambling.
          type: int
          default: "2"
          local: "false"
          expose: "true"
          name_top: SramCtrlMboxNumAddrScrRounds
        }
        {
          name: Outstanding
          desc: Number of outstanding TLUL transactions
          type: int
          default: "2"
          local: "true"
          expose: "true"
          name_top: SramCtrlMboxOutstanding
        }
        {
          name: EccCorrection
          desc: Enable single-bit error correction and error logging
          type: bit
          default: "0"
          local: "false"
          expose: "true"
          name_top: SramCtrlMboxEccCorrection
        }
        {
          name: SecZeroInit
          desc: Initialize the memory with zeros instead of pseudo-random data.
          type: bit
          default: "0"
          local: "false"
          expose: "true"
          name_top: SecSramCtrlMboxZeroInit
        }
      ]
      inter_signal_list:
      [
        {
          name: sram_otp_key
          struct: sram_otp_key
          package: otp_ctrl_pkg
          type: req_rsp
          act: req
          width: 1
          inst_name: sram_ctrl_mbox
          default: ""
          domain: Main
          top_signame: otp_ctrl_sram_otp_key
          index: 2
        }
        {
          name: ram_cfg
          struct: ram_1p_cfg
          package: prim_ram_1p_pkg
          type: req_rsp
          act: rsp
          width:
          {
            name: NumRamInst
            desc: Number of internal RAM instances. Must be the same as ceil(MemSizeRam / InstSize) .
            param_type: int
            unpacked_dimensions: null
            default: 1
            local: false
            expose: true
            name_top: SramCtrlMboxNumRamInst
          }
          inst_name: sram_ctrl_mbox
          default: ""
          external: true
          conn_type: false
          index: -1
          top_signame: sram_ctrl_mbox_ram_cfg
        }
        {
          name: lc_escalate_en
          struct: lc_tx
          package: lc_ctrl_pkg
          type: uni
          act: rcv
          width: 1
          default: lc_ctrl_pkg::Off
          inst_name: sram_ctrl_mbox
          domain: Main
          top_signame: lc_ctrl_lc_escalate_en
          index: -1
        }
        {
          name: lc_hw_debug_en
          struct: lc_tx
          package: lc_ctrl_pkg
          type: uni
          act: rcv
          width: 1
          default: lc_ctrl_pkg::Off
          inst_name: sram_ctrl_mbox
          index: -1
        }
        {
          name: otp_en_sram_ifetch
          struct: mubi8
          package: prim_mubi_pkg
          type: uni
          act: rcv
          width: 1
          default: prim_mubi_pkg::MuBi8False
          inst_name: sram_ctrl_mbox
          index: -1
        }
        {
          name: racl_policies
          desc:
            '''
            Incoming RACL policy vector from a racl_ctrl instance.
            The policy selection vector (parameter) selects the policy for each register.
            '''
          struct: racl_policy_vec
          package: top_racl_pkg
          type: uni
          act: rcv
          width: 1
          inst_name: sram_ctrl_mbox
          index: -1
        }
        {
          name: racl_error
          desc: RACL error log information of this module.
          struct: racl_error_log
          package: top_racl_pkg
          type: uni
          act: req
          width: 1
          inst_name: sram_ctrl_mbox
          index: -1
        }
        {
          name: sram_rerror
          desc: SRAM read error indicating correctable and uncorrectable ECC errors.
          struct: sram_error_t
          package: sram_ctrl_pkg
          type: uni
          act: req
          width: 1
          inst_name: sram_ctrl_mbox
          index: -1
        }
        {
          name: regs_tl
          struct: tl
          package: tlul_pkg
          type: req_rsp
          act: rsp
          width: 1
          inst_name: sram_ctrl_mbox
          default: ""
          end_idx: -1
          top_type: one-to-one
          top_signame: sram_ctrl_mbox_regs_tl
          index: -1
        }
        {
          name: ram_tl
          struct: tl
          package: tlul_pkg
          type: req_rsp
          act: rsp
          width: 1
          inst_name: sram_ctrl_mbox
          default: ""
          end_idx: -1
          top_type: one-to-one
          top_signame: sram_ctrl_mbox_ram_tl
          index: -1
        }
      ]
      generate_dif: true
    }
    {
      name: rom_ctrl0
      type: rom_ctrl
      clock_srcs:
      {
        clk_i: main
      }
      clock_group: infra
      reset_connections:
      {
        rst_ni:
        {
          name: lc
          domain: Main
        }
      }
      base_addrs:
      {
        rom:
        {
          hart: 0x00008000
        }
        regs:
        {
          hart: 0x211e0000
        }
      }
      memory:
      {
        rom:
        {
          label: rom0
          swaccess: ro
          data_intg_passthru: True
          exec: True
          byte_write: False
          size: 0x8000
        }
      }
      param_decl:
      {
        SecDisableScrambling: 1'b0
        FlopToKmac: 1'b1
      }
      domain: Main
      clock_connections:
      {
        clk_i: clkmgr_clocks_i.clk_main_infra
      }
      param_list:
      [
        {
          name: BootRomInitFile
          desc: Contents of ROM
          type: ""
          default: '''""'''
          local: "false"
          expose: "true"
          name_top: RomCtrl0BootRomInitFile
        }
        {
          name: FlopToKmac
          desc:
            '''
            Add a flop stage between the output of the ROM and the data that gets
            sent to KMAC. This may break long paths in a target chip, at the cost of
            adding chip area.
            '''
          type: bit
          default: 1'b1
          local: "true"
          expose: "true"
          name_top: RomCtrl0FlopToKmac
        }
        {
          name: SecDisableScrambling
          desc:
            '''
            Disable scrambling and checking in rom_ctrl, turning the block into a
            simple ROM wrapper. This isn't intended for real chips, but is useful
            for small FPGA targets where there's not space for the PRINCE
            primitives.
            '''
          type: bit
          default: 1'b0
          local: "false"
          expose: "true"
          name_top: SecRomCtrl0DisableScrambling
        }
        {
          name: MemSizeRom
          desc: Memory size of the ROM (in bytes).
          type: int
          name_top: MemSizeRomCtrl0Rom
          default: 32768
        }
      ]
      inter_signal_list:
      [
        {
          name: rom_cfg
          struct: rom_cfg
          package: prim_rom_pkg
          type: req_rsp
          act: rsp
          width: 1
          inst_name: rom_ctrl0
          default: ""
          external: true
          conn_type: false
          index: -1
          top_signame: rom_ctrl0_rom_cfg
        }
        {
          name: pwrmgr_data
          struct: pwrmgr_data
          package: rom_ctrl_pkg
          type: uni
          act: req
          width: 1
          inst_name: rom_ctrl0
          default: ""
          domain: Main
          top_signame: pwrmgr_rom_ctrl
          index: 0
          external: true
          conn_type: false
        }
        {
          name: keymgr_data
          struct: keymgr_data
          package: rom_ctrl_pkg
          type: uni
          act: req
          width: 1
          inst_name: rom_ctrl0
          default: ""
          domain: Main
          top_signame: keymgr_dpe_rom_digest
          index: 0
        }
        {
          name: kmac_data
          struct: app
          package: kmac_pkg
          type: req_rsp
          act: req
          width: 1
          inst_name: rom_ctrl0
          default: ""
          domain: Main
          top_signame: kmac_app
          index: 2
        }
        {
          name: regs_tl
          struct: tl
          package: tlul_pkg
          type: req_rsp
          act: rsp
          width: 1
          inst_name: rom_ctrl0
          default: ""
          end_idx: -1
          top_type: one-to-one
          top_signame: rom_ctrl0_regs_tl
          index: -1
        }
        {
          name: rom_tl
          struct: tl
          package: tlul_pkg
          type: req_rsp
          act: rsp
          width: 1
          inst_name: rom_ctrl0
          default: ""
          end_idx: -1
          top_type: one-to-one
          top_signame: rom_ctrl0_rom_tl
          index: -1
        }
      ]
      generate_dif: true
    }
    {
      name: rom_ctrl1
      type: rom_ctrl
      clock_srcs:
      {
        clk_i: main
      }
      clock_group: infra
      reset_connections:
      {
        rst_ni:
        {
          name: lc
          domain: Main
        }
      }
      base_addrs:
      {
        rom:
        {
          hart: 0x00020000
        }
        regs:
        {
          hart: 0x211e1000
        }
      }
      memory:
      {
        rom:
        {
          label: rom1
          swaccess: ro
          data_intg_passthru: True
          exec: True
          byte_write: False
          size: 0x10000
        }
      }
      param_decl:
      {
        SecDisableScrambling: 1'b0
        FlopToKmac: 1'b1
      }
      domain: Main
      clock_connections:
      {
        clk_i: clkmgr_clocks_i.clk_main_infra
      }
      param_list:
      [
        {
          name: BootRomInitFile
          desc: Contents of ROM
          type: ""
          default: '''""'''
          local: "false"
          expose: "true"
          name_top: RomCtrl1BootRomInitFile
        }
        {
          name: FlopToKmac
          desc:
            '''
            Add a flop stage between the output of the ROM and the data that gets
            sent to KMAC. This may break long paths in a target chip, at the cost of
            adding chip area.
            '''
          type: bit
          default: 1'b1
          local: "true"
          expose: "true"
          name_top: RomCtrl1FlopToKmac
        }
        {
          name: SecDisableScrambling
          desc:
            '''
            Disable scrambling and checking in rom_ctrl, turning the block into a
            simple ROM wrapper. This isn't intended for real chips, but is useful
            for small FPGA targets where there's not space for the PRINCE
            primitives.
            '''
          type: bit
          default: 1'b0
          local: "false"
          expose: "true"
          name_top: SecRomCtrl1DisableScrambling
        }
        {
          name: MemSizeRom
          desc: Memory size of the ROM (in bytes).
          type: int
          name_top: MemSizeRomCtrl1Rom
          default: 65536
        }
      ]
      inter_signal_list:
      [
        {
          name: rom_cfg
          struct: rom_cfg
          package: prim_rom_pkg
          type: req_rsp
          act: rsp
          width: 1
          inst_name: rom_ctrl1
          default: ""
          external: true
          conn_type: false
          index: -1
          top_signame: rom_ctrl1_rom_cfg
        }
        {
          name: pwrmgr_data
          struct: pwrmgr_data
          package: rom_ctrl_pkg
          type: uni
          act: req
          width: 1
          inst_name: rom_ctrl1
          default: ""
          domain: Main
          top_signame: pwrmgr_rom_ctrl
          index: 1
          external: true
          conn_type: false
        }
        {
          name: keymgr_data
          struct: keymgr_data
          package: rom_ctrl_pkg
          type: uni
          act: req
          width: 1
          inst_name: rom_ctrl1
          default: ""
          domain: Main
          top_signame: keymgr_dpe_rom_digest
          index: 1
        }
        {
          name: kmac_data
          struct: app
          package: kmac_pkg
          type: req_rsp
          act: req
          width: 1
          inst_name: rom_ctrl1
          default: ""
          domain: Main
          top_signame: kmac_app
          index: 3
        }
        {
          name: regs_tl
          struct: tl
          package: tlul_pkg
          type: req_rsp
          act: rsp
          width: 1
          inst_name: rom_ctrl1
          default: ""
          end_idx: -1
          top_type: one-to-one
          top_signame: rom_ctrl1_regs_tl
          index: -1
        }
        {
          name: rom_tl
          struct: tl
          package: tlul_pkg
          type: req_rsp
          act: rsp
          width: 1
          inst_name: rom_ctrl1
          default: ""
          end_idx: -1
          top_type: one-to-one
          top_signame: rom_ctrl1_rom_tl
          index: -1
        }
      ]
      generate_dif: true
    }
    {
      name: dma
      type: dma
      clock_srcs:
      {
        clk_i: main
      }
      clock_group: infra
      reset_connections:
      {
        rst_ni:
        {
          name: lc
          domain: Main
        }
      }
      domain: Main
      clock_connections:
      {
        clk_i: clkmgr_clocks_i.clk_main_infra
      }
      param_decl: {}
      memory: {}
      param_list:
      [
        {
          name: EnableDataIntgGen
          desc: Compute integrity bits for A channel data on all TL-UL host ports
          type: bit
          default: 1'b1
          local: "false"
          expose: "true"
          name_top: DmaEnableDataIntgGen
        }
        {
          name: EnableRspDataIntgCheck
          desc: Enable integrity checks on the response TL-UL D channel
          type: bit
          default: 1'b1
          local: "false"
          expose: "true"
          name_top: DmaEnableRspDataIntgCheck
        }
        {
          name: TlUserRsvd
          desc: Value of `rsvd` field in A channel of all TL-UL host ports
          type: logic [tlul_pkg::RsvdWidth-1:0]
          default: "'0"
          local: "false"
          expose: "true"
          name_top: DmaTlUserRsvd
        }
        {
          name: SysRaclRole
          desc: RACL propagated on the Sys interface via `racl_vec`
          type: top_racl_pkg::racl_role_t
          default: "'0"
          local: "false"
          expose: "true"
          name_top: DmaSysRaclRole
        }
        {
          name: OtAgentId
          desc: OT Agent ID
          type: int unsigned
          default: "0"
          local: "false"
          expose: "true"
          name_top: DmaOtAgentId
        }
      ]
      inter_signal_list:
      [
        {
          name: lsio_trigger
          struct: lsio_trigger
          package: dma_pkg
          type: uni
          act: rcv
          width: 1
          inst_name: dma
          default: ""
          end_idx: -1
          top_type: broadcast
          top_signame: dma_lsio_trigger
          index: -1
          external: true
          conn_type: false
        }
        {
          name: sys
          desc: SoC System Bus (requests and responses), synchronous
          struct: sys
          package: dma_pkg
          type: req_rsp
          act: req
          width: 1
          inst_name: dma
          default: ""
          external: true
          conn_type: false
          index: -1
          top_signame: dma_sys
        }
        {
          name: ctn_tl_h2d
          desc: TL-UL host port for egress into CTN (request part), synchronous
          struct: tl_h2d
          package: tlul_pkg
          type: uni
          act: req
          width: 1
          inst_name: dma
          default: ""
          domain: Main
          top_signame: soc_proxy_dma_tl_h2d
          index: -1
          external: true
          conn_type: false
        }
        {
          name: ctn_tl_d2h
          desc: TL-UL host port for egress into CTN (response part), synchronous
          struct: tl_d2h
          package: tlul_pkg
          type: uni
          act: rcv
          width: 1
          inst_name: dma
          default: ""
          domain: Main
          top_signame: soc_proxy_dma_tl_d2h
          index: -1
          external: true
          conn_type: false
        }
        {
          name: racl_policies
          desc:
            '''
            Incoming RACL policy vector from a racl_ctrl instance.
            The policy selection vector (parameter) selects the policy for each register.
            '''
          struct: racl_policy_vec
          package: top_racl_pkg
          type: uni
          act: rcv
          width: 1
          inst_name: dma
          index: -1
        }
        {
          name: racl_error
          desc: RACL error log information of this module.
          struct: racl_error_log
          package: top_racl_pkg
          type: uni
          act: req
          width: 1
          inst_name: dma
          index: -1
        }
        {
          name: host_tl_h
          struct: tl
          package: tlul_pkg
          type: req_rsp
          act: req
          width: 1
          inst_name: dma
          default: ""
          domain: Main
          top_signame: main_tl_dma__host
          index: -1
        }
        {
          name: tl_d
          struct: tl
          package: tlul_pkg
          type: req_rsp
          act: rsp
          width: 1
          inst_name: dma
          default: ""
          end_idx: -1
          top_type: one-to-one
          top_signame: dma_tl_d
          index: -1
        }
      ]
      base_addrs:
      {
        null:
        {
          hart: 0x22010000
        }
      }
      generate_dif: true
    }
    {
      name: mbx0
      type: mbx
      clock_srcs:
      {
        clk_i: main
      }
      clock_group: infra
      reset_connections:
      {
        rst_ni:
        {
          name: lc
          domain: Main
        }
      }
      base_addrs:
      {
        core:
        {
          hart: 0x22000000
        }
        soc:
        {
          soc_mbx: 0x01465000
        }
      }
      racl_mappings:
      {
        soc:
        {
          racl_group: Null
          register_mapping:
          {
            SOC_CONTROL: 0
            SOC_STATUS: 0
            SOC_DOE_INTR_MSG_ADDR: 0
            SOC_DOE_INTR_MSG_DATA: 0
          }
          window_mapping:
          {
            WDATA: 0
            RDATA: 0
          }
          range_mapping: []
        }
      }
      domain: Main
      clock_connections:
      {
        clk_i: clkmgr_clocks_i.clk_main_infra
      }
      param_decl: {}
      memory: {}
      param_list: []
      inter_signal_list:
      [
        {
          name: doe_intr_support
          struct: logic
          type: uni
          act: req
          width: 1
          default: 1'b0
          inst_name: mbx0
          package: ""
          external: true
          conn_type: false
          index: -1
          top_signame: mbx0_doe_intr_support
        }
        {
          name: doe_intr_en
          struct: logic
          type: uni
          act: req
          width: 1
          default: 1'b0
          inst_name: mbx0
          package: ""
          external: true
          conn_type: false
          index: -1
          top_signame: mbx0_doe_intr_en
        }
        {
          name: doe_intr
          struct: logic
          type: uni
          act: req
          width: 1
          default: 1'b0
          inst_name: mbx0
          package: ""
          external: true
          conn_type: false
          index: -1
          top_signame: mbx0_doe_intr
        }
        {
          name: doe_async_msg_support
          struct: logic
          type: uni
          act: req
          width: 1
          default: 1'b0
          inst_name: mbx0
          package: ""
          external: true
          conn_type: false
          index: -1
          top_signame: mbx0_doe_async_msg_support
        }
        {
          name: racl_policies
          desc:
            '''
            Incoming RACL policy vector from a racl_ctrl instance.
            The policy selection vector (parameter) selects the policy for each register.
            '''
          struct: racl_policy_vec
          package: top_racl_pkg
          type: uni
          act: rcv
          width: 1
          inst_name: mbx0
          default: ""
          domain: Main
          top_signame: racl_ctrl_racl_policies
          index: -1
        }
        {
          name: racl_error
          desc: RACL error log information of this module.
          struct: racl_error_log
          package: top_racl_pkg
          type: uni
          act: req
          width: 1
          inst_name: mbx0
          default: ""
          domain: Main
          top_signame: racl_ctrl_racl_error
          index: 0
        }
        {
          name: sram_tl_h
          struct: tl
          package: tlul_pkg
          type: req_rsp
          act: req
          width: 1
          inst_name: mbx0
          default: ""
          domain: Main
          top_signame: main_tl_mbx0__sram
          index: -1
        }
        {
          name: core_tl_d
          struct: tl
          package: tlul_pkg
          type: req_rsp
          act: rsp
          width: 1
          inst_name: mbx0
          default: ""
          end_idx: -1
          top_type: one-to-one
          top_signame: mbx0_core_tl_d
          index: -1
        }
        {
          name: soc_tl_d
          struct: tl
          package: tlul_pkg
          type: req_rsp
          act: rsp
          width: 1
          inst_name: mbx0
          default: ""
          end_idx: -1
          top_type: one-to-one
          top_signame: mbx0_soc_tl_d
          index: -1
        }
      ]
      generate_dif: true
    }
    {
      name: mbx1
      type: mbx
      clock_srcs:
      {
        clk_i: main
      }
      clock_group: infra
      reset_connections:
      {
        rst_ni:
        {
          name: lc
          domain: Main
        }
      }
      base_addrs:
      {
        core:
        {
          hart: 0x22000100
        }
        soc:
        {
          soc_mbx: 0x01465100
        }
      }
      racl_mappings:
      {
        soc:
        {
          racl_group: Null
          register_mapping:
          {
            SOC_CONTROL: 0
            SOC_STATUS: 0
            SOC_DOE_INTR_MSG_ADDR: 0
            SOC_DOE_INTR_MSG_DATA: 0
          }
          window_mapping:
          {
            WDATA: 0
            RDATA: 0
          }
          range_mapping: []
        }
      }
      domain: Main
      clock_connections:
      {
        clk_i: clkmgr_clocks_i.clk_main_infra
      }
      param_decl: {}
      memory: {}
      param_list: []
      inter_signal_list:
      [
        {
          name: doe_intr_support
          struct: logic
          type: uni
          act: req
          width: 1
          default: 1'b0
          inst_name: mbx1
          package: ""
          external: true
          conn_type: false
          index: -1
          top_signame: mbx1_doe_intr_support
        }
        {
          name: doe_intr_en
          struct: logic
          type: uni
          act: req
          width: 1
          default: 1'b0
          inst_name: mbx1
          package: ""
          external: true
          conn_type: false
          index: -1
          top_signame: mbx1_doe_intr_en
        }
        {
          name: doe_intr
          struct: logic
          type: uni
          act: req
          width: 1
          default: 1'b0
          inst_name: mbx1
          package: ""
          external: true
          conn_type: false
          index: -1
          top_signame: mbx1_doe_intr
        }
        {
          name: doe_async_msg_support
          struct: logic
          type: uni
          act: req
          width: 1
          default: 1'b0
          inst_name: mbx1
          package: ""
          external: true
          conn_type: false
          index: -1
          top_signame: mbx1_doe_async_msg_support
        }
        {
          name: racl_policies
          desc:
            '''
            Incoming RACL policy vector from a racl_ctrl instance.
            The policy selection vector (parameter) selects the policy for each register.
            '''
          struct: racl_policy_vec
          package: top_racl_pkg
          type: uni
          act: rcv
          width: 1
          inst_name: mbx1
          default: ""
          domain: Main
          top_signame: racl_ctrl_racl_policies
          index: -1
        }
        {
          name: racl_error
          desc: RACL error log information of this module.
          struct: racl_error_log
          package: top_racl_pkg
          type: uni
          act: req
          width: 1
          inst_name: mbx1
          default: ""
          domain: Main
          top_signame: racl_ctrl_racl_error
          index: 1
        }
        {
          name: sram_tl_h
          struct: tl
          package: tlul_pkg
          type: req_rsp
          act: req
          width: 1
          inst_name: mbx1
          default: ""
          domain: Main
          top_signame: main_tl_mbx1__sram
          index: -1
        }
        {
          name: core_tl_d
          struct: tl
          package: tlul_pkg
          type: req_rsp
          act: rsp
          width: 1
          inst_name: mbx1
          default: ""
          end_idx: -1
          top_type: one-to-one
          top_signame: mbx1_core_tl_d
          index: -1
        }
        {
          name: soc_tl_d
          struct: tl
          package: tlul_pkg
          type: req_rsp
          act: rsp
          width: 1
          inst_name: mbx1
          default: ""
          end_idx: -1
          top_type: one-to-one
          top_signame: mbx1_soc_tl_d
          index: -1
        }
      ]
      generate_dif: true
    }
    {
      name: mbx2
      type: mbx
      clock_srcs:
      {
        clk_i: main
      }
      clock_group: infra
      reset_connections:
      {
        rst_ni:
        {
          name: lc
          domain: Main
        }
      }
      base_addrs:
      {
        core:
        {
          hart: 0x22000200
        }
        soc:
        {
          soc_mbx: 0x01465200
        }
      }
      racl_mappings:
      {
        soc:
        {
          racl_group: Null
          register_mapping:
          {
            SOC_CONTROL: 0
            SOC_STATUS: 0
            SOC_DOE_INTR_MSG_ADDR: 0
            SOC_DOE_INTR_MSG_DATA: 0
          }
          window_mapping:
          {
            WDATA: 0
            RDATA: 0
          }
          range_mapping: []
        }
      }
      domain: Main
      clock_connections:
      {
        clk_i: clkmgr_clocks_i.clk_main_infra
      }
      param_decl: {}
      memory: {}
      param_list: []
      inter_signal_list:
      [
        {
          name: doe_intr_support
          struct: logic
          type: uni
          act: req
          width: 1
          default: 1'b0
          inst_name: mbx2
          package: ""
          external: true
          conn_type: false
          index: -1
          top_signame: mbx2_doe_intr_support
        }
        {
          name: doe_intr_en
          struct: logic
          type: uni
          act: req
          width: 1
          default: 1'b0
          inst_name: mbx2
          package: ""
          external: true
          conn_type: false
          index: -1
          top_signame: mbx2_doe_intr_en
        }
        {
          name: doe_intr
          struct: logic
          type: uni
          act: req
          width: 1
          default: 1'b0
          inst_name: mbx2
          package: ""
          external: true
          conn_type: false
          index: -1
          top_signame: mbx2_doe_intr
        }
        {
          name: doe_async_msg_support
          struct: logic
          type: uni
          act: req
          width: 1
          default: 1'b0
          inst_name: mbx2
          package: ""
          external: true
          conn_type: false
          index: -1
          top_signame: mbx2_doe_async_msg_support
        }
        {
          name: racl_policies
          desc:
            '''
            Incoming RACL policy vector from a racl_ctrl instance.
            The policy selection vector (parameter) selects the policy for each register.
            '''
          struct: racl_policy_vec
          package: top_racl_pkg
          type: uni
          act: rcv
          width: 1
          inst_name: mbx2
          default: ""
          domain: Main
          top_signame: racl_ctrl_racl_policies
          index: -1
        }
        {
          name: racl_error
          desc: RACL error log information of this module.
          struct: racl_error_log
          package: top_racl_pkg
          type: uni
          act: req
          width: 1
          inst_name: mbx2
          default: ""
          domain: Main
          top_signame: racl_ctrl_racl_error
          index: 2
        }
        {
          name: sram_tl_h
          struct: tl
          package: tlul_pkg
          type: req_rsp
          act: req
          width: 1
          inst_name: mbx2
          default: ""
          domain: Main
          top_signame: main_tl_mbx2__sram
          index: -1
        }
        {
          name: core_tl_d
          struct: tl
          package: tlul_pkg
          type: req_rsp
          act: rsp
          width: 1
          inst_name: mbx2
          default: ""
          end_idx: -1
          top_type: one-to-one
          top_signame: mbx2_core_tl_d
          index: -1
        }
        {
          name: soc_tl_d
          struct: tl
          package: tlul_pkg
          type: req_rsp
          act: rsp
          width: 1
          inst_name: mbx2
          default: ""
          end_idx: -1
          top_type: one-to-one
          top_signame: mbx2_soc_tl_d
          index: -1
        }
      ]
      generate_dif: true
    }
    {
      name: mbx3
      type: mbx
      clock_srcs:
      {
        clk_i: main
      }
      clock_group: infra
      reset_connections:
      {
        rst_ni:
        {
          name: lc
          domain: Main
        }
      }
      base_addrs:
      {
        core:
        {
          hart: 0x22000300
        }
        soc:
        {
          soc_mbx: 0x01465300
        }
      }
      racl_mappings:
      {
        soc:
        {
          racl_group: Null
          register_mapping:
          {
            SOC_CONTROL: 0
            SOC_STATUS: 0
            SOC_DOE_INTR_MSG_ADDR: 0
            SOC_DOE_INTR_MSG_DATA: 0
          }
          window_mapping:
          {
            WDATA: 0
            RDATA: 0
          }
          range_mapping: []
        }
      }
      domain: Main
      clock_connections:
      {
        clk_i: clkmgr_clocks_i.clk_main_infra
      }
      param_decl: {}
      memory: {}
      param_list: []
      inter_signal_list:
      [
        {
          name: doe_intr_support
          struct: logic
          type: uni
          act: req
          width: 1
          default: 1'b0
          inst_name: mbx3
          package: ""
          external: true
          conn_type: false
          index: -1
          top_signame: mbx3_doe_intr_support
        }
        {
          name: doe_intr_en
          struct: logic
          type: uni
          act: req
          width: 1
          default: 1'b0
          inst_name: mbx3
          package: ""
          external: true
          conn_type: false
          index: -1
          top_signame: mbx3_doe_intr_en
        }
        {
          name: doe_intr
          struct: logic
          type: uni
          act: req
          width: 1
          default: 1'b0
          inst_name: mbx3
          package: ""
          external: true
          conn_type: false
          index: -1
          top_signame: mbx3_doe_intr
        }
        {
          name: doe_async_msg_support
          struct: logic
          type: uni
          act: req
          width: 1
          default: 1'b0
          inst_name: mbx3
          package: ""
          external: true
          conn_type: false
          index: -1
          top_signame: mbx3_doe_async_msg_support
        }
        {
          name: racl_policies
          desc:
            '''
            Incoming RACL policy vector from a racl_ctrl instance.
            The policy selection vector (parameter) selects the policy for each register.
            '''
          struct: racl_policy_vec
          package: top_racl_pkg
          type: uni
          act: rcv
          width: 1
          inst_name: mbx3
          default: ""
          domain: Main
          top_signame: racl_ctrl_racl_policies
          index: -1
        }
        {
          name: racl_error
          desc: RACL error log information of this module.
          struct: racl_error_log
          package: top_racl_pkg
          type: uni
          act: req
          width: 1
          inst_name: mbx3
          default: ""
          domain: Main
          top_signame: racl_ctrl_racl_error
          index: 3
        }
        {
          name: sram_tl_h
          struct: tl
          package: tlul_pkg
          type: req_rsp
          act: req
          width: 1
          inst_name: mbx3
          default: ""
          domain: Main
          top_signame: main_tl_mbx3__sram
          index: -1
        }
        {
          name: core_tl_d
          struct: tl
          package: tlul_pkg
          type: req_rsp
          act: rsp
          width: 1
          inst_name: mbx3
          default: ""
          end_idx: -1
          top_type: one-to-one
          top_signame: mbx3_core_tl_d
          index: -1
        }
        {
          name: soc_tl_d
          struct: tl
          package: tlul_pkg
          type: req_rsp
          act: rsp
          width: 1
          inst_name: mbx3
          default: ""
          end_idx: -1
          top_type: one-to-one
          top_signame: mbx3_soc_tl_d
          index: -1
        }
      ]
      generate_dif: true
    }
    {
      name: mbx4
      type: mbx
      clock_srcs:
      {
        clk_i: main
      }
      clock_group: infra
      reset_connections:
      {
        rst_ni:
        {
          name: lc
          domain: Main
        }
      }
      base_addrs:
      {
        core:
        {
          hart: 0x22000400
        }
        soc:
        {
          soc_mbx: 0x01465400
        }
      }
      racl_mappings:
      {
        soc:
        {
          racl_group: Null
          register_mapping:
          {
            SOC_CONTROL: 0
            SOC_STATUS: 0
            SOC_DOE_INTR_MSG_ADDR: 0
            SOC_DOE_INTR_MSG_DATA: 0
          }
          window_mapping:
          {
            WDATA: 0
            RDATA: 0
          }
          range_mapping: []
        }
      }
      domain: Main
      clock_connections:
      {
        clk_i: clkmgr_clocks_i.clk_main_infra
      }
      param_decl: {}
      memory: {}
      param_list: []
      inter_signal_list:
      [
        {
          name: doe_intr_support
          struct: logic
          type: uni
          act: req
          width: 1
          default: 1'b0
          inst_name: mbx4
          package: ""
          external: true
          conn_type: false
          index: -1
          top_signame: mbx4_doe_intr_support
        }
        {
          name: doe_intr_en
          struct: logic
          type: uni
          act: req
          width: 1
          default: 1'b0
          inst_name: mbx4
          package: ""
          external: true
          conn_type: false
          index: -1
          top_signame: mbx4_doe_intr_en
        }
        {
          name: doe_intr
          struct: logic
          type: uni
          act: req
          width: 1
          default: 1'b0
          inst_name: mbx4
          package: ""
          external: true
          conn_type: false
          index: -1
          top_signame: mbx4_doe_intr
        }
        {
          name: doe_async_msg_support
          struct: logic
          type: uni
          act: req
          width: 1
          default: 1'b0
          inst_name: mbx4
          package: ""
          external: true
          conn_type: false
          index: -1
          top_signame: mbx4_doe_async_msg_support
        }
        {
          name: racl_policies
          desc:
            '''
            Incoming RACL policy vector from a racl_ctrl instance.
            The policy selection vector (parameter) selects the policy for each register.
            '''
          struct: racl_policy_vec
          package: top_racl_pkg
          type: uni
          act: rcv
          width: 1
          inst_name: mbx4
          default: ""
          domain: Main
          top_signame: racl_ctrl_racl_policies
          index: -1
        }
        {
          name: racl_error
          desc: RACL error log information of this module.
          struct: racl_error_log
          package: top_racl_pkg
          type: uni
          act: req
          width: 1
          inst_name: mbx4
          default: ""
          domain: Main
          top_signame: racl_ctrl_racl_error
          index: 4
        }
        {
          name: sram_tl_h
          struct: tl
          package: tlul_pkg
          type: req_rsp
          act: req
          width: 1
          inst_name: mbx4
          default: ""
          domain: Main
          top_signame: main_tl_mbx4__sram
          index: -1
        }
        {
          name: core_tl_d
          struct: tl
          package: tlul_pkg
          type: req_rsp
          act: rsp
          width: 1
          inst_name: mbx4
          default: ""
          end_idx: -1
          top_type: one-to-one
          top_signame: mbx4_core_tl_d
          index: -1
        }
        {
          name: soc_tl_d
          struct: tl
          package: tlul_pkg
          type: req_rsp
          act: rsp
          width: 1
          inst_name: mbx4
          default: ""
          end_idx: -1
          top_type: one-to-one
          top_signame: mbx4_soc_tl_d
          index: -1
        }
      ]
      generate_dif: true
    }
    {
      name: mbx5
      type: mbx
      clock_srcs:
      {
        clk_i: main
      }
      clock_group: infra
      reset_connections:
      {
        rst_ni:
        {
          name: lc
          domain: Main
        }
      }
      base_addrs:
      {
        core:
        {
          hart: 0x22000500
        }
        soc:
        {
          soc_mbx: 0x01465500
        }
      }
      racl_mappings:
      {
        soc:
        {
          racl_group: Null
          register_mapping:
          {
            SOC_CONTROL: 0
            SOC_STATUS: 0
            SOC_DOE_INTR_MSG_ADDR: 0
            SOC_DOE_INTR_MSG_DATA: 0
          }
          window_mapping:
          {
            WDATA: 0
            RDATA: 0
          }
          range_mapping: []
        }
      }
      domain: Main
      clock_connections:
      {
        clk_i: clkmgr_clocks_i.clk_main_infra
      }
      param_decl: {}
      memory: {}
      param_list: []
      inter_signal_list:
      [
        {
          name: doe_intr_support
          struct: logic
          type: uni
          act: req
          width: 1
          default: 1'b0
          inst_name: mbx5
          package: ""
          external: true
          conn_type: false
          index: -1
          top_signame: mbx5_doe_intr_support
        }
        {
          name: doe_intr_en
          struct: logic
          type: uni
          act: req
          width: 1
          default: 1'b0
          inst_name: mbx5
          package: ""
          external: true
          conn_type: false
          index: -1
          top_signame: mbx5_doe_intr_en
        }
        {
          name: doe_intr
          struct: logic
          type: uni
          act: req
          width: 1
          default: 1'b0
          inst_name: mbx5
          package: ""
          external: true
          conn_type: false
          index: -1
          top_signame: mbx5_doe_intr
        }
        {
          name: doe_async_msg_support
          struct: logic
          type: uni
          act: req
          width: 1
          default: 1'b0
          inst_name: mbx5
          package: ""
          external: true
          conn_type: false
          index: -1
          top_signame: mbx5_doe_async_msg_support
        }
        {
          name: racl_policies
          desc:
            '''
            Incoming RACL policy vector from a racl_ctrl instance.
            The policy selection vector (parameter) selects the policy for each register.
            '''
          struct: racl_policy_vec
          package: top_racl_pkg
          type: uni
          act: rcv
          width: 1
          inst_name: mbx5
          default: ""
          domain: Main
          top_signame: racl_ctrl_racl_policies
          index: -1
        }
        {
          name: racl_error
          desc: RACL error log information of this module.
          struct: racl_error_log
          package: top_racl_pkg
          type: uni
          act: req
          width: 1
          inst_name: mbx5
          default: ""
          domain: Main
          top_signame: racl_ctrl_racl_error
          index: 5
        }
        {
          name: sram_tl_h
          struct: tl
          package: tlul_pkg
          type: req_rsp
          act: req
          width: 1
          inst_name: mbx5
          default: ""
          domain: Main
          top_signame: main_tl_mbx5__sram
          index: -1
        }
        {
          name: core_tl_d
          struct: tl
          package: tlul_pkg
          type: req_rsp
          act: rsp
          width: 1
          inst_name: mbx5
          default: ""
          end_idx: -1
          top_type: one-to-one
          top_signame: mbx5_core_tl_d
          index: -1
        }
        {
          name: soc_tl_d
          struct: tl
          package: tlul_pkg
          type: req_rsp
          act: rsp
          width: 1
          inst_name: mbx5
          default: ""
          end_idx: -1
          top_type: one-to-one
          top_signame: mbx5_soc_tl_d
          index: -1
        }
      ]
      generate_dif: true
    }
    {
      name: mbx6
      type: mbx
      clock_srcs:
      {
        clk_i: main
      }
      clock_group: infra
      reset_connections:
      {
        rst_ni:
        {
          name: lc
          domain: Main
        }
      }
      base_addrs:
      {
        core:
        {
          hart: 0x22000600
        }
        soc:
        {
          soc_mbx: 0x01496000
        }
      }
      racl_mappings:
      {
        soc:
        {
          racl_group: Null
          register_mapping:
          {
            SOC_CONTROL: 0
            SOC_STATUS: 0
            SOC_DOE_INTR_MSG_ADDR: 0
            SOC_DOE_INTR_MSG_DATA: 0
          }
          window_mapping:
          {
            WDATA: 0
            RDATA: 0
          }
          range_mapping: []
        }
      }
      domain: Main
      clock_connections:
      {
        clk_i: clkmgr_clocks_i.clk_main_infra
      }
      param_decl: {}
      memory: {}
      param_list: []
      inter_signal_list:
      [
        {
          name: doe_intr_support
          struct: logic
          type: uni
          act: req
          width: 1
          default: 1'b0
          inst_name: mbx6
          package: ""
          external: true
          conn_type: false
          index: -1
          top_signame: mbx6_doe_intr_support
        }
        {
          name: doe_intr_en
          struct: logic
          type: uni
          act: req
          width: 1
          default: 1'b0
          inst_name: mbx6
          package: ""
          external: true
          conn_type: false
          index: -1
          top_signame: mbx6_doe_intr_en
        }
        {
          name: doe_intr
          struct: logic
          type: uni
          act: req
          width: 1
          default: 1'b0
          inst_name: mbx6
          package: ""
          external: true
          conn_type: false
          index: -1
          top_signame: mbx6_doe_intr
        }
        {
          name: doe_async_msg_support
          struct: logic
          type: uni
          act: req
          width: 1
          default: 1'b0
          inst_name: mbx6
          package: ""
          external: true
          conn_type: false
          index: -1
          top_signame: mbx6_doe_async_msg_support
        }
        {
          name: racl_policies
          desc:
            '''
            Incoming RACL policy vector from a racl_ctrl instance.
            The policy selection vector (parameter) selects the policy for each register.
            '''
          struct: racl_policy_vec
          package: top_racl_pkg
          type: uni
          act: rcv
          width: 1
          inst_name: mbx6
          default: ""
          domain: Main
          top_signame: racl_ctrl_racl_policies
          index: -1
        }
        {
          name: racl_error
          desc: RACL error log information of this module.
          struct: racl_error_log
          package: top_racl_pkg
          type: uni
          act: req
          width: 1
          inst_name: mbx6
          default: ""
          domain: Main
          top_signame: racl_ctrl_racl_error
          index: 6
        }
        {
          name: sram_tl_h
          struct: tl
          package: tlul_pkg
          type: req_rsp
          act: req
          width: 1
          inst_name: mbx6
          default: ""
          domain: Main
          top_signame: main_tl_mbx6__sram
          index: -1
        }
        {
          name: core_tl_d
          struct: tl
          package: tlul_pkg
          type: req_rsp
          act: rsp
          width: 1
          inst_name: mbx6
          default: ""
          end_idx: -1
          top_type: one-to-one
          top_signame: mbx6_core_tl_d
          index: -1
        }
        {
          name: soc_tl_d
          struct: tl
          package: tlul_pkg
          type: req_rsp
          act: rsp
          width: 1
          inst_name: mbx6
          default: ""
          end_idx: -1
          top_type: one-to-one
          top_signame: mbx6_soc_tl_d
          index: -1
        }
      ]
      generate_dif: true
    }
    {
      name: mbx_jtag
      type: mbx
      clock_srcs:
      {
        clk_i: main
      }
      clock_group: infra
      reset_connections:
      {
        rst_ni:
        {
          name: lc
          domain: Main
        }
      }
      base_addrs:
      {
        core:
        {
          hart: 0x22000800
        }
        soc:
        {
          soc_dbg: 0x2200
        }
      }
      racl_mappings:
      {
        soc:
        {
          racl_group: Null
          register_mapping:
          {
            SOC_CONTROL: 0
            SOC_STATUS: 0
            SOC_DOE_INTR_MSG_ADDR: 0
            SOC_DOE_INTR_MSG_DATA: 0
          }
          window_mapping:
          {
            WDATA: 0
            RDATA: 0
          }
          range_mapping: []
        }
      }
      domain: Main
      clock_connections:
      {
        clk_i: clkmgr_clocks_i.clk_main_infra
      }
      param_decl: {}
      memory: {}
      param_list: []
      inter_signal_list:
      [
        {
          name: doe_intr_support
          struct: logic
          type: uni
          act: req
          width: 1
          default: 1'b0
          inst_name: mbx_jtag
          package: ""
          external: true
          conn_type: false
          index: -1
          top_signame: mbx_jtag_doe_intr_support
        }
        {
          name: doe_intr_en
          struct: logic
          type: uni
          act: req
          width: 1
          default: 1'b0
          inst_name: mbx_jtag
          package: ""
          external: true
          conn_type: false
          index: -1
          top_signame: mbx_jtag_doe_intr_en
        }
        {
          name: doe_intr
          struct: logic
          type: uni
          act: req
          width: 1
          default: 1'b0
          inst_name: mbx_jtag
          package: ""
          external: true
          conn_type: false
          index: -1
          top_signame: mbx_jtag_doe_intr
        }
        {
          name: doe_async_msg_support
          struct: logic
          type: uni
          act: req
          width: 1
          default: 1'b0
          inst_name: mbx_jtag
          package: ""
          external: true
          conn_type: false
          index: -1
          top_signame: mbx_jtag_doe_async_msg_support
        }
        {
          name: racl_policies
          desc:
            '''
            Incoming RACL policy vector from a racl_ctrl instance.
            The policy selection vector (parameter) selects the policy for each register.
            '''
          struct: racl_policy_vec
          package: top_racl_pkg
          type: uni
          act: rcv
          width: 1
          inst_name: mbx_jtag
          default: ""
          domain: Main
          top_signame: racl_ctrl_racl_policies
          index: -1
        }
        {
          name: racl_error
          desc: RACL error log information of this module.
          struct: racl_error_log
          package: top_racl_pkg
          type: uni
          act: req
          width: 1
          inst_name: mbx_jtag
          default: ""
          domain: Main
          top_signame: racl_ctrl_racl_error
          index: 7
        }
        {
          name: sram_tl_h
          struct: tl
          package: tlul_pkg
          type: req_rsp
          act: req
          width: 1
          inst_name: mbx_jtag
          default: ""
          domain: Main
          top_signame: main_tl_mbx_jtag__sram
          index: -1
        }
        {
          name: core_tl_d
          struct: tl
          package: tlul_pkg
          type: req_rsp
          act: rsp
          width: 1
          inst_name: mbx_jtag
          default: ""
          end_idx: -1
          top_type: one-to-one
          top_signame: mbx_jtag_core_tl_d
          index: -1
        }
        {
          name: soc_tl_d
          struct: tl
          package: tlul_pkg
          type: req_rsp
          act: rsp
          width: 1
          inst_name: mbx_jtag
          default: ""
          end_idx: -1
          top_type: one-to-one
          top_signame: mbx_jtag_soc_tl_d
          index: -1
        }
      ]
      generate_dif: true
    }
    {
      name: mbx_pcie0
      type: mbx
      clock_srcs:
      {
        clk_i: main
      }
      clock_group: infra
      reset_connections:
      {
        rst_ni:
        {
          name: lc
          domain: Main
        }
      }
      base_addrs:
      {
        core:
        {
          hart: 0x22040000
        }
        soc:
        {
          soc_mbx: 0x01460100
        }
      }
      racl_mappings:
      {
        soc:
        {
          racl_group: Null
          register_mapping:
          {
            SOC_CONTROL: 2
            SOC_STATUS: 2
            SOC_DOE_INTR_MSG_ADDR: 2
            SOC_DOE_INTR_MSG_DATA: 2
          }
          window_mapping:
          {
            WDATA: 2
            RDATA: 2
          }
          range_mapping: []
        }
      }
      domain: Main
      clock_connections:
      {
        clk_i: clkmgr_clocks_i.clk_main_infra
      }
      param_decl: {}
      memory: {}
      param_list: []
      inter_signal_list:
      [
        {
          name: doe_intr_support
          struct: logic
          type: uni
          act: req
          width: 1
          default: 1'b0
          inst_name: mbx_pcie0
          package: ""
          external: true
          conn_type: false
          index: -1
          top_signame: mbx_pcie0_doe_intr_support
        }
        {
          name: doe_intr_en
          struct: logic
          type: uni
          act: req
          width: 1
          default: 1'b0
          inst_name: mbx_pcie0
          package: ""
          external: true
          conn_type: false
          index: -1
          top_signame: mbx_pcie0_doe_intr_en
        }
        {
          name: doe_intr
          struct: logic
          type: uni
          act: req
          width: 1
          default: 1'b0
          inst_name: mbx_pcie0
          package: ""
          external: true
          conn_type: false
          index: -1
          top_signame: mbx_pcie0_doe_intr
        }
        {
          name: doe_async_msg_support
          struct: logic
          type: uni
          act: req
          width: 1
          default: 1'b0
          inst_name: mbx_pcie0
          package: ""
          external: true
          conn_type: false
          index: -1
          top_signame: mbx_pcie0_doe_async_msg_support
        }
        {
          name: racl_policies
          desc:
            '''
            Incoming RACL policy vector from a racl_ctrl instance.
            The policy selection vector (parameter) selects the policy for each register.
            '''
          struct: racl_policy_vec
          package: top_racl_pkg
          type: uni
          act: rcv
          width: 1
          inst_name: mbx_pcie0
          default: ""
          domain: Main
          top_signame: racl_ctrl_racl_policies
          index: -1
        }
        {
          name: racl_error
          desc: RACL error log information of this module.
          struct: racl_error_log
          package: top_racl_pkg
          type: uni
          act: req
          width: 1
          inst_name: mbx_pcie0
          default: ""
          domain: Main
          top_signame: racl_ctrl_racl_error
          index: 8
        }
        {
          name: sram_tl_h
          struct: tl
          package: tlul_pkg
          type: req_rsp
          act: req
          width: 1
          inst_name: mbx_pcie0
          default: ""
          domain: Main
          top_signame: main_tl_mbx_pcie0__sram
          index: -1
        }
        {
          name: core_tl_d
          struct: tl
          package: tlul_pkg
          type: req_rsp
          act: rsp
          width: 1
          inst_name: mbx_pcie0
          default: ""
          end_idx: -1
          top_type: one-to-one
          top_signame: mbx_pcie0_core_tl_d
          index: -1
        }
        {
          name: soc_tl_d
          struct: tl
          package: tlul_pkg
          type: req_rsp
          act: rsp
          width: 1
          inst_name: mbx_pcie0
          default: ""
          end_idx: -1
          top_type: one-to-one
          top_signame: mbx_pcie0_soc_tl_d
          index: -1
        }
      ]
      generate_dif: true
    }
    {
      name: mbx_pcie1
      type: mbx
      clock_srcs:
      {
        clk_i: main
      }
      clock_group: infra
      reset_connections:
      {
        rst_ni:
        {
          name: lc
          domain: Main
        }
      }
      base_addrs:
      {
        core:
        {
          hart: 0x22040100
        }
        soc:
        {
          soc_mbx: 0x01460200
        }
      }
      racl_mappings:
      {
        soc:
        {
          racl_group: Null
          register_mapping:
          {
            SOC_CONTROL: 2
            SOC_STATUS: 2
            SOC_DOE_INTR_MSG_ADDR: 2
            SOC_DOE_INTR_MSG_DATA: 2
          }
          window_mapping:
          {
            WDATA: 2
            RDATA: 2
          }
          range_mapping: []
        }
      }
      domain: Main
      clock_connections:
      {
        clk_i: clkmgr_clocks_i.clk_main_infra
      }
      param_decl: {}
      memory: {}
      param_list: []
      inter_signal_list:
      [
        {
          name: doe_intr_support
          struct: logic
          type: uni
          act: req
          width: 1
          default: 1'b0
          inst_name: mbx_pcie1
          package: ""
          external: true
          conn_type: false
          index: -1
          top_signame: mbx_pcie1_doe_intr_support
        }
        {
          name: doe_intr_en
          struct: logic
          type: uni
          act: req
          width: 1
          default: 1'b0
          inst_name: mbx_pcie1
          package: ""
          external: true
          conn_type: false
          index: -1
          top_signame: mbx_pcie1_doe_intr_en
        }
        {
          name: doe_intr
          struct: logic
          type: uni
          act: req
          width: 1
          default: 1'b0
          inst_name: mbx_pcie1
          package: ""
          external: true
          conn_type: false
          index: -1
          top_signame: mbx_pcie1_doe_intr
        }
        {
          name: doe_async_msg_support
          struct: logic
          type: uni
          act: req
          width: 1
          default: 1'b0
          inst_name: mbx_pcie1
          package: ""
          external: true
          conn_type: false
          index: -1
          top_signame: mbx_pcie1_doe_async_msg_support
        }
        {
          name: racl_policies
          desc:
            '''
            Incoming RACL policy vector from a racl_ctrl instance.
            The policy selection vector (parameter) selects the policy for each register.
            '''
          struct: racl_policy_vec
          package: top_racl_pkg
          type: uni
          act: rcv
          width: 1
          inst_name: mbx_pcie1
          default: ""
          domain: Main
          top_signame: racl_ctrl_racl_policies
          index: -1
        }
        {
          name: racl_error
          desc: RACL error log information of this module.
          struct: racl_error_log
          package: top_racl_pkg
          type: uni
          act: req
          width: 1
          inst_name: mbx_pcie1
          default: ""
          domain: Main
          top_signame: racl_ctrl_racl_error
          index: 9
        }
        {
          name: sram_tl_h
          struct: tl
          package: tlul_pkg
          type: req_rsp
          act: req
          width: 1
          inst_name: mbx_pcie1
          default: ""
          domain: Main
          top_signame: main_tl_mbx_pcie1__sram
          index: -1
        }
        {
          name: core_tl_d
          struct: tl
          package: tlul_pkg
          type: req_rsp
          act: rsp
          width: 1
          inst_name: mbx_pcie1
          default: ""
          end_idx: -1
          top_type: one-to-one
          top_signame: mbx_pcie1_core_tl_d
          index: -1
        }
        {
          name: soc_tl_d
          struct: tl
          package: tlul_pkg
          type: req_rsp
          act: rsp
          width: 1
          inst_name: mbx_pcie1
          default: ""
          end_idx: -1
          top_type: one-to-one
          top_signame: mbx_pcie1_soc_tl_d
          index: -1
        }
      ]
      generate_dif: true
    }
    {
      name: soc_dbg_ctrl
      type: soc_dbg_ctrl
      clock_srcs:
      {
        clk_i: io
      }
      clock_group: secure
      reset_connections:
      {
        rst_ni:
        {
          name: lc_io
          domain: Main
        }
      }
      base_addrs:
      {
        core:
        {
          hart: 0x30170000
        }
        jtag:
        {
          soc_dbg: 0x2300
        }
      }
      domain: Main
      clock_connections:
      {
        clk_i: clkmgr_clocks_i.clk_io_secure
      }
      param_decl: {}
      memory: {}
      param_list: []
      inter_signal_list:
      [
        {
          name: boot_status
          struct: pwr_boot_status
          package: pwrmgr_pkg
          type: uni
          act: rcv
          width: 1
          inst_name: soc_dbg_ctrl
          default: ""
          domain: Main
          top_signame: pwrmgr_boot_status
          index: -1
          external: true
          conn_type: false
        }
        {
          name: soc_dbg_state
          struct: soc_dbg_state
          package: lc_ctrl_state_pkg
          type: uni
          act: rcv
          width: 1
          inst_name: soc_dbg_ctrl
          default: ""
          top_signame: soc_dbg_ctrl_soc_dbg_state
          index: -1
        }
        {
          name: soc_dbg_policy_bus
          struct: soc_dbg_policy
          package: soc_dbg_ctrl_pkg
          type: uni
          act: req
          width: 1
          inst_name: soc_dbg_ctrl
          default: ""
          external: true
          conn_type: false
          index: -1
          top_signame: soc_dbg_policy_bus
        }
        {
          name: lc_hw_debug_en
          desc: Multibit life cycle hardware debug enable signal coming from life cycle controller, asserted when the hardware debug mechanisms are enabled in the system.
          struct: lc_tx
          package: lc_ctrl_pkg
          type: uni
          act: rcv
          width: 1
          default: lc_ctrl_pkg::Off
          inst_name: soc_dbg_ctrl
          domain: Main
          top_signame: lc_ctrl_lc_hw_debug_en
          index: -1
        }
        {
          name: lc_dft_en
          desc:
            '''
            Test enable qualifier coming from life cycle controller.
            This signals enables TEST & RMA mode accesses.
            '''
          struct: lc_tx
          package: lc_ctrl_pkg
          type: uni
          act: rcv
          width: 1
          default: lc_ctrl_pkg::Off
          inst_name: soc_dbg_ctrl
          domain: Main
          top_signame: lc_ctrl_lc_dft_en
          index: -1
        }
        {
          name: lc_raw_test_rma
          desc:
            '''
            Test enable qualifier coming from life cycle controller.
            This signals enables RAW, TEST and RMA mode accesses.
            '''
          struct: lc_tx
          package: lc_ctrl_pkg
          type: uni
          act: rcv
          width: 1
          default: lc_ctrl_pkg::Off
          inst_name: soc_dbg_ctrl
          domain: Main
          top_signame: lc_ctrl_lc_raw_test_rma
          index: -1
        }
        {
          name: lc_cpu_en
          desc:
            '''
            CPU enable qualifier coming from life cycle controller.
            Indication from life cycle controller that the CPU is running.
            '''
          struct: lc_tx
          package: lc_ctrl_pkg
          type: uni
          act: rcv
          width: 1
          default: lc_ctrl_pkg::Off
          inst_name: soc_dbg_ctrl
          domain: Main
          top_signame: lc_ctrl_lc_cpu_en
          index: -1
        }
        {
          name: lc_rma_state
          desc:
            '''
            RMA state qualifier coming from life cycle controller.
            Indication from life cycle controller that the RMA state is active.
            '''
          struct: lc_tx
          package: lc_ctrl_pkg
          type: uni
          act: rcv
          width: 1
          default: lc_ctrl_pkg::Off
          inst_name: soc_dbg_ctrl
          domain: Main
          top_signame: lc_ctrl_lc_rma_state
          index: -1
        }
        {
          name: halt_cpu_boot
          desc: External request to halt the CPU until a JTAG command allows the boot process to continue.
          struct: logic
          type: uni
          act: rcv
          width: 1
          inst_name: soc_dbg_ctrl
          default: ""
          package: ""
          external: true
          conn_type: false
          index: -1
          top_signame: debug_halt_cpu_boot
        }
        {
          name: continue_cpu_boot
          desc: Artificial ROM control input to the pwrmgr to halt the boot process.
          struct: pwrmgr_data
          package: rom_ctrl_pkg
          type: uni
          act: req
          width: 1
          inst_name: soc_dbg_ctrl
          default: ""
          domain: Main
          top_signame: pwrmgr_rom_ctrl
          index: 2
          external: true
          conn_type: false
        }
        {
          name: core_tl
          struct: tl
          package: tlul_pkg
          type: req_rsp
          act: rsp
          width: 1
          inst_name: soc_dbg_ctrl
          default: ""
          end_idx: -1
          top_type: one-to-one
          top_signame: soc_dbg_ctrl_core_tl
          index: -1
        }
        {
          name: jtag_tl
          struct: tl
          package: tlul_pkg
          type: req_rsp
          act: rsp
          width: 1
          inst_name: soc_dbg_ctrl
          default: ""
          end_idx: -1
          top_type: one-to-one
          top_signame: soc_dbg_ctrl_jtag_tl
          index: -1
        }
      ]
      generate_dif: true
    }
    {
      name: racl_ctrl
      type: racl_ctrl
      template_type: racl_ctrl
      clock_srcs:
      {
        clk_i: main
      }
      clock_group: infra
      reset_connections:
      {
        rst_ni:
        {
          name: lc
          domain: Main
        }
      }
      attr: ipgen
      domain: Main
      clock_connections:
      {
        clk_i: clkmgr_clocks_i.clk_main_infra
      }
      param_decl: {}
      memory: {}
      param_list:
      [
        {
          name: NumSubscribingIps
          desc: Number of subscribing RACL IPs
          type: int
          default: 11
          local: "true"
          expose: "true"
          name_top: RaclCtrlNumSubscribingIps
        }
        {
          name: NumExternalSubscribingIps
          desc: Number of external subscribing RACL IPs
          type: int
          default: 1
          local: "false"
          expose: "true"
          name_top: RaclCtrlNumExternalSubscribingIps
        }
      ]
      inter_signal_list:
      [
        {
          name: racl_policies
          desc: Policy vector distributed to the subscribing RACL IPs.
          struct: racl_policy_vec
          package: top_racl_pkg
          type: uni
          act: req
          width: 1
          inst_name: racl_ctrl
          default: ""
          end_idx: -1
          top_type: broadcast
          top_signame: racl_ctrl_racl_policies
          index: -1
          external: true
          conn_type: true
        }
        {
          name: racl_error
          desc:
            '''
            Error log information from all IPs.
            Only one IP can raise an error at a time.
            '''
          struct: racl_error_log
          package: top_racl_pkg
          type: uni
          act: rcv
          width:
          {
            name: NumSubscribingIps
            desc: Number of subscribing RACL IPs
            param_type: int
            unpacked_dimensions: null
            default: 11
            local: true
            expose: true
            name_top: RaclCtrlNumSubscribingIps
          }
          inst_name: racl_ctrl
          default: ""
          end_idx: -1
          top_type: one-to-N
          top_signame: racl_ctrl_racl_error
          index: -1
        }
        {
          name: racl_error_external
          desc:
            '''
            Error log information from all external IPs.
            Only one IP can raise an error at a time.
            '''
          struct: racl_error_log
          package: top_racl_pkg
          type: uni
          act: rcv
          width:
          {
            name: NumExternalSubscribingIps
            desc: Number of external subscribing RACL IPs
            param_type: int
            unpacked_dimensions: null
            default: 1
            local: false
            expose: true
            name_top: RaclCtrlNumExternalSubscribingIps
          }
          inst_name: racl_ctrl
          default: ""
          external: true
          conn_type: false
          index: -1
          top_signame: racl_error
        }
        {
          name: tl
          struct: tl
          package: tlul_pkg
          type: req_rsp
          act: rsp
          width: 1
          inst_name: racl_ctrl
          default: ""
          end_idx: -1
          top_type: one-to-one
          top_signame: racl_ctrl_tl
          index: -1
        }
      ]
      base_addrs:
      {
        null:
        {
          soc_mbx: 0x01461f00
        }
      }
      generate_dif: true
    }
    {
      name: ac_range_check
      type: ac_range_check
      template_type: ac_range_check
      clock_srcs:
      {
        clk_i: main
      }
      clock_group: secure
      reset_connections:
      {
        rst_ni:
        {
          name: lc
          domain: Main
        }
      }
      ipgen_params:
      {
        num_ranges: 32
      }
      attr: ipgen
      domain: Main
      clock_connections:
      {
        clk_i: clkmgr_clocks_i.clk_main_secure
      }
      param_decl: {}
      memory: {}
      param_list:
      [
        {
          name: RangeCheckErrorRsp
          desc:
            '''
            Error behavior on blocked requests:
            1: A denied request returns a TLUL error (.d_error = 1 on the response)
            0: Writes are dropped and reads return all-zero, without a TLUL error
            '''
          type: bit
          default: "1"
          local: "false"
          expose: "true"
          name_top: AcRangeCheckRangeCheckErrorRsp
        }
      ]
      inter_signal_list:
      [
        {
          name: range_check_overwrite
          desc: Overwrites all ranges and let all requests pass through.
          struct: mubi8
          package: prim_mubi_pkg
          type: uni
          act: rcv
          width: 1
          inst_name: ac_range_check
          default: ""
          external: true
          conn_type: false
          index: -1
          top_signame: ac_range_check_overwrite
        }
        {
          name: ctn_tl_h2d
          desc: TL-UL input port (request part), synchronous
          struct: tl_h2d
          package: tlul_pkg
          type: uni
          act: rcv
          width: 1
          inst_name: ac_range_check
          default: ""
          domain: Main
          top_signame: soc_proxy_ctn_tl_h2d
          index: -1
          external: true
          conn_type: false
        }
        {
          name: ctn_tl_d2h
          desc: TL-UL input port (response part), synchronous
          struct: tl_d2h
          package: tlul_pkg
          type: uni
          act: req
          width: 1
          inst_name: ac_range_check
          default: ""
          domain: Main
          top_signame: soc_proxy_ctn_tl_d2h
          index: -1
          external: true
          conn_type: false
        }
        {
          name: ctn_filtered_tl_h2d
          desc: Filtered TL-UL output port (request part), synchronous
          struct: tl_h2d
          package: tlul_pkg
          type: uni
          act: req
          width: 1
          inst_name: ac_range_check
          default: ""
          external: true
          conn_type: false
          index: -1
          top_signame: ctn_tl_h2d
        }
        {
          name: ctn_filtered_tl_d2h
          desc: Filtered TL-UL output port (response part), synchronous
          struct: tl_d2h
          package: tlul_pkg
          type: uni
          act: rcv
          width: 1
          inst_name: ac_range_check
          default: ""
          external: true
          conn_type: false
          index: -1
          top_signame: ctn_tl_d2h
        }
        {
          name: racl_policies
          desc:
            '''
            Incoming RACL policy vector from a racl_ctrl instance.
            The policy selection vector (parameter) selects the policy for each register.
            '''
          struct: racl_policy_vec
          package: top_racl_pkg
          type: uni
          act: rcv
          width: 1
          inst_name: ac_range_check
          default: ""
          domain: Main
          top_signame: racl_ctrl_racl_policies
          index: -1
        }
        {
          name: racl_error
          desc: RACL error log information of this module.
          struct: racl_error_log
          package: top_racl_pkg
          type: uni
          act: req
          width: 1
          inst_name: ac_range_check
          default: ""
          domain: Main
          top_signame: racl_ctrl_racl_error
          index: 10
        }
        {
          name: tl
          struct: tl
          package: tlul_pkg
          type: req_rsp
          act: rsp
          width: 1
          inst_name: ac_range_check
          default: ""
          end_idx: -1
          top_type: one-to-one
          top_signame: ac_range_check_tl
          index: -1
        }
      ]
      base_addrs:
      {
        null:
        {
          soc_mbx: 0x01464000
        }
      }
      generate_dif: true
      racl_mappings:
      {
        null:
        {
          racl_group: Null
          register_mapping:
          {
            INTR_STATE: 2
            INTR_ENABLE: 2
            INTR_TEST: 2
            ALERT_TEST: 2
            ALERT_STATUS: 2
            LOG_CONFIG: 2
            LOG_STATUS: 2
            LOG_ADDRESS: 2
            RANGE_REGWEN_0: 2
            RANGE_REGWEN_1: 2
            RANGE_REGWEN_2: 2
            RANGE_REGWEN_3: 2
            RANGE_REGWEN_4: 2
            RANGE_REGWEN_5: 2
            RANGE_REGWEN_6: 2
            RANGE_REGWEN_7: 2
            RANGE_REGWEN_8: 2
            RANGE_REGWEN_9: 2
            RANGE_REGWEN_10: 2
            RANGE_REGWEN_11: 2
            RANGE_REGWEN_12: 2
            RANGE_REGWEN_13: 2
            RANGE_REGWEN_14: 2
            RANGE_REGWEN_15: 2
            RANGE_REGWEN_16: 2
            RANGE_REGWEN_17: 2
            RANGE_REGWEN_18: 2
            RANGE_REGWEN_19: 2
            RANGE_REGWEN_20: 2
            RANGE_REGWEN_21: 2
            RANGE_REGWEN_22: 2
            RANGE_REGWEN_23: 2
            RANGE_REGWEN_24: 2
            RANGE_REGWEN_25: 2
            RANGE_REGWEN_26: 2
            RANGE_REGWEN_27: 2
            RANGE_REGWEN_28: 2
            RANGE_REGWEN_29: 2
            RANGE_REGWEN_30: 2
            RANGE_REGWEN_31: 2
            RANGE_BASE_0: 2
            RANGE_BASE_1: 2
            RANGE_BASE_2: 2
            RANGE_BASE_3: 2
            RANGE_BASE_4: 2
            RANGE_BASE_5: 2
            RANGE_BASE_6: 2
            RANGE_BASE_7: 2
            RANGE_BASE_8: 2
            RANGE_BASE_9: 2
            RANGE_BASE_10: 2
            RANGE_BASE_11: 2
            RANGE_BASE_12: 2
            RANGE_BASE_13: 2
            RANGE_BASE_14: 2
            RANGE_BASE_15: 2
            RANGE_BASE_16: 2
            RANGE_BASE_17: 2
            RANGE_BASE_18: 2
            RANGE_BASE_19: 2
            RANGE_BASE_20: 2
            RANGE_BASE_21: 2
            RANGE_BASE_22: 2
            RANGE_BASE_23: 2
            RANGE_BASE_24: 2
            RANGE_BASE_25: 2
            RANGE_BASE_26: 2
            RANGE_BASE_27: 2
            RANGE_BASE_28: 2
            RANGE_BASE_29: 2
            RANGE_BASE_30: 2
            RANGE_BASE_31: 2
            RANGE_LIMIT_0: 2
            RANGE_LIMIT_1: 2
            RANGE_LIMIT_2: 2
            RANGE_LIMIT_3: 2
            RANGE_LIMIT_4: 2
            RANGE_LIMIT_5: 2
            RANGE_LIMIT_6: 2
            RANGE_LIMIT_7: 2
            RANGE_LIMIT_8: 2
            RANGE_LIMIT_9: 2
            RANGE_LIMIT_10: 2
            RANGE_LIMIT_11: 2
            RANGE_LIMIT_12: 2
            RANGE_LIMIT_13: 2
            RANGE_LIMIT_14: 2
            RANGE_LIMIT_15: 2
            RANGE_LIMIT_16: 2
            RANGE_LIMIT_17: 2
            RANGE_LIMIT_18: 2
            RANGE_LIMIT_19: 2
            RANGE_LIMIT_20: 2
            RANGE_LIMIT_21: 2
            RANGE_LIMIT_22: 2
            RANGE_LIMIT_23: 2
            RANGE_LIMIT_24: 2
            RANGE_LIMIT_25: 2
            RANGE_LIMIT_26: 2
            RANGE_LIMIT_27: 2
            RANGE_LIMIT_28: 2
            RANGE_LIMIT_29: 2
            RANGE_LIMIT_30: 2
            RANGE_LIMIT_31: 2
            RANGE_ATTR_0: 2
            RANGE_ATTR_1: 2
            RANGE_ATTR_2: 2
            RANGE_ATTR_3: 2
            RANGE_ATTR_4: 2
            RANGE_ATTR_5: 2
            RANGE_ATTR_6: 2
            RANGE_ATTR_7: 2
            RANGE_ATTR_8: 2
            RANGE_ATTR_9: 2
            RANGE_ATTR_10: 2
            RANGE_ATTR_11: 2
            RANGE_ATTR_12: 2
            RANGE_ATTR_13: 2
            RANGE_ATTR_14: 2
            RANGE_ATTR_15: 2
            RANGE_ATTR_16: 2
            RANGE_ATTR_17: 2
            RANGE_ATTR_18: 2
            RANGE_ATTR_19: 2
            RANGE_ATTR_20: 2
            RANGE_ATTR_21: 2
            RANGE_ATTR_22: 2
            RANGE_ATTR_23: 2
            RANGE_ATTR_24: 2
            RANGE_ATTR_25: 2
            RANGE_ATTR_26: 2
            RANGE_ATTR_27: 2
            RANGE_ATTR_28: 2
            RANGE_ATTR_29: 2
            RANGE_ATTR_30: 2
            RANGE_ATTR_31: 2
            RANGE_RACL_POLICY_SHADOWED_0: 2
            RANGE_RACL_POLICY_SHADOWED_1: 2
            RANGE_RACL_POLICY_SHADOWED_2: 2
            RANGE_RACL_POLICY_SHADOWED_3: 2
            RANGE_RACL_POLICY_SHADOWED_4: 2
            RANGE_RACL_POLICY_SHADOWED_5: 2
            RANGE_RACL_POLICY_SHADOWED_6: 2
            RANGE_RACL_POLICY_SHADOWED_7: 2
            RANGE_RACL_POLICY_SHADOWED_8: 2
            RANGE_RACL_POLICY_SHADOWED_9: 2
            RANGE_RACL_POLICY_SHADOWED_10: 2
            RANGE_RACL_POLICY_SHADOWED_11: 2
            RANGE_RACL_POLICY_SHADOWED_12: 2
            RANGE_RACL_POLICY_SHADOWED_13: 2
            RANGE_RACL_POLICY_SHADOWED_14: 2
            RANGE_RACL_POLICY_SHADOWED_15: 2
            RANGE_RACL_POLICY_SHADOWED_16: 2
            RANGE_RACL_POLICY_SHADOWED_17: 2
            RANGE_RACL_POLICY_SHADOWED_18: 2
            RANGE_RACL_POLICY_SHADOWED_19: 2
            RANGE_RACL_POLICY_SHADOWED_20: 2
            RANGE_RACL_POLICY_SHADOWED_21: 2
            RANGE_RACL_POLICY_SHADOWED_22: 2
            RANGE_RACL_POLICY_SHADOWED_23: 2
            RANGE_RACL_POLICY_SHADOWED_24: 2
            RANGE_RACL_POLICY_SHADOWED_25: 2
            RANGE_RACL_POLICY_SHADOWED_26: 2
            RANGE_RACL_POLICY_SHADOWED_27: 2
            RANGE_RACL_POLICY_SHADOWED_28: 2
            RANGE_RACL_POLICY_SHADOWED_29: 2
            RANGE_RACL_POLICY_SHADOWED_30: 2
            RANGE_RACL_POLICY_SHADOWED_31: 2
          }
          window_mapping: {}
          range_mapping: []
        }
      }
    }
    {
      name: rv_core_ibex
      type: rv_core_ibex
      template_type: rv_core_ibex
      attr: ipgen
      ipgen_params:
      {
        num_regions: 32
      }
      param_decl:
      {
        PMPEnable: "1"
        PMPGranularity: "0"
        PMPNumRegions: "16"
        MHPMCounterNum: "10"
        MHPMCounterWidth: "32"
        PMPRstCfg: ibex_pmp_reset_pkg::PmpCfgRst
        PMPRstAddr: ibex_pmp_reset_pkg::PmpAddrRst
        PMPRstMsecCfg: ibex_pmp_reset_pkg::PmpMseccfgRst
        RV32E: "0"
        RV32M: ibex_pkg::RV32MSingleCycle
        RV32B: ibex_pkg::RV32BFull
        RV32ZC: ibex_pkg::RV32ZcaZcbZcmp
        RegFile: ibex_pkg::RegFileFF
        BranchTargetALU: "1"
        WritebackStage: "1"
        ICache: "1"
        ICacheECC: "1"
        ICacheScramble: "1"
        BranchPredictor: "0"
        DbgTriggerEn: "1"
        DbgHwBreakNum: "4"
        SecureIbex: "1"
        DmBaseAddr: tl_main_pkg::ADDR_SPACE_RV_DM__MEM
        DmAddrMask: tl_main_pkg::ADDR_MASK_RV_DM__MEM
        DmHaltAddr: tl_main_pkg::ADDR_SPACE_RV_DM__MEM + dm::HaltAddress[31:0]
        DmExceptionAddr: tl_main_pkg::ADDR_SPACE_RV_DM__MEM + dm::ExceptionAddress[31:0]
        PipeLine: "1"
        InstructionPipeline: "1"
        NEscalationSeverities: AlertHandlerEscNumSeverities
        WidthPingCounter: AlertHandlerEscPingCountWidth
      }
      clock_srcs:
      {
        clk_i: main
        clk_edn_i: main
        clk_esc_i:
        {
          clock: io
          group: secure
        }
        clk_otp_i:
        {
          clock: io
          group: secure
        }
      }
      clock_group: infra
      reset_connections:
      {
        rst_ni:
        {
          name: lc
          domain: Main
        }
        rst_edn_ni:
        {
          name: lc
          domain: Main
        }
        rst_esc_ni:
        {
          name: lc_io
          domain: Main
        }
        rst_otp_ni:
        {
          name: lc_io
          domain: Main
        }
      }
      domain: Main
      clock_connections:
      {
        clk_i: clkmgr_clocks_i.clk_main_infra
        clk_edn_i: clkmgr_clocks_i.clk_main_infra
        clk_esc_i: clkmgr_clocks_i.clk_io_secure
        clk_otp_i: clkmgr_clocks_i.clk_io_secure
      }
      memory: {}
      param_list:
      [
        {
          name: NEscalationSeverities
          desc: Number of escalation severities
          type: int unsigned
          default: AlertHandlerEscNumSeverities
          local: "false"
          expose: "false"
          name_top: RvCoreIbexNEscalationSeverities
        }
        {
          name: WidthPingCounter
          desc: Width of the ping counter
          type: int unsigned
          default: AlertHandlerEscPingCountWidth
          local: "false"
          expose: "false"
          name_top: RvCoreIbexWidthPingCounter
        }
        {
          name: PMPEnable
          desc: Enable PMP
          type: bit
          default: "1"
          local: "false"
          expose: "true"
          name_top: RvCoreIbexPMPEnable
        }
        {
          name: PMPGranularity
          desc: PMP Granularity
          type: int unsigned
          default: "0"
          local: "false"
          expose: "true"
          name_top: RvCoreIbexPMPGranularity
        }
        {
          name: PMPNumRegions
          desc: PMP number of regions
          type: int unsigned
          default: "16"
          local: "false"
          expose: "true"
          name_top: RvCoreIbexPMPNumRegions
        }
        {
          name: MHPMCounterNum
          desc: "Number of the MHPM counter "
          type: int unsigned
          default: "10"
          local: "false"
          expose: "true"
          name_top: RvCoreIbexMHPMCounterNum
        }
        {
          name: MHPMCounterWidth
          desc: "Width of the MHPM Counter "
          type: int unsigned
          default: "32"
          local: "false"
          expose: "true"
          name_top: RvCoreIbexMHPMCounterWidth
        }
        {
          name: PMPRstCfg
          desc: Reset value of PMP config CSRs
          type: ibex_pkg::pmp_cfg_t
          unpacked_dimensions: "[16]"
          default: ibex_pmp_reset_pkg::PmpCfgRst
          local: "false"
          expose: "true"
          name_top: RvCoreIbexPMPRstCfg
        }
        {
          name: PMPRstAddr
          desc: Reset value of PMP address CSRs
          type: logic [33:0]
          unpacked_dimensions: "[16]"
          default: ibex_pmp_reset_pkg::PmpAddrRst
          local: "false"
          expose: "true"
          name_top: RvCoreIbexPMPRstAddr
        }
        {
          name: PMPRstMsecCfg
          desc: Reset value of MSECCFG CSR
          type: ibex_pkg::pmp_mseccfg_t
          default: ibex_pmp_reset_pkg::PmpMseccfgRst
          local: "false"
          expose: "true"
          name_top: RvCoreIbexPMPRstMsecCfg
        }
        {
          name: RV32E
          desc: RV32E
          type: bit
          default: "0"
          local: "false"
          expose: "true"
          name_top: RvCoreIbexRV32E
        }
        {
          name: RV32M
          desc: RV32M
          type: ibex_pkg::rv32m_e
          default: ibex_pkg::RV32MSingleCycle
          local: "false"
          expose: "true"
          name_top: RvCoreIbexRV32M
        }
        {
          name: RV32B
          desc: RV32B
          type: ibex_pkg::rv32b_e
          default: ibex_pkg::RV32BFull
          local: "false"
          expose: "true"
          name_top: RvCoreIbexRV32B
        }
        {
          name: RV32ZC
          desc: RV32ZC
          type: ibex_pkg::rv32zc_e
          default: ibex_pkg::RV32ZcaZcbZcmp
          local: "false"
          expose: "true"
          name_top: RvCoreIbexRV32ZC
        }
        {
          name: RegFile
          desc: Reg file
          type: ibex_pkg::regfile_e
          default: ibex_pkg::RegFileFF
          local: "false"
          expose: "true"
          name_top: RvCoreIbexRegFile
        }
        {
          name: BranchTargetALU
          desc: Branch target ALU
          type: bit
          default: "1"
          local: "false"
          expose: "true"
          name_top: RvCoreIbexBranchTargetALU
        }
        {
          name: WritebackStage
          desc: Write back stage
          type: bit
          default: "1"
          local: "false"
          expose: "true"
          name_top: RvCoreIbexWritebackStage
        }
        {
          name: ICache
          desc: Instruction cache
          type: bit
          default: "1"
          local: "false"
          expose: "true"
          name_top: RvCoreIbexICache
        }
        {
          name: ICacheECC
          desc: Instruction cache ECC
          type: bit
          default: "1"
          local: "false"
          expose: "true"
          name_top: RvCoreIbexICacheECC
        }
        {
          name: ICacheScramble
          desc: Scramble instruction cach
          type: bit
          default: "1"
          local: "false"
          expose: "true"
          name_top: RvCoreIbexICacheScramble
        }
        {
          name: ICacheNWays
          desc: Number of instruction cache ways
          type: int unsigned
          default: 2
          local: "false"
          expose: "true"
          name_top: RvCoreIbexICacheNWays
        }
        {
          name: BranchPredictor
          desc: Branch predictor
          type: bit
          default: "0"
          local: "false"
          expose: "true"
          name_top: RvCoreIbexBranchPredictor
        }
        {
          name: DbgTriggerEn
          desc: Enable degug trigger
          type: bit
          default: "1"
          local: "false"
          expose: "true"
          name_top: RvCoreIbexDbgTriggerEn
        }
        {
          name: DbgHwBreakNum
          desc: Number of debug hardware break
          type: int
          default: "4"
          local: "false"
          expose: "true"
          name_top: RvCoreIbexDbgHwBreakNum
        }
        {
          name: SecureIbex
          desc: "Width of the MHPM Counter "
          type: bit
          default: "1"
          local: "false"
          expose: "true"
          name_top: RvCoreIbexSecureIbex
        }
        {
          name: DmBaseAddr
          desc: Base address of Debug Module
          type: int unsigned
          default: tl_main_pkg::ADDR_SPACE_RV_DM__MEM
          local: "false"
          expose: "true"
          name_top: RvCoreIbexDmBaseAddr
        }
        {
          name: DmAddrMask
          desc: Adress mask of Debug Module
          type: int unsigned
          default: tl_main_pkg::ADDR_MASK_RV_DM__MEM
          local: "false"
          expose: "true"
          name_top: RvCoreIbexDmAddrMask
        }
        {
          name: DmHaltAddr
          desc: Halt address
          type: int unsigned
          default: tl_main_pkg::ADDR_SPACE_RV_DM__MEM + dm::HaltAddress[31:0]
          local: "false"
          expose: "true"
          name_top: RvCoreIbexDmHaltAddr
        }
        {
          name: DmExceptionAddr
          desc: Exception address
          type: int unsigned
          default: tl_main_pkg::ADDR_SPACE_RV_DM__MEM + dm::ExceptionAddress[31:0]
          local: "false"
          expose: "true"
          name_top: RvCoreIbexDmExceptionAddr
        }
        {
          name: PipeLine
          desc: Pipe line
          type: bit
          default: "1"
          local: "false"
          expose: "true"
          name_top: RvCoreIbexPipeLine
        }
        {
          name: TlulHostUserRsvdBits
          desc: TLUL user bits sent on outgoing transfers.
          type: logic [tlul_pkg::RsvdWidth-1:0]
          default: "'0"
          local: "false"
          expose: "true"
          name_top: RvCoreIbexTlulHostUserRsvdBits
        }
        {
          name: CsrMvendorId
          desc:
            '''
            mvendorid: encoding of manufacturer/provider
            0 indicates this field is not implemented.
            Ibex implementors may wish to set their own JEDEC ID here.
            '''
          type: logic [31:0]
          default: "'0"
          local: "false"
          expose: "true"
          name_top: RvCoreIbexCsrMvendorId
        }
        {
          name: CsrMimpId
          desc:
            '''
            mimpid: encoding of processor implementation version
            0 indicates this field is not implemented.
            Ibex implementors may wish to indicate an RTL/netlist version here using their own unique encoding (e.g. 32 bits of the git hash of the implemented commit).
            '''
          type: logic [31:0]
          default: "'0"
          local: "false"
          expose: "true"
          name_top: RvCoreIbexCsrMimpId
        }
        {
          name: InstructionPipeline
          desc: Add a pipeline stage in the instruction interface between Ibex and the address translation
          type: bit
          default: "1"
          local: "true"
          expose: "true"
          name_top: RvCoreIbexInstructionPipeline
        }
      ]
      inter_signal_list:
      [
        {
          name: rst_cpu_n
          struct: logic
          type: uni
          act: req
          width: 1
          inst_name: rv_core_ibex
          index: -1
        }
        {
          name: ram_cfg_icache_tag
          struct: ram_1p_cfg
          package: prim_ram_1p_pkg
          type: req_rsp
          act: rsp
          width:
          {
            name: ICacheNWays
            desc: Number of instruction cache ways
            param_type: int unsigned
            unpacked_dimensions: null
            default: 2
            local: false
            expose: true
            name_top: RvCoreIbexICacheNWays
          }
          inst_name: rv_core_ibex
          default: ""
          external: true
          conn_type: false
          index: -1
          top_signame: rv_core_ibex_icache_tag_ram_cfg
        }
        {
          name: ram_cfg_icache_data
          struct: ram_1p_cfg
          package: prim_ram_1p_pkg
          type: req_rsp
          act: rsp
          width:
          {
            name: ICacheNWays
            desc: Number of instruction cache ways
            param_type: int unsigned
            unpacked_dimensions: null
            default: 2
            local: false
            expose: true
            name_top: RvCoreIbexICacheNWays
          }
          inst_name: rv_core_ibex
          default: ""
          external: true
          conn_type: false
          index: -1
          top_signame: rv_core_ibex_icache_data_ram_cfg
        }
        {
          name: hart_id
          struct: logic
          type: uni
          act: rcv
          width: 32
          inst_name: rv_core_ibex
          default: ""
          package: ""
          top_signame: rv_core_ibex_hart_id
          index: -1
        }
        {
          name: boot_addr
          struct: logic
          type: uni
          act: rcv
          width: 32
          inst_name: rv_core_ibex
          default: ""
          package: ""
          top_signame: rv_core_ibex_boot_addr
          index: -1
        }
        {
          name: irq_software
          struct: logic
          type: uni
          act: rcv
          width: 1
          inst_name: rv_core_ibex
          default: ""
          package: ""
          domain: Main
          top_signame: rv_plic_msip
          index: -1
        }
        {
          name: irq_timer
          struct: logic
          type: uni
          act: rcv
          width: 1
          inst_name: rv_core_ibex
          default: ""
          package: ""
          top_signame: rv_core_ibex_irq_timer
          index: -1
        }
        {
          name: irq_external
          struct: logic
          type: uni
          act: rcv
          width: 1
          inst_name: rv_core_ibex
          default: ""
          package: ""
          domain: Main
          top_signame: rv_plic_irq
          index: -1
        }
        {
          name: esc_tx
          struct: esc_tx
          package: prim_esc_pkg
          type: uni
          act: rcv
          width: 1
          inst_name: rv_core_ibex
          default: ""
          domain: Main
          top_signame: alert_handler_esc_tx
          index: 0
        }
        {
          name: esc_rx
          struct: esc_rx
          package: prim_esc_pkg
          type: uni
          act: req
          width: 1
          inst_name: rv_core_ibex
          default: ""
          domain: Main
          top_signame: alert_handler_esc_rx
          index: 0
        }
        {
          name: debug_req
          struct: logic
          type: uni
          act: rcv
          width: 1
          inst_name: rv_core_ibex
          default: ""
          package: ""
          domain: Main
          top_signame: rv_dm_debug_req
          index: -1
        }
        {
          name: crash_dump
          struct: cpu_crash_dump
          package: rv_core_ibex_pkg
          type: uni
          act: req
          width: 1
          inst_name: rv_core_ibex
          default: ""
          end_idx: -1
          top_type: broadcast
          top_signame: rv_core_ibex_crash_dump
          index: -1
          external: true
          conn_type: false
        }
        {
          name: lc_cpu_en
          struct: lc_tx
          package: lc_ctrl_pkg
          type: uni
          act: rcv
          width: 1
          default: lc_ctrl_pkg::On
          inst_name: rv_core_ibex
          domain: Main
          top_signame: lc_ctrl_lc_cpu_en
          index: -1
        }
        {
          name: pwrmgr_cpu_en
          struct: lc_tx
          package: lc_ctrl_pkg
          type: uni
          act: rcv
          width: 1
          inst_name: rv_core_ibex
          default: ""
          domain: Main
          top_signame: pwrmgr_fetch_en
          index: -1
          external: true
          conn_type: false
        }
        {
          name: pwrmgr
          struct: cpu_pwrmgr
          package: rv_core_ibex_pkg
          type: uni
          act: req
          width: 1
          inst_name: rv_core_ibex
          default: ""
          end_idx: -1
          top_type: broadcast
          top_signame: rv_core_ibex_pwrmgr
          index: -1
          external: true
          conn_type: false
        }
        {
          name: nmi_wdog
          struct: logic
          type: uni
          act: rcv
          width: 1
          inst_name: rv_core_ibex
          default: ""
          package: ""
          domain: Main
          top_signame: aon_timer_nmi_wdog_timer_bark
          index: -1
          external: true
          conn_type: false
        }
        {
          name: edn
          struct: edn
          package: edn_pkg
          type: req_rsp
          act: req
          width: 1
          inst_name: rv_core_ibex
          default: ""
          domain: Main
          top_signame: edn0_edn
          index: 6
        }
        {
          name: icache_otp_key
          struct: sram_otp_key
          package: otp_ctrl_pkg
          type: req_rsp
          act: req
          width: 1
          inst_name: rv_core_ibex
          default: ""
          domain: Main
          top_signame: otp_ctrl_sram_otp_key
          index: 3
        }
        {
          name: corei_tl_h
          struct: tl
          package: tlul_pkg
          type: req_rsp
          act: req
          width: 1
          inst_name: rv_core_ibex
          default: ""
          domain: Main
          top_signame: main_tl_rv_core_ibex__corei
          index: -1
        }
        {
          name: cored_tl_h
          struct: tl
          package: tlul_pkg
          type: req_rsp
          act: req
          width: 1
          inst_name: rv_core_ibex
          default: ""
          domain: Main
          top_signame: main_tl_rv_core_ibex__cored
          index: -1
        }
        {
          name: cfg_tl_d
          struct: tl
          package: tlul_pkg
          type: req_rsp
          act: rsp
          width: 1
          inst_name: rv_core_ibex
          default: ""
          end_idx: -1
          top_type: one-to-one
          top_signame: rv_core_ibex_cfg_tl_d
          index: -1
        }
      ]
      base_addrs:
      {
        cfg:
        {
          hart: 0x211f0000
        }
      }
      generate_dif: true
    }
  ]
  port:
  [
    {
      name: ast
      inter_signal_list:
      [
        {
          struct: lc_tx
          type: uni
          name: lc_dft_en
          act: req
          package: lc_ctrl_pkg
          inst_name: ast
          width: 1
          default: ""
          domain: Main
          top_signame: lc_ctrl_lc_dft_en
          index: -1
          external: true
          conn_type: true
        }
        {
          struct: lc_tx
          type: uni
          name: lc_hw_debug_en
          act: req
          package: lc_ctrl_pkg
          inst_name: ast
          width: 1
          default: ""
          domain: Main
          top_signame: lc_ctrl_lc_hw_debug_en
          index: -1
          external: true
          conn_type: true
        }
        {
          struct: ast_obs_ctrl
          type: uni
          name: obs_ctrl
          act: rcv
          package: ast_pkg
          inst_name: ast
          width: 1
          default: ""
          end_idx: -1
          top_type: broadcast
          top_signame: ast_obs_ctrl
          index: -1
          external: true
          conn_type: true
        }
      ]
    }
  ]
  inter_module:
  {
    connect:
    {
      ast.obs_ctrl:
      [
        otp_macro.obs_ctrl
      ]
      alert_handler.crashdump:
      [
        rstmgr.alert_dump
      ]
      alert_handler.esc_rx:
      [
        rv_core_ibex.esc_rx
        lc_ctrl.esc_scrap_state0_rx
        lc_ctrl.esc_scrap_state1_rx
        pwrmgr.esc_rst_rx
      ]
      alert_handler.esc_tx:
      [
        rv_core_ibex.esc_tx
        lc_ctrl.esc_scrap_state0_tx
        lc_ctrl.esc_scrap_state1_tx
        pwrmgr.esc_rst_tx
      ]
      aon_timer.nmi_wdog_timer_bark:
      [
        rv_core_ibex.nmi_wdog
      ]
      csrng.csrng_cmd:
      [
        edn0.csrng_cmd
        edn1.csrng_cmd
      ]
      csrng.entropy_src_hw_if:
      [
        entropy_src.entropy_src_hw_if
      ]
      otp_ctrl.sram_otp_key:
      [
        sram_ctrl_main.sram_otp_key
        sram_ctrl_ret.sram_otp_key
        sram_ctrl_mbox.sram_otp_key
        rv_core_ibex.icache_otp_key
      ]
      pwrmgr.pwr_rst:
      [
        rstmgr.pwr
      ]
      pwrmgr.pwr_clk:
      [
        clkmgr.pwr
      ]
      pwrmgr.pwr_otp:
      [
        otp_ctrl.pwr_otp
      ]
      pwrmgr.pwr_lc:
      [
        lc_ctrl.pwr_lc
      ]
      pwrmgr.strap:
      [
        gpio0.strap_en
        rv_dm.strap_en
      ]
      pwrmgr.low_power:
      [
        pinmux.sleep_en
        aon_timer.sleep_mode
      ]
      pwrmgr.fetch_en:
      [
        rv_core_ibex.pwrmgr_cpu_en
      ]
      pwrmgr.rom_ctrl:
      [
        rom_ctrl0.pwrmgr_data
        rom_ctrl1.pwrmgr_data
        soc_dbg_ctrl.continue_cpu_boot
      ]
      pwrmgr.boot_status:
      [
        soc_dbg_ctrl.boot_status
      ]
      keymgr_dpe.rom_digest:
      [
        rom_ctrl0.keymgr_data
        rom_ctrl1.keymgr_data
      ]
      dma.lsio_trigger:
      [
        soc_proxy.dma_lsio_trigger
      ]
      i2c0.lsio_trigger:
      [
        soc_proxy.i2c_lsio_trigger
      ]
      spi_host0.lsio_trigger:
      [
        soc_proxy.spi_host_lsio_trigger
      ]
      uart0.lsio_trigger:
      [
        soc_proxy.uart_lsio_trigger
      ]
      lc_ctrl.lc_nvm_rma_req:
      [
        otbn.lc_rma_req
      ]
      otbn.lc_rma_ack:
      [
        lc_ctrl.lc_nvm_rma_ack
      ]
      edn0.edn:
      [
        keymgr_dpe.edn
        otp_ctrl.edn
        kmac.entropy
        alert_handler.edn
        aes.edn
        otbn.edn_urnd
        rv_core_ibex.edn
      ]
      edn1.edn:
      [
        otbn.edn_rnd
      ]
      otp_ctrl.otbn_otp_key:
      [
        otbn.otbn_otp_key
      ]
      otp_ctrl.keymgr_creator_root_key:
      [
        keymgr_dpe.creator_root_key
      ]
      otp_ctrl.keymgr_creator_seed:
      [
        keymgr_dpe.creator_seed
      ]
      otp_ctrl.keymgr_owner_seed:
      [
        keymgr_dpe.owner_seed
      ]
      keymgr_dpe.aes_key:
      [
        aes.keymgr_key
      ]
      keymgr_dpe.kmac_key:
      [
        kmac.keymgr_key
      ]
      keymgr_dpe.hmac_key:
      [
        hmac.keymgr_key
      ]
      keymgr_dpe.otbn_key:
      [
        otbn.keymgr_key
      ]
      kmac.app:
      [
        keymgr_dpe.kmac_app
        lc_ctrl.kmac_data
        rom_ctrl0.kmac_data
        rom_ctrl1.kmac_data
      ]
      kmac.en_masking:
      [
        keymgr_dpe.kmac_en_masking
      ]
      kmac.keymgr_sensitive_key:
      [
        keymgr_dpe.kmac_sensitive_key
      ]
      otbn.keymgr_app:
      [
        keymgr_dpe.otbn_app
      ]
      otbn.keymgr_sensitive_key:
      [
        keymgr_dpe.otbn_sensitive_key
      ]
      clkmgr.idle:
      [
        aes.idle
        hmac.idle
        kmac.idle
        otbn.idle
      ]
      otp_ctrl.otp_lc_data:
      [
        lc_ctrl.otp_lc_data
      ]
      lc_ctrl.lc_otp_program:
      [
        otp_ctrl.lc_otp_program
      ]
      lc_ctrl.lc_otp_vendor_test:
      [
        otp_macro.test
      ]
      lc_ctrl.lc_keymgr_div:
      [
        keymgr_dpe.lc_keymgr_div
      ]
      lc_ctrl.strap_en_override:
      [
        rv_dm.strap_en_override
      ]
      lc_ctrl.lc_raw_test_rma:
      [
        soc_dbg_ctrl.lc_raw_test_rma
      ]
      lc_ctrl.lc_dft_en:
      [
        otp_macro.lc_dft_en
        ast.lc_dft_en
        pwrmgr.lc_dft_en
        soc_dbg_ctrl.lc_dft_en
        rv_dm.lc_dft_en
      ]
      lc_ctrl.lc_hw_debug_clr:
      [
        rv_dm.lc_hw_debug_clr
      ]
      lc_ctrl.lc_init_done:
      [
        rv_dm.lc_init_done
      ]
      lc_ctrl.lc_hw_debug_en:
      [
        sram_ctrl_main.lc_hw_debug_en
        ast.lc_hw_debug_en
        csrng.lc_hw_debug_en
        rv_dm.lc_hw_debug_en
        pwrmgr.lc_hw_debug_en
        soc_dbg_ctrl.lc_hw_debug_en
      ]
      lc_ctrl.lc_cpu_en:
      [
        rv_core_ibex.lc_cpu_en
        soc_dbg_ctrl.lc_cpu_en
      ]
      lc_ctrl.lc_keymgr_en:
      [
        keymgr_dpe.lc_keymgr_en
      ]
      lc_ctrl.lc_escalate_en:
      [
        aes.lc_escalate_en
        kmac.lc_escalate_en
        otbn.lc_escalate_en
        otp_ctrl.lc_escalate_en
        sram_ctrl_main.lc_escalate_en
        sram_ctrl_ret.lc_escalate_en
        sram_ctrl_mbox.lc_escalate_en
        aon_timer.lc_escalate_en
        rv_dm.lc_escalate_en
      ]
      lc_ctrl.lc_check_byp_en:
      [
        otp_ctrl.lc_check_byp_en
        rv_dm.lc_check_byp_en
      ]
      lc_ctrl.lc_clk_byp_ack:
      [
        lc_ctrl.lc_clk_byp_req
      ]
      lc_ctrl.lc_creator_seed_sw_rw_en:
      [
        otp_ctrl.lc_creator_seed_sw_rw_en
      ]
      lc_ctrl.lc_owner_seed_sw_rw_en:
      [
        otp_ctrl.lc_owner_seed_sw_rw_en
      ]
      lc_ctrl.lc_seed_hw_rd_en:
      [
        otp_ctrl.lc_seed_hw_rd_en
      ]
      lc_ctrl.lc_rma_state:
      [
        otp_ctrl.lc_rma_state
        soc_dbg_ctrl.lc_rma_state
      ]
      otp_ctrl.otp_macro:
      [
        otp_macro.otp
      ]
      rv_plic.msip:
      [
        rv_core_ibex.irq_software
      ]
      rv_plic.irq:
      [
        rv_core_ibex.irq_external
      ]
      rv_dm.debug_req:
      [
        rv_core_ibex.debug_req
      ]
      rv_core_ibex.crash_dump:
      [
        rstmgr.cpu_dump
      ]
      rv_core_ibex.pwrmgr:
      [
        pwrmgr.pwr_cpu
      ]
      spi_device.passthrough:
      [
        spi_host0.passthrough
      ]
      rv_dm.ndmreset_req:
      [
        pwrmgr.ndmreset_req
      ]
      rstmgr.sw_rst_req:
      [
        pwrmgr.sw_rst_req
      ]
      soc_proxy.dma_tl_h2d:
      [
        dma.ctn_tl_h2d
      ]
      soc_proxy.dma_tl_d2h:
      [
        dma.ctn_tl_d2h
      ]
      soc_proxy.ctn_tl_h2d:
      [
        ac_range_check.ctn_tl_h2d
      ]
      soc_proxy.ctn_tl_d2h:
      [
        ac_range_check.ctn_tl_d2h
      ]
      pwrmgr.wakeups:
      [
        pinmux.pin_wkup_req
        aon_timer.wkup_req
        soc_proxy.wkup_external_req
      ]
      pwrmgr.rstreqs:
      [
        aon_timer.aon_timer_rst_req
        soc_proxy.rst_req_external
      ]
      main.tl_rv_core_ibex__corei:
      [
        rv_core_ibex.corei_tl_h
      ]
      main.tl_rv_core_ibex__cored:
      [
        rv_core_ibex.cored_tl_h
      ]
      main.tl_rv_dm__sba:
      [
        rv_dm.sba_tl_h
      ]
      rv_dm.regs_tl_d:
      [
        main.tl_rv_dm__regs
      ]
      rv_dm.mem_tl_d:
      [
        main.tl_rv_dm__mem
      ]
      rom_ctrl0.rom_tl:
      [
        main.tl_rom_ctrl0__rom
      ]
      rom_ctrl0.regs_tl:
      [
        main.tl_rom_ctrl0__regs
      ]
      rom_ctrl1.rom_tl:
      [
        main.tl_rom_ctrl1__rom
      ]
      rom_ctrl1.regs_tl:
      [
        main.tl_rom_ctrl1__regs
      ]
      main.tl_peri:
      [
        peri.tl_main
      ]
      soc_proxy.core_tl:
      [
        main.tl_soc_proxy__core
      ]
      soc_proxy.ctn_tl:
      [
        main.tl_soc_proxy__ctn
      ]
      hmac.tl:
      [
        main.tl_hmac
      ]
      kmac.tl:
      [
        main.tl_kmac
      ]
      aes.tl:
      [
        main.tl_aes
      ]
      entropy_src.tl:
      [
        main.tl_entropy_src
      ]
      csrng.tl:
      [
        main.tl_csrng
      ]
      edn0.tl:
      [
        main.tl_edn0
      ]
      edn1.tl:
      [
        main.tl_edn1
      ]
      rv_plic.tl:
      [
        main.tl_rv_plic
      ]
      otbn.tl:
      [
        main.tl_otbn
      ]
      keymgr_dpe.tl:
      [
        main.tl_keymgr_dpe
      ]
      rv_core_ibex.cfg_tl_d:
      [
        main.tl_rv_core_ibex__cfg
      ]
      sram_ctrl_main.regs_tl:
      [
        main.tl_sram_ctrl_main__regs
      ]
      sram_ctrl_main.ram_tl:
      [
        main.tl_sram_ctrl_main__ram
      ]
      sram_ctrl_mbox.regs_tl:
      [
        main.tl_sram_ctrl_mbox__regs
      ]
      sram_ctrl_mbox.ram_tl:
      [
        main.tl_sram_ctrl_mbox__ram
      ]
      dma.tl_d:
      [
        main.tl_dma
      ]
      main.tl_dma__host:
      [
        dma.host_tl_h
      ]
      mbx0.core_tl_d:
      [
        main.tl_mbx0__core
      ]
      main.tl_mbx0__sram:
      [
        mbx0.sram_tl_h
      ]
      mbx1.core_tl_d:
      [
        main.tl_mbx1__core
      ]
      main.tl_mbx1__sram:
      [
        mbx1.sram_tl_h
      ]
      mbx2.core_tl_d:
      [
        main.tl_mbx2__core
      ]
      main.tl_mbx2__sram:
      [
        mbx2.sram_tl_h
      ]
      mbx3.core_tl_d:
      [
        main.tl_mbx3__core
      ]
      main.tl_mbx3__sram:
      [
        mbx3.sram_tl_h
      ]
      mbx4.core_tl_d:
      [
        main.tl_mbx4__core
      ]
      main.tl_mbx4__sram:
      [
        mbx4.sram_tl_h
      ]
      mbx5.core_tl_d:
      [
        main.tl_mbx5__core
      ]
      main.tl_mbx5__sram:
      [
        mbx5.sram_tl_h
      ]
      mbx6.core_tl_d:
      [
        main.tl_mbx6__core
      ]
      main.tl_mbx6__sram:
      [
        mbx6.sram_tl_h
      ]
      mbx_jtag.core_tl_d:
      [
        main.tl_mbx_jtag__core
      ]
      main.tl_mbx_jtag__sram:
      [
        mbx_jtag.sram_tl_h
      ]
      mbx_pcie0.core_tl_d:
      [
        main.tl_mbx_pcie0__core
      ]
      main.tl_mbx_pcie0__sram:
      [
        mbx_pcie0.sram_tl_h
      ]
      mbx_pcie1.core_tl_d:
      [
        main.tl_mbx_pcie1__core
      ]
      main.tl_mbx_pcie1__sram:
      [
        mbx_pcie1.sram_tl_h
      ]
      uart0.tl:
      [
        peri.tl_uart0
      ]
      i2c0.tl:
      [
        peri.tl_i2c0
      ]
      gpio0.tl:
      [
        peri.tl_gpio0
      ]
      spi_host0.tl:
      [
        peri.tl_spi_host0
      ]
      spi_device.tl:
      [
        peri.tl_spi_device
      ]
      rv_timer.tl:
      [
        peri.tl_rv_timer
      ]
      pwrmgr.tl:
      [
        peri.tl_pwrmgr
      ]
      rstmgr.tl:
      [
        peri.tl_rstmgr
      ]
      clkmgr.tl:
      [
        peri.tl_clkmgr
      ]
      pinmux.tl:
      [
        peri.tl_pinmux
      ]
      otp_ctrl.core_tl:
      [
        peri.tl_otp_ctrl__core
      ]
      otp_macro.prim_tl:
      [
        peri.tl_otp_macro__prim
      ]
      lc_ctrl.regs_tl:
      [
        peri.tl_lc_ctrl__regs
      ]
      alert_handler.tl:
      [
        peri.tl_alert_handler
      ]
      sram_ctrl_ret.regs_tl:
      [
        peri.tl_sram_ctrl_ret__regs
      ]
      sram_ctrl_ret.ram_tl:
      [
        peri.tl_sram_ctrl_ret__ram
      ]
      aon_timer.tl:
      [
        peri.tl_aon_timer
      ]
      soc_dbg_ctrl.core_tl:
      [
        peri.tl_soc_dbg_ctrl__core
      ]
      mbx0.soc_tl_d:
      [
        mbx.tl_mbx0__soc
      ]
      mbx1.soc_tl_d:
      [
        mbx.tl_mbx1__soc
      ]
      mbx2.soc_tl_d:
      [
        mbx.tl_mbx2__soc
      ]
      mbx3.soc_tl_d:
      [
        mbx.tl_mbx3__soc
      ]
      mbx4.soc_tl_d:
      [
        mbx.tl_mbx4__soc
      ]
      mbx5.soc_tl_d:
      [
        mbx.tl_mbx5__soc
      ]
      mbx6.soc_tl_d:
      [
        mbx.tl_mbx6__soc
      ]
      mbx_pcie0.soc_tl_d:
      [
        mbx.tl_mbx_pcie0__soc
      ]
      mbx_pcie1.soc_tl_d:
      [
        mbx.tl_mbx_pcie1__soc
      ]
      racl_ctrl.tl:
      [
        mbx.tl_racl_ctrl
      ]
      ac_range_check.tl:
      [
        mbx.tl_ac_range_check
      ]
      rv_dm.dbg_tl_d:
      [
        dbg.tl_rv_dm__dbg
      ]
      mbx_jtag.soc_tl_d:
      [
        dbg.tl_mbx_jtag__soc
      ]
      lc_ctrl.dmi_tl:
      [
        dbg.tl_lc_ctrl__dmi
      ]
      soc_dbg_ctrl.jtag_tl:
      [
        dbg.tl_soc_dbg_ctrl__jtag
      ]
      racl_ctrl.racl_policies:
      [
        mbx0.racl_policies
        mbx1.racl_policies
        mbx2.racl_policies
        mbx3.racl_policies
        mbx4.racl_policies
        mbx5.racl_policies
        mbx6.racl_policies
        mbx_jtag.racl_policies
        mbx_pcie0.racl_policies
        mbx_pcie1.racl_policies
        ac_range_check.racl_policies
      ]
      racl_ctrl.racl_error:
      [
        mbx0.racl_error
        mbx1.racl_error
        mbx2.racl_error
        mbx3.racl_error
        mbx4.racl_error
        mbx5.racl_error
        mbx6.racl_error
        mbx_jtag.racl_error
        mbx_pcie0.racl_error
        mbx_pcie1.racl_error
        ac_range_check.racl_error
      ]
    }
    top:
    [
      clkmgr.clocks
      clkmgr.cg_en
      rstmgr.resets
      rstmgr.rst_en
      rv_core_ibex.irq_timer
      rv_core_ibex.hart_id
      rv_core_ibex.boot_addr
      otp_ctrl.otp_broadcast
      soc_dbg_ctrl.soc_dbg_state
      lc_ctrl.otp_device_id
      lc_ctrl.otp_manuf_state
      keymgr_dpe.device_id
      sram_ctrl_main.otp_en_sram_ifetch
      rv_dm.otp_dis_rv_dm_late_debug
    ]
    external:
    {
      ast.lc_dft_en: ""
      ast.lc_hw_debug_en: ""
      ast.obs_ctrl: obs_ctrl
      otbn.ram_cfg_imem: otbn_imem_ram_cfg
      otbn.ram_cfg_dmem: otbn_dmem_ram_cfg
      i2c0.ram_cfg: i2c0_ram_cfg
      rv_core_ibex.ram_cfg_icache_tag: rv_core_ibex_icache_tag_ram_cfg
      rv_core_ibex.ram_cfg_icache_data: rv_core_ibex_icache_data_ram_cfg
      spi_device.ram_cfg_sys2spi: spi_device_sys2spi_ram_cfg
      spi_device.ram_cfg_spi2sys: spi_device_spi2sys_ram_cfg
      rom_ctrl0.rom_cfg: rom_ctrl0_rom_cfg
      rom_ctrl1.rom_cfg: rom_ctrl1_rom_cfg
      sram_ctrl_main.ram_cfg: sram_ctrl_main_ram_cfg
      sram_ctrl_ret.ram_cfg: sram_ctrl_ret_ram_cfg
      sram_ctrl_mbox.ram_cfg: sram_ctrl_mbox_ram_cfg
      pwrmgr.boot_status: pwrmgr_boot_status_obs
      pwrmgr.ext_rst_ack: pwrmgr_ext_rst_ack
      clkmgr.clocks: ""
      clkmgr.cg_en: ""
      clkmgr.jitter_en: clk_main_jitter_en
      dma.sys: dma_sys
      entropy_src.entropy_src_rng_enable: es_rng_enable
      entropy_src.entropy_src_rng_valid: es_rng_valid
      entropy_src.entropy_src_rng_bits: es_rng_bit
      entropy_src.rng_fips: es_rng_fips
      mbx.tl_mbx: mbx_tl
      mbx0.doe_intr: mbx0_doe_intr
      mbx0.doe_intr_en: mbx0_doe_intr_en
      mbx0.doe_intr_support: mbx0_doe_intr_support
      mbx0.doe_async_msg_support: mbx0_doe_async_msg_support
      mbx1.doe_intr: mbx1_doe_intr
      mbx1.doe_intr_en: mbx1_doe_intr_en
      mbx1.doe_intr_support: mbx1_doe_intr_support
      mbx1.doe_async_msg_support: mbx1_doe_async_msg_support
      mbx2.doe_intr: mbx2_doe_intr
      mbx2.doe_intr_en: mbx2_doe_intr_en
      mbx2.doe_intr_support: mbx2_doe_intr_support
      mbx2.doe_async_msg_support: mbx2_doe_async_msg_support
      mbx3.doe_intr: mbx3_doe_intr
      mbx3.doe_intr_en: mbx3_doe_intr_en
      mbx3.doe_intr_support: mbx3_doe_intr_support
      mbx3.doe_async_msg_support: mbx3_doe_async_msg_support
      mbx4.doe_intr: mbx4_doe_intr
      mbx4.doe_intr_en: mbx4_doe_intr_en
      mbx4.doe_intr_support: mbx4_doe_intr_support
      mbx4.doe_async_msg_support: mbx4_doe_async_msg_support
      mbx5.doe_intr: mbx5_doe_intr
      mbx5.doe_intr_en: mbx5_doe_intr_en
      mbx5.doe_intr_support: mbx5_doe_intr_support
      mbx5.doe_async_msg_support: mbx5_doe_async_msg_support
      mbx6.doe_intr: mbx6_doe_intr
      mbx6.doe_intr_en: mbx6_doe_intr_en
      mbx6.doe_intr_support: mbx6_doe_intr_support
      mbx6.doe_async_msg_support: mbx6_doe_async_msg_support
      mbx_jtag.doe_intr: mbx_jtag_doe_intr
      mbx_jtag.doe_intr_en: mbx_jtag_doe_intr_en
      mbx_jtag.doe_intr_support: mbx_jtag_doe_intr_support
      mbx_jtag.doe_async_msg_support: mbx_jtag_doe_async_msg_support
      mbx_pcie0.doe_intr: mbx_pcie0_doe_intr
      mbx_pcie0.doe_intr_en: mbx_pcie0_doe_intr_en
      mbx_pcie0.doe_intr_support: mbx_pcie0_doe_intr_support
      mbx_pcie0.doe_async_msg_support: mbx_pcie0_doe_async_msg_support
      mbx_pcie1.doe_intr: mbx_pcie1_doe_intr
      mbx_pcie1.doe_intr_en: mbx_pcie1_doe_intr_en
      mbx_pcie1.doe_intr_support: mbx_pcie1_doe_intr_support
      mbx_pcie1.doe_async_msg_support: mbx_pcie1_doe_async_msg_support
      dbg.tl_dbg: dbg_tl
      rv_dm.next_dm_addr: rv_dm_next_dm_addr
      peri.tl_ast: ast_tl
      pwrmgr.pwr_ast: pwrmgr_ast
      otp_macro.pwr_seq: ""
      otp_macro.pwr_seq_h: ""
      otp_macro.ext_voltage_h: otp_ext_voltage_h
      otp_macro.otp_obs: otp_obs
      otp_macro.cfg: otp_cfg
      rstmgr.por_n: por_n
      rstmgr.resets: ""
      rstmgr.rst_en: ""
      soc_proxy.misc_tl_h2d: ctn_misc_tl_h2d
      soc_proxy.misc_tl_d2h: ctn_misc_tl_d2h
      soc_proxy.soc_wkup_async: soc_wkup_async
      soc_proxy.soc_rst_req_async: soc_rst_req_async
      soc_proxy.soc_lsio_trigger: soc_lsio_trigger
      soc_proxy.soc_gpi_async: soc_gpi_async
      soc_proxy.soc_gpo_async: soc_gpo_async
      soc_proxy.integrator_id: integrator_id
      spi_device.sck_monitor: sck_monitor
      soc_dbg_ctrl.soc_dbg_policy_bus: soc_dbg_policy_bus
      soc_dbg_ctrl.halt_cpu_boot: debug_halt_cpu_boot
      racl_ctrl.racl_policies: racl_policies
      racl_ctrl.racl_error_external: racl_error
      ac_range_check.range_check_overwrite: ac_range_check_overwrite
      ac_range_check.ctn_filtered_tl_h2d: ctn_tl_h2d
      ac_range_check.ctn_filtered_tl_d2h: ctn_tl_d2h
    }
  }
  xbar:
  [
    {
      name: main
      clock_srcs:
      {
        clk_main_i: main
        clk_fixed_i: io
      }
      clock_group: infra
      reset: rst_main_ni
      reset_connections:
      {
        rst_main_ni:
        {
          name: lc
          domain: Main
        }
        rst_fixed_ni:
        {
          name: lc_io
          domain: Main
        }
      }
      domain: Main
      clock_connections:
      {
        clk_main_i: clkmgr_clocks_i.clk_main_infra
        clk_fixed_i: clkmgr_clocks_i.clk_io_infra
      }
      connections:
      {
        rv_core_ibex.corei:
        [
          rom_ctrl0.rom
          rom_ctrl1.rom
          rv_dm.mem
          sram_ctrl_main.ram
          soc_proxy.ctn
        ]
        rv_core_ibex.cored:
        [
          rom_ctrl0.rom
          rom_ctrl0.regs
          rom_ctrl1.rom
          rom_ctrl1.regs
          rv_dm.mem
          rv_dm.regs
          sram_ctrl_main.ram
          peri
          aes
          entropy_src
          csrng
          edn0
          edn1
          hmac
          rv_plic
          otbn
          keymgr_dpe
          kmac
          sram_ctrl_main.regs
          rv_core_ibex.cfg
          sram_ctrl_mbox.ram
          sram_ctrl_mbox.regs
          soc_proxy.ctn
          soc_proxy.core
          dma
          mbx0.core
          mbx1.core
          mbx2.core
          mbx3.core
          mbx4.core
          mbx5.core
          mbx6.core
          mbx_jtag.core
          mbx_pcie0.core
          mbx_pcie1.core
        ]
        rv_dm.sba:
        [
          rom_ctrl0.rom
          rom_ctrl0.regs
          rom_ctrl1.rom
          rom_ctrl1.regs
          rv_dm.mem
          rv_dm.regs
          sram_ctrl_main.ram
          peri
          aes
          entropy_src
          csrng
          edn0
          edn1
          hmac
          rv_plic
          otbn
          keymgr_dpe
          kmac
          sram_ctrl_main.regs
          rv_core_ibex.cfg
          sram_ctrl_mbox.ram
          sram_ctrl_mbox.regs
          soc_proxy.ctn
          soc_proxy.core
          dma
          mbx0.core
          mbx1.core
          mbx2.core
          mbx3.core
          mbx4.core
          mbx5.core
          mbx6.core
          mbx_jtag.core
          mbx_pcie0.core
          mbx_pcie1.core
        ]
        dma.host:
        [
          sram_ctrl_main.ram
          sram_ctrl_mbox.ram
          aes
          hmac
          otbn
          keymgr_dpe
          kmac
          soc_proxy.ctn
          peri
        ]
        mbx0.sram:
        [
          sram_ctrl_mbox.ram
        ]
        mbx1.sram:
        [
          sram_ctrl_mbox.ram
        ]
        mbx2.sram:
        [
          sram_ctrl_mbox.ram
        ]
        mbx3.sram:
        [
          sram_ctrl_mbox.ram
        ]
        mbx4.sram:
        [
          sram_ctrl_mbox.ram
        ]
        mbx5.sram:
        [
          sram_ctrl_mbox.ram
        ]
        mbx6.sram:
        [
          sram_ctrl_mbox.ram
        ]
        mbx_jtag.sram:
        [
          sram_ctrl_mbox.ram
        ]
        mbx_pcie0.sram:
        [
          sram_ctrl_mbox.ram
        ]
        mbx_pcie1.sram:
        [
          sram_ctrl_mbox.ram
        ]
      }
      nodes:
      [
        {
          name: rv_core_ibex.corei
          type: host
          addr_space: hart
          clock: clk_main_i
          reset: rst_main_ni
          pipeline: false
          xbar: false
          stub: false
          inst_type: ""
          req_fifo_pass: true
          rsp_fifo_pass: true
        }
        {
          name: rv_core_ibex.cored
          type: host
          addr_space: hart
          clock: clk_main_i
          reset: rst_main_ni
          pipeline: false
          xbar: false
          stub: false
          inst_type: ""
          req_fifo_pass: true
          rsp_fifo_pass: true
        }
        {
          name: rv_dm.sba
          type: host
          addr_space: hart
          clock: clk_main_i
          reset: rst_main_ni
          req_fifo_pass: false
          rsp_fifo_pass: false
          xbar: false
          stub: false
          inst_type: ""
          pipeline: true
        }
        {
          name: rv_dm.regs
          type: device
          clock: clk_main_i
          reset: rst_main_ni
          req_fifo_pass: false
          rsp_fifo_pass: false
          inst_type: rv_dm
          addr_range:
          [
            {
              base_addrs:
              {
                hart: 0x21200000
              }
              size_byte: 0x10
            }
          ]
          xbar: false
          stub: false
          pipeline: true
        }
        {
          name: rv_dm.mem
          type: device
          clock: clk_main_i
          reset: rst_main_ni
          req_fifo_pass: false
          rsp_fifo_pass: false
          inst_type: rv_dm
          addr_range:
          [
            {
              base_addrs:
              {
                hart: 0x40000
              }
              size_byte: 0x1000
            }
          ]
          xbar: false
          stub: false
          pipeline: true
        }
        {
          name: rom_ctrl0.rom
          type: device
          clock: clk_main_i
          reset: rst_main_ni
          req_fifo_pass: true
          rsp_fifo_pass: false
          inst_type: rom_ctrl
          addr_range:
          [
            {
              base_addrs:
              {
                hart: 0x8000
              }
              size_byte: 0x8000
            }
          ]
          xbar: false
          stub: false
          pipeline: true
        }
        {
          name: rom_ctrl0.regs
          type: device
          clock: clk_main_i
          reset: rst_main_ni
          req_fifo_pass: false
          rsp_fifo_pass: false
          inst_type: rom_ctrl
          addr_range:
          [
            {
              base_addrs:
              {
                hart: 0x211e0000
              }
              size_byte: 0x80
            }
          ]
          xbar: false
          stub: false
          pipeline: true
        }
        {
          name: rom_ctrl1.rom
          type: device
          clock: clk_main_i
          reset: rst_main_ni
          req_fifo_pass: true
          rsp_fifo_pass: false
          inst_type: rom_ctrl
          addr_range:
          [
            {
              base_addrs:
              {
                hart: 0x20000
              }
              size_byte: 0x10000
            }
          ]
          xbar: false
          stub: false
          pipeline: true
        }
        {
          name: rom_ctrl1.regs
          type: device
          clock: clk_main_i
          reset: rst_main_ni
          req_fifo_pass: false
          rsp_fifo_pass: false
          inst_type: rom_ctrl
          addr_range:
          [
            {
              base_addrs:
              {
                hart: 0x211e1000
              }
              size_byte: 0x80
            }
          ]
          xbar: false
          stub: false
          pipeline: true
        }
        {
          name: peri
          type: device
          clock: clk_fixed_i
          reset: rst_fixed_ni
          req_fifo_pass: false
          rsp_fifo_pass: false
          xbar: true
          stub: false
          pipeline: true
          addr_space: hart
          addr_range:
          [
            {
              base_addrs:
              {
                hart: 0x30000000
              }
              size_byte: 0x800000
            }
          ]
        }
        {
          name: soc_proxy.core
          type: device
          clock: clk_main_i
          reset: rst_main_ni
          req_fifo_pass: false
          rsp_fifo_pass: false
          inst_type: soc_proxy
          addr_range:
          [
            {
              base_addrs:
              {
                hart: 0x22030000
              }
              size_byte: 0x8
            }
          ]
          xbar: false
          stub: false
          pipeline: true
        }
        {
          name: soc_proxy.ctn
          type: device
          clock: clk_main_i
          reset: rst_main_ni
          pipeline: false
          inst_type: soc_proxy
          addr_range:
          [
            {
              base_addrs:
              {
                hart: 0x40000000
              }
              size_byte: 0x80000000
            }
          ]
          xbar: false
          stub: false
          req_fifo_pass: true
        }
        {
          name: hmac
          type: device
          clock: clk_main_i
          reset: rst_main_ni
          req_fifo_pass: false
          rsp_fifo_pass: false
          inst_type: hmac
          addr_range:
          [
            {
              base_addrs:
              {
                hart: 0x21110000
              }
              size_byte: 0x2000
            }
          ]
          xbar: false
          stub: false
          pipeline: true
        }
        {
          name: kmac
          type: device
          clock: clk_main_i
          reset: rst_main_ni
          req_fifo_pass: false
          rsp_fifo_pass: false
          inst_type: kmac
          addr_range:
          [
            {
              base_addrs:
              {
                hart: 0x21120000
              }
              size_byte: 0x1000
            }
          ]
          xbar: false
          stub: false
          pipeline: true
        }
        {
          name: aes
          type: device
          clock: clk_main_i
          reset: rst_main_ni
          req_fifo_pass: false
          rsp_fifo_pass: false
          inst_type: aes
          addr_range:
          [
            {
              base_addrs:
              {
                hart: 0x21100000
              }
              size_byte: 0x100
            }
          ]
          xbar: false
          stub: false
          pipeline: true
        }
        {
          name: entropy_src
          type: device
          clock: clk_main_i
          reset: rst_main_ni
          req_fifo_pass: false
          rsp_fifo_pass: false
          inst_type: entropy_src
          addr_range:
          [
            {
              base_addrs:
              {
                hart: 0x21160000
              }
              size_byte: 0x100
            }
          ]
          xbar: false
          stub: false
          pipeline: true
        }
        {
          name: csrng
          type: device
          clock: clk_main_i
          reset: rst_main_ni
          req_fifo_pass: false
          rsp_fifo_pass: false
          inst_type: csrng
          addr_range:
          [
            {
              base_addrs:
              {
                hart: 0x21150000
              }
              size_byte: 0x100
            }
          ]
          xbar: false
          stub: false
          pipeline: true
        }
        {
          name: edn0
          type: device
          clock: clk_main_i
          reset: rst_main_ni
          req_fifo_pass: false
          rsp_fifo_pass: false
          inst_type: edn
          addr_range:
          [
            {
              base_addrs:
              {
                hart: 0x21170000
              }
              size_byte: 0x80
            }
          ]
          xbar: false
          stub: false
          pipeline: true
        }
        {
          name: edn1
          type: device
          clock: clk_main_i
          reset: rst_main_ni
          req_fifo_pass: false
          rsp_fifo_pass: false
          inst_type: edn
          addr_range:
          [
            {
              base_addrs:
              {
                hart: 0x21180000
              }
              size_byte: 0x80
            }
          ]
          xbar: false
          stub: false
          pipeline: true
        }
        {
          name: rv_plic
          type: device
          clock: clk_main_i
          reset: rst_main_ni
          inst_type: rv_plic
          req_fifo_pass: false
          rsp_fifo_pass: false
          addr_range:
          [
            {
              base_addrs:
              {
                hart: 0x28000000
              }
              size_byte: 0x8000000
            }
          ]
          xbar: false
          stub: false
          pipeline: true
        }
        {
          name: otbn
          type: device
          clock: clk_main_i
          reset: rst_main_ni
          req_fifo_pass: false
          rsp_fifo_pass: false
          inst_type: otbn
          addr_range:
          [
            {
              base_addrs:
              {
                hart: 0x21130000
              }
              size_byte: 0x10000
            }
          ]
          xbar: false
          stub: false
          pipeline: true
        }
        {
          name: keymgr_dpe
          type: device
          clock: clk_main_i
          reset: rst_main_ni
          req_fifo_pass: false
          rsp_fifo_pass: false
          inst_type: keymgr_dpe
          addr_range:
          [
            {
              base_addrs:
              {
                hart: 0x21140000
              }
              size_byte: 0x200
            }
          ]
          xbar: false
          stub: false
          pipeline: true
        }
        {
          name: rv_core_ibex.cfg
          type: device
          clock: clk_main_i
          reset: rst_main_ni
          req_fifo_pass: false
          rsp_fifo_pass: false
          inst_type: rv_core_ibex
          addr_range:
          [
            {
              base_addrs:
              {
                hart: 0x211f0000
              }
              size_byte: 0x800
            }
          ]
          xbar: false
          stub: false
          pipeline: true
        }
        {
          name: sram_ctrl_main.regs
          type: device
          clock: clk_main_i
          reset: rst_main_ni
          req_fifo_pass: false
          rsp_fifo_pass: false
          inst_type: sram_ctrl
          addr_range:
          [
            {
              base_addrs:
              {
                hart: 0x211c0000
              }
              size_byte: 0x40
            }
          ]
          xbar: false
          stub: false
          pipeline: true
        }
        {
          name: sram_ctrl_main.ram
          type: device
          clock: clk_main_i
          reset: rst_main_ni
          pipeline: false
          inst_type: sram_ctrl
          addr_range:
          [
            {
              base_addrs:
              {
                hart: 0x10000000
              }
              size_byte: 0x10000
            }
          ]
          xbar: false
          stub: false
          req_fifo_pass: true
        }
        {
          name: sram_ctrl_mbox.regs
          type: device
          clock: clk_main_i
          reset: rst_main_ni
          pipeline: false
          inst_type: sram_ctrl
          addr_range:
          [
            {
              base_addrs:
              {
                hart: 0x211d0000
              }
              size_byte: 0x40
            }
          ]
          xbar: false
          stub: false
          req_fifo_pass: true
        }
        {
          name: sram_ctrl_mbox.ram
          type: device
          clock: clk_main_i
          reset: rst_main_ni
          pipeline: false
          inst_type: sram_ctrl
          addr_range:
          [
            {
              base_addrs:
              {
                hart: 0x11000000
              }
              size_byte: 0x1000
            }
          ]
          xbar: false
          stub: false
          req_fifo_pass: true
        }
        {
          name: dma
          type: device
          clock: clk_main_i
          reset: rst_main_ni
          req_fifo_pass: false
          rsp_fifo_pass: false
          inst_type: dma
          addr_range:
          [
            {
              base_addrs:
              {
                hart: 0x22010000
              }
              size_byte: 0x200
            }
          ]
          xbar: false
          stub: false
          pipeline: true
        }
        {
          name: dma.host
          type: host
          addr_space: hart
          clock: clk_main_i
          reset: rst_main_ni
          pipeline: false
          xbar: false
          stub: false
          inst_type: ""
          req_fifo_pass: true
          rsp_fifo_pass: true
        }
        {
          name: mbx0.core
          type: device
          addr_space: hart
          clock: clk_main_i
          reset: rst_main_ni
          pipeline: false
          inst_type: mbx
          addr_range:
          [
            {
              base_addrs:
              {
                hart: 0x22000000
              }
              size_byte: 0x80
            }
          ]
          xbar: false
          stub: false
          req_fifo_pass: true
        }
        {
          name: mbx0.sram
          type: host
          addr_space: hart
          clock: clk_main_i
          reset: rst_main_ni
          pipeline: false
          xbar: false
          stub: false
          inst_type: ""
          req_fifo_pass: true
          rsp_fifo_pass: true
        }
        {
          name: mbx1.core
          type: device
          addr_space: hart
          clock: clk_main_i
          reset: rst_main_ni
          pipeline: false
          inst_type: mbx
          addr_range:
          [
            {
              base_addrs:
              {
                hart: 0x22000100
              }
              size_byte: 0x80
            }
          ]
          xbar: false
          stub: false
          req_fifo_pass: true
        }
        {
          name: mbx1.sram
          type: host
          addr_space: hart
          clock: clk_main_i
          reset: rst_main_ni
          pipeline: false
          xbar: false
          stub: false
          inst_type: ""
          req_fifo_pass: true
          rsp_fifo_pass: true
        }
        {
          name: mbx2.core
          type: device
          addr_space: hart
          clock: clk_main_i
          reset: rst_main_ni
          pipeline: false
          inst_type: mbx
          addr_range:
          [
            {
              base_addrs:
              {
                hart: 0x22000200
              }
              size_byte: 0x80
            }
          ]
          xbar: false
          stub: false
          req_fifo_pass: true
        }
        {
          name: mbx2.sram
          type: host
          addr_space: hart
          clock: clk_main_i
          reset: rst_main_ni
          pipeline: false
          xbar: false
          stub: false
          inst_type: ""
          req_fifo_pass: true
          rsp_fifo_pass: true
        }
        {
          name: mbx3.core
          type: device
          addr_space: hart
          clock: clk_main_i
          reset: rst_main_ni
          pipeline: false
          inst_type: mbx
          addr_range:
          [
            {
              base_addrs:
              {
                hart: 0x22000300
              }
              size_byte: 0x80
            }
          ]
          xbar: false
          stub: false
          req_fifo_pass: true
        }
        {
          name: mbx3.sram
          type: host
          addr_space: hart
          clock: clk_main_i
          reset: rst_main_ni
          pipeline: false
          xbar: false
          stub: false
          inst_type: ""
          req_fifo_pass: true
          rsp_fifo_pass: true
        }
        {
          name: mbx4.core
          type: device
          addr_space: hart
          clock: clk_main_i
          reset: rst_main_ni
          pipeline: false
          inst_type: mbx
          addr_range:
          [
            {
              base_addrs:
              {
                hart: 0x22000400
              }
              size_byte: 0x80
            }
          ]
          xbar: false
          stub: false
          req_fifo_pass: true
        }
        {
          name: mbx4.sram
          type: host
          addr_space: hart
          clock: clk_main_i
          reset: rst_main_ni
          pipeline: false
          xbar: false
          stub: false
          inst_type: ""
          req_fifo_pass: true
          rsp_fifo_pass: true
        }
        {
          name: mbx5.core
          type: device
          addr_space: hart
          clock: clk_main_i
          reset: rst_main_ni
          pipeline: false
          inst_type: mbx
          addr_range:
          [
            {
              base_addrs:
              {
                hart: 0x22000500
              }
              size_byte: 0x80
            }
          ]
          xbar: false
          stub: false
          req_fifo_pass: true
        }
        {
          name: mbx5.sram
          type: host
          addr_space: hart
          clock: clk_main_i
          reset: rst_main_ni
          pipeline: false
          xbar: false
          stub: false
          inst_type: ""
          req_fifo_pass: true
          rsp_fifo_pass: true
        }
        {
          name: mbx6.core
          type: device
          addr_space: hart
          clock: clk_main_i
          reset: rst_main_ni
          pipeline: false
          inst_type: mbx
          addr_range:
          [
            {
              base_addrs:
              {
                hart: 0x22000600
              }
              size_byte: 0x80
            }
          ]
          xbar: false
          stub: false
          req_fifo_pass: true
        }
        {
          name: mbx6.sram
          type: host
          addr_space: hart
          clock: clk_main_i
          reset: rst_main_ni
          pipeline: false
          xbar: false
          stub: false
          inst_type: ""
          req_fifo_pass: true
          rsp_fifo_pass: true
        }
        {
          name: mbx_jtag.core
          type: device
          addr_space: hart
          clock: clk_main_i
          reset: rst_main_ni
          pipeline: false
          inst_type: mbx
          addr_range:
          [
            {
              base_addrs:
              {
                hart: 0x22000800
              }
              size_byte: 0x80
            }
          ]
          xbar: false
          stub: false
          req_fifo_pass: true
        }
        {
          name: mbx_jtag.sram
          type: host
          addr_space: hart
          clock: clk_main_i
          reset: rst_main_ni
          pipeline: false
          xbar: false
          stub: false
          inst_type: ""
          req_fifo_pass: true
          rsp_fifo_pass: true
        }
        {
          name: mbx_pcie0.core
          type: device
          addr_space: hart
          clock: clk_main_i
          reset: rst_main_ni
          pipeline: false
          inst_type: mbx
          addr_range:
          [
            {
              base_addrs:
              {
                hart: 0x22040000
              }
              size_byte: 0x80
            }
          ]
          xbar: false
          stub: false
          req_fifo_pass: true
        }
        {
          name: mbx_pcie0.sram
          type: host
          addr_space: hart
          clock: clk_main_i
          reset: rst_main_ni
          pipeline: false
          xbar: false
          stub: false
          inst_type: ""
          req_fifo_pass: true
          rsp_fifo_pass: true
        }
        {
          name: mbx_pcie1.core
          type: device
          addr_space: hart
          clock: clk_main_i
          reset: rst_main_ni
          pipeline: false
          inst_type: mbx
          addr_range:
          [
            {
              base_addrs:
              {
                hart: 0x22040100
              }
              size_byte: 0x80
            }
          ]
          xbar: false
          stub: false
          req_fifo_pass: true
        }
        {
          name: mbx_pcie1.sram
          type: host
          addr_space: hart
          clock: clk_main_i
          reset: rst_main_ni
          pipeline: false
          xbar: false
          stub: false
          inst_type: ""
          req_fifo_pass: true
          rsp_fifo_pass: true
        }
      ]
      addr_spaces:
      [
        hart
      ]
      clock: clk_main_i
      type: xbar
      inter_signal_list:
      [
        {
          name: tl_rv_core_ibex__corei
          struct: tl
          package: tlul_pkg
          type: req_rsp
          act: rsp
          inst_name: main
          width: 1
          default: ""
          end_idx: -1
          top_type: one-to-one
          top_signame: main_tl_rv_core_ibex__corei
          index: -1
        }
        {
          name: tl_rv_core_ibex__cored
          struct: tl
          package: tlul_pkg
          type: req_rsp
          act: rsp
          inst_name: main
          width: 1
          default: ""
          end_idx: -1
          top_type: one-to-one
          top_signame: main_tl_rv_core_ibex__cored
          index: -1
        }
        {
          name: tl_rv_dm__sba
          struct: tl
          package: tlul_pkg
          type: req_rsp
          act: rsp
          inst_name: main
          width: 1
          default: ""
          end_idx: -1
          top_type: one-to-one
          top_signame: main_tl_rv_dm__sba
          index: -1
        }
        {
          name: tl_dma__host
          struct: tl
          package: tlul_pkg
          type: req_rsp
          act: rsp
          inst_name: main
          width: 1
          default: ""
          end_idx: -1
          top_type: one-to-one
          top_signame: main_tl_dma__host
          index: -1
        }
        {
          name: tl_mbx0__sram
          struct: tl
          package: tlul_pkg
          type: req_rsp
          act: rsp
          inst_name: main
          width: 1
          default: ""
          end_idx: -1
          top_type: one-to-one
          top_signame: main_tl_mbx0__sram
          index: -1
        }
        {
          name: tl_mbx1__sram
          struct: tl
          package: tlul_pkg
          type: req_rsp
          act: rsp
          inst_name: main
          width: 1
          default: ""
          end_idx: -1
          top_type: one-to-one
          top_signame: main_tl_mbx1__sram
          index: -1
        }
        {
          name: tl_mbx2__sram
          struct: tl
          package: tlul_pkg
          type: req_rsp
          act: rsp
          inst_name: main
          width: 1
          default: ""
          end_idx: -1
          top_type: one-to-one
          top_signame: main_tl_mbx2__sram
          index: -1
        }
        {
          name: tl_mbx3__sram
          struct: tl
          package: tlul_pkg
          type: req_rsp
          act: rsp
          inst_name: main
          width: 1
          default: ""
          end_idx: -1
          top_type: one-to-one
          top_signame: main_tl_mbx3__sram
          index: -1
        }
        {
          name: tl_mbx4__sram
          struct: tl
          package: tlul_pkg
          type: req_rsp
          act: rsp
          inst_name: main
          width: 1
          default: ""
          end_idx: -1
          top_type: one-to-one
          top_signame: main_tl_mbx4__sram
          index: -1
        }
        {
          name: tl_mbx5__sram
          struct: tl
          package: tlul_pkg
          type: req_rsp
          act: rsp
          inst_name: main
          width: 1
          default: ""
          end_idx: -1
          top_type: one-to-one
          top_signame: main_tl_mbx5__sram
          index: -1
        }
        {
          name: tl_mbx6__sram
          struct: tl
          package: tlul_pkg
          type: req_rsp
          act: rsp
          inst_name: main
          width: 1
          default: ""
          end_idx: -1
          top_type: one-to-one
          top_signame: main_tl_mbx6__sram
          index: -1
        }
        {
          name: tl_mbx_jtag__sram
          struct: tl
          package: tlul_pkg
          type: req_rsp
          act: rsp
          inst_name: main
          width: 1
          default: ""
          end_idx: -1
          top_type: one-to-one
          top_signame: main_tl_mbx_jtag__sram
          index: -1
        }
        {
          name: tl_mbx_pcie0__sram
          struct: tl
          package: tlul_pkg
          type: req_rsp
          act: rsp
          inst_name: main
          width: 1
          default: ""
          end_idx: -1
          top_type: one-to-one
          top_signame: main_tl_mbx_pcie0__sram
          index: -1
        }
        {
          name: tl_mbx_pcie1__sram
          struct: tl
          package: tlul_pkg
          type: req_rsp
          act: rsp
          inst_name: main
          width: 1
          default: ""
          end_idx: -1
          top_type: one-to-one
          top_signame: main_tl_mbx_pcie1__sram
          index: -1
        }
        {
          name: tl_rv_dm__regs
          struct: tl
          package: tlul_pkg
          type: req_rsp
          act: req
          inst_name: main
          width: 1
          default: ""
          domain: Main
          top_signame: rv_dm_regs_tl_d
          index: -1
        }
        {
          name: tl_rv_dm__mem
          struct: tl
          package: tlul_pkg
          type: req_rsp
          act: req
          inst_name: main
          width: 1
          default: ""
          domain: Main
          top_signame: rv_dm_mem_tl_d
          index: -1
        }
        {
          name: tl_rom_ctrl0__rom
          struct: tl
          package: tlul_pkg
          type: req_rsp
          act: req
          inst_name: main
          width: 1
          default: ""
          domain: Main
          top_signame: rom_ctrl0_rom_tl
          index: -1
        }
        {
          name: tl_rom_ctrl0__regs
          struct: tl
          package: tlul_pkg
          type: req_rsp
          act: req
          inst_name: main
          width: 1
          default: ""
          domain: Main
          top_signame: rom_ctrl0_regs_tl
          index: -1
        }
        {
          name: tl_rom_ctrl1__rom
          struct: tl
          package: tlul_pkg
          type: req_rsp
          act: req
          inst_name: main
          width: 1
          default: ""
          domain: Main
          top_signame: rom_ctrl1_rom_tl
          index: -1
        }
        {
          name: tl_rom_ctrl1__regs
          struct: tl
          package: tlul_pkg
          type: req_rsp
          act: req
          inst_name: main
          width: 1
          default: ""
          domain: Main
          top_signame: rom_ctrl1_regs_tl
          index: -1
        }
        {
          name: tl_peri
          struct: tl
          package: tlul_pkg
          type: req_rsp
          act: req
          inst_name: main
          width: 1
          default: ""
          end_idx: -1
          top_type: one-to-one
          top_signame: main_tl_peri
          index: -1
        }
        {
          name: tl_soc_proxy__core
          struct: tl
          package: tlul_pkg
          type: req_rsp
          act: req
          inst_name: main
          width: 1
          default: ""
          domain: Main
          top_signame: soc_proxy_core_tl
          index: -1
          external: true
          conn_type: false
        }
        {
          name: tl_soc_proxy__ctn
          struct: tl
          package: tlul_pkg
          type: req_rsp
          act: req
          inst_name: main
          width: 1
          default: ""
          domain: Main
          top_signame: soc_proxy_ctn_tl
          index: -1
          external: true
          conn_type: false
        }
        {
          name: tl_hmac
          struct: tl
          package: tlul_pkg
          type: req_rsp
          act: req
          inst_name: main
          width: 1
          default: ""
          domain: Main
          top_signame: hmac_tl
          index: -1
        }
        {
          name: tl_kmac
          struct: tl
          package: tlul_pkg
          type: req_rsp
          act: req
          inst_name: main
          width: 1
          default: ""
          domain: Main
          top_signame: kmac_tl
          index: -1
        }
        {
          name: tl_aes
          struct: tl
          package: tlul_pkg
          type: req_rsp
          act: req
          inst_name: main
          width: 1
          default: ""
          domain: Main
          top_signame: aes_tl
          index: -1
        }
        {
          name: tl_entropy_src
          struct: tl
          package: tlul_pkg
          type: req_rsp
          act: req
          inst_name: main
          width: 1
          default: ""
          domain: Main
          top_signame: entropy_src_tl
          index: -1
        }
        {
          name: tl_csrng
          struct: tl
          package: tlul_pkg
          type: req_rsp
          act: req
          inst_name: main
          width: 1
          default: ""
          domain: Main
          top_signame: csrng_tl
          index: -1
        }
        {
          name: tl_edn0
          struct: tl
          package: tlul_pkg
          type: req_rsp
          act: req
          inst_name: main
          width: 1
          default: ""
          domain: Main
          top_signame: edn0_tl
          index: -1
        }
        {
          name: tl_edn1
          struct: tl
          package: tlul_pkg
          type: req_rsp
          act: req
          inst_name: main
          width: 1
          default: ""
          domain: Main
          top_signame: edn1_tl
          index: -1
        }
        {
          name: tl_rv_plic
          struct: tl
          package: tlul_pkg
          type: req_rsp
          act: req
          inst_name: main
          width: 1
          default: ""
          domain: Main
          top_signame: rv_plic_tl
          index: -1
        }
        {
          name: tl_otbn
          struct: tl
          package: tlul_pkg
          type: req_rsp
          act: req
          inst_name: main
          width: 1
          default: ""
          domain: Main
          top_signame: otbn_tl
          index: -1
        }
        {
          name: tl_keymgr_dpe
          struct: tl
          package: tlul_pkg
          type: req_rsp
          act: req
          inst_name: main
          width: 1
          default: ""
          domain: Main
          top_signame: keymgr_dpe_tl
          index: -1
        }
        {
          name: tl_rv_core_ibex__cfg
          struct: tl
          package: tlul_pkg
          type: req_rsp
          act: req
          inst_name: main
          width: 1
          default: ""
          domain: Main
          top_signame: rv_core_ibex_cfg_tl_d
          index: -1
        }
        {
          name: tl_sram_ctrl_main__regs
          struct: tl
          package: tlul_pkg
          type: req_rsp
          act: req
          inst_name: main
          width: 1
          default: ""
          domain: Main
          top_signame: sram_ctrl_main_regs_tl
          index: -1
        }
        {
          name: tl_sram_ctrl_main__ram
          struct: tl
          package: tlul_pkg
          type: req_rsp
          act: req
          inst_name: main
          width: 1
          default: ""
          domain: Main
          top_signame: sram_ctrl_main_ram_tl
          index: -1
        }
        {
          name: tl_sram_ctrl_mbox__regs
          struct: tl
          package: tlul_pkg
          type: req_rsp
          act: req
          inst_name: main
          width: 1
          default: ""
          domain: Main
          top_signame: sram_ctrl_mbox_regs_tl
          index: -1
        }
        {
          name: tl_sram_ctrl_mbox__ram
          struct: tl
          package: tlul_pkg
          type: req_rsp
          act: req
          inst_name: main
          width: 1
          default: ""
          domain: Main
          top_signame: sram_ctrl_mbox_ram_tl
          index: -1
        }
        {
          name: tl_dma
          struct: tl
          package: tlul_pkg
          type: req_rsp
          act: req
          inst_name: main
          width: 1
          default: ""
          domain: Main
          top_signame: dma_tl_d
          index: -1
        }
        {
          name: tl_mbx0__core
          struct: tl
          package: tlul_pkg
          type: req_rsp
          act: req
          inst_name: main
          width: 1
          default: ""
          domain: Main
          top_signame: mbx0_core_tl_d
          index: -1
        }
        {
          name: tl_mbx1__core
          struct: tl
          package: tlul_pkg
          type: req_rsp
          act: req
          inst_name: main
          width: 1
          default: ""
          domain: Main
          top_signame: mbx1_core_tl_d
          index: -1
        }
        {
          name: tl_mbx2__core
          struct: tl
          package: tlul_pkg
          type: req_rsp
          act: req
          inst_name: main
          width: 1
          default: ""
          domain: Main
          top_signame: mbx2_core_tl_d
          index: -1
        }
        {
          name: tl_mbx3__core
          struct: tl
          package: tlul_pkg
          type: req_rsp
          act: req
          inst_name: main
          width: 1
          default: ""
          domain: Main
          top_signame: mbx3_core_tl_d
          index: -1
        }
        {
          name: tl_mbx4__core
          struct: tl
          package: tlul_pkg
          type: req_rsp
          act: req
          inst_name: main
          width: 1
          default: ""
          domain: Main
          top_signame: mbx4_core_tl_d
          index: -1
        }
        {
          name: tl_mbx5__core
          struct: tl
          package: tlul_pkg
          type: req_rsp
          act: req
          inst_name: main
          width: 1
          default: ""
          domain: Main
          top_signame: mbx5_core_tl_d
          index: -1
        }
        {
          name: tl_mbx6__core
          struct: tl
          package: tlul_pkg
          type: req_rsp
          act: req
          inst_name: main
          width: 1
          default: ""
          domain: Main
          top_signame: mbx6_core_tl_d
          index: -1
        }
        {
          name: tl_mbx_jtag__core
          struct: tl
          package: tlul_pkg
          type: req_rsp
          act: req
          inst_name: main
          width: 1
          default: ""
          domain: Main
          top_signame: mbx_jtag_core_tl_d
          index: -1
        }
        {
          name: tl_mbx_pcie0__core
          struct: tl
          package: tlul_pkg
          type: req_rsp
          act: req
          inst_name: main
          width: 1
          default: ""
          domain: Main
          top_signame: mbx_pcie0_core_tl_d
          index: -1
        }
        {
          name: tl_mbx_pcie1__core
          struct: tl
          package: tlul_pkg
          type: req_rsp
          act: req
          inst_name: main
          width: 1
          default: ""
          domain: Main
          top_signame: mbx_pcie1_core_tl_d
          index: -1
        }
      ]
    }
    {
      name: peri
      clock_srcs:
      {
        clk_peri_i: io
      }
      clock_group: infra
      reset: rst_peri_ni
      reset_connections:
      {
        rst_peri_ni:
        {
          name: lc_io
          domain: Main
        }
      }
      domain: Main
      clock_connections:
      {
        clk_peri_i: clkmgr_clocks_i.clk_io_infra
      }
      connections:
      {
        main:
        [
          uart0
          i2c0
          gpio0
          spi_host0
          spi_device
          rv_timer
          pwrmgr
          rstmgr
          clkmgr
          pinmux
          otp_ctrl.core
          otp_macro.prim
          lc_ctrl.regs
          alert_handler
          ast
          sram_ctrl_ret.ram
          sram_ctrl_ret.regs
          aon_timer
          soc_dbg_ctrl.core
        ]
      }
      nodes:
      [
        {
          name: main
          type: host
          addr_space: hart
          clock: clk_peri_i
          reset: rst_peri_ni
          xbar: true
          pipeline: false
          stub: false
          inst_type: ""
          req_fifo_pass: true
          rsp_fifo_pass: true
        }
        {
          name: uart0
          type: device
          clock: clk_peri_i
          reset: rst_peri_ni
          pipeline: false
          inst_type: uart
          addr_range:
          [
            {
              base_addrs:
              {
                hart: 0x30010000
              }
              size_byte: 0x40
            }
          ]
          xbar: false
          stub: false
          req_fifo_pass: true
        }
        {
          name: i2c0
          type: device
          clock: clk_peri_i
          reset: rst_peri_ni
          pipeline: false
          inst_type: i2c
          addr_range:
          [
            {
              base_addrs:
              {
                hart: 0x30080000
              }
              size_byte: 0x80
            }
          ]
          xbar: false
          stub: false
          req_fifo_pass: true
        }
        {
          name: gpio0
          type: device
          clock: clk_peri_i
          reset: rst_peri_ni
          pipeline: false
          inst_type: gpio
          addr_range:
          [
            {
              base_addrs:
              {
                hart: 0x30000000
              }
              size_byte: 0x100
            }
          ]
          xbar: false
          stub: false
          req_fifo_pass: true
        }
        {
          name: spi_host0
          type: device
          clock: clk_peri_i
          reset: rst_peri_ni
          pipeline: false
          inst_type: spi_host
          addr_range:
          [
            {
              base_addrs:
              {
                hart: 0x30300000
              }
              size_byte: 0x40
            }
          ]
          xbar: false
          stub: false
          req_fifo_pass: true
        }
        {
          name: spi_device
          type: device
          clock: clk_peri_i
          reset: rst_peri_ni
          pipeline: false
          inst_type: spi_device
          addr_range:
          [
            {
              base_addrs:
              {
                hart: 0x30310000
              }
              size_byte: 0x2000
            }
          ]
          xbar: false
          stub: false
          req_fifo_pass: true
        }
        {
          name: rv_timer
          type: device
          clock: clk_peri_i
          reset: rst_peri_ni
          pipeline: false
          inst_type: rv_timer
          addr_range:
          [
            {
              base_addrs:
              {
                hart: 0x30100000
              }
              size_byte: 0x200
            }
          ]
          xbar: false
          stub: false
          req_fifo_pass: true
        }
        {
          name: pwrmgr
          type: device
          clock: clk_peri_i
          reset: rst_peri_ni
          pipeline: false
          inst_type: pwrmgr
          addr_range:
          [
            {
              base_addrs:
              {
                hart: 0x30400000
              }
              size_byte: 0x80
            }
          ]
          xbar: false
          stub: false
          req_fifo_pass: true
        }
        {
          name: rstmgr
          type: device
          clock: clk_peri_i
          reset: rst_peri_ni
          pipeline: false
          inst_type: rstmgr
          addr_range:
          [
            {
              base_addrs:
              {
                hart: 0x30410000
              }
              size_byte: 0x80
            }
          ]
          xbar: false
          stub: false
          req_fifo_pass: true
        }
        {
          name: clkmgr
          type: device
          clock: clk_peri_i
          reset: rst_peri_ni
          pipeline: false
          inst_type: clkmgr
          addr_range:
          [
            {
              base_addrs:
              {
                hart: 0x30420000
              }
              size_byte: 0x40
            }
          ]
          xbar: false
          stub: false
          req_fifo_pass: true
        }
        {
          name: pinmux
          type: device
          clock: clk_peri_i
          reset: rst_peri_ni
          pipeline: false
          inst_type: pinmux
          addr_range:
          [
            {
              base_addrs:
              {
                hart: 0x30460000
              }
              size_byte: 0x800
            }
          ]
          xbar: false
          stub: false
          req_fifo_pass: true
        }
        {
          name: otp_ctrl.core
          type: device
          clock: clk_peri_i
          reset: rst_peri_ni
          pipeline: false
          inst_type: otp_ctrl
          addr_range:
          [
            {
              base_addrs:
              {
                hart: 0x30130000
              }
              size_byte: 0x8000
            }
          ]
          xbar: false
          stub: false
          req_fifo_pass: true
        }
        {
          name: otp_macro.prim
          type: device
          clock: clk_peri_i
          reset: rst_peri_ni
          pipeline: false
          inst_type: otp_macro
          addr_range:
          [
            {
              base_addrs:
              {
                hart: 0x30140000
              }
              size_byte: 0x20
            }
          ]
          xbar: false
          stub: false
          req_fifo_pass: true
        }
        {
          name: lc_ctrl.regs
          type: device
          clock: clk_peri_i
          reset: rst_peri_ni
          pipeline: false
          inst_type: lc_ctrl
          addr_range:
          [
            {
              base_addrs:
              {
                hart: 0x30150000
              }
              size_byte: 0x100
            }
          ]
          xbar: false
          stub: false
          req_fifo_pass: true
        }
        {
          name: alert_handler
          type: device
          clock: clk_peri_i
          reset: rst_peri_ni
          pipeline: false
          inst_type: alert_handler
          addr_range:
          [
            {
              base_addrs:
              {
                hart: 0x30160000
              }
              size_byte: 0x800
            }
          ]
          xbar: false
          stub: false
          req_fifo_pass: true
        }
        {
          name: sram_ctrl_ret.regs
          type: device
          clock: clk_peri_i
          reset: rst_peri_ni
          pipeline: false
          inst_type: sram_ctrl
          addr_range:
          [
            {
              base_addrs:
              {
                hart: 0x30500000
              }
              size_byte: 0x40
            }
          ]
          xbar: false
          stub: false
          req_fifo_pass: true
        }
        {
          name: sram_ctrl_ret.ram
          type: device
          clock: clk_peri_i
          reset: rst_peri_ni
          pipeline: false
          inst_type: sram_ctrl
          addr_range:
          [
            {
              base_addrs:
              {
                hart: 0x30600000
              }
              size_byte: 0x1000
            }
          ]
          xbar: false
          stub: false
          req_fifo_pass: true
        }
        {
          name: aon_timer
          type: device
          clock: clk_peri_i
          reset: rst_peri_ni
          pipeline: false
          inst_type: aon_timer
          addr_range:
          [
            {
              base_addrs:
              {
                hart: 0x30470000
              }
              size_byte: 0x40
            }
          ]
          xbar: false
          stub: false
          req_fifo_pass: true
        }
        {
          name: ast
          type: device
          clock: clk_peri_i
          reset: rst_peri_ni
          pipeline: false
          inst_type: ast
          addr_range:
          [
            {
              base_addrs:
              {
                hart: 0x30480000
              }
              size_byte: 0x400
            }
          ]
          xbar: false
          stub: true
          req_fifo_pass: true
        }
        {
          name: soc_dbg_ctrl.core
          type: device
          clock: clk_peri_i
          reset: rst_peri_ni
          pipeline: false
          inst_type: soc_dbg_ctrl
          addr_range:
          [
            {
              base_addrs:
              {
                hart: 0x30170000
              }
              size_byte: 0x20
            }
          ]
          xbar: false
          stub: false
          req_fifo_pass: true
        }
      ]
      addr_spaces:
      [
        hart
      ]
      clock: clk_peri_i
      type: xbar
      inter_signal_list:
      [
        {
          name: tl_main
          struct: tl
          package: tlul_pkg
          type: req_rsp
          act: rsp
          inst_name: peri
          width: 1
          default: ""
          domain: Main
          top_signame: main_tl_peri
          index: -1
        }
        {
          name: tl_uart0
          struct: tl
          package: tlul_pkg
          type: req_rsp
          act: req
          inst_name: peri
          width: 1
          default: ""
          domain: Main
          top_signame: uart0_tl
          index: -1
        }
        {
          name: tl_i2c0
          struct: tl
          package: tlul_pkg
          type: req_rsp
          act: req
          inst_name: peri
          width: 1
          default: ""
          domain: Main
          top_signame: i2c0_tl
          index: -1
        }
        {
          name: tl_gpio0
          struct: tl
          package: tlul_pkg
          type: req_rsp
          act: req
          inst_name: peri
          width: 1
          default: ""
          domain: Main
          top_signame: gpio0_tl
          index: -1
        }
        {
          name: tl_spi_host0
          struct: tl
          package: tlul_pkg
          type: req_rsp
          act: req
          inst_name: peri
          width: 1
          default: ""
          domain: Main
          top_signame: spi_host0_tl
          index: -1
        }
        {
          name: tl_spi_device
          struct: tl
          package: tlul_pkg
          type: req_rsp
          act: req
          inst_name: peri
          width: 1
          default: ""
          domain: Main
          top_signame: spi_device_tl
          index: -1
        }
        {
          name: tl_rv_timer
          struct: tl
          package: tlul_pkg
          type: req_rsp
          act: req
          inst_name: peri
          width: 1
          default: ""
          domain: Main
          top_signame: rv_timer_tl
          index: -1
        }
        {
          name: tl_pwrmgr
          struct: tl
          package: tlul_pkg
          type: req_rsp
          act: req
          inst_name: peri
          width: 1
          default: ""
          domain: Main
          top_signame: pwrmgr_tl
          index: -1
          external: true
          conn_type: false
        }
        {
          name: tl_rstmgr
          struct: tl
          package: tlul_pkg
          type: req_rsp
          act: req
          inst_name: peri
          width: 1
          default: ""
          domain: Main
          top_signame: rstmgr_tl
          index: -1
          external: true
          conn_type: false
        }
        {
          name: tl_clkmgr
          struct: tl
          package: tlul_pkg
          type: req_rsp
          act: req
          inst_name: peri
          width: 1
          default: ""
          domain: Main
          top_signame: clkmgr_tl
          index: -1
          external: true
          conn_type: false
        }
        {
          name: tl_pinmux
          struct: tl
          package: tlul_pkg
          type: req_rsp
          act: req
          inst_name: peri
          width: 1
          default: ""
          domain: Main
          top_signame: pinmux_tl
          index: -1
        }
        {
          name: tl_otp_ctrl__core
          struct: tl
          package: tlul_pkg
          type: req_rsp
          act: req
          inst_name: peri
          width: 1
          default: ""
          domain: Main
          top_signame: otp_ctrl_core_tl
          index: -1
        }
        {
          name: tl_otp_macro__prim
          struct: tl
          package: tlul_pkg
          type: req_rsp
          act: req
          inst_name: peri
          width: 1
          default: ""
          domain: Main
          top_signame: otp_macro_prim_tl
          index: -1
        }
        {
          name: tl_lc_ctrl__regs
          struct: tl
          package: tlul_pkg
          type: req_rsp
          act: req
          inst_name: peri
          width: 1
          default: ""
          domain: Main
          top_signame: lc_ctrl_regs_tl
          index: -1
        }
        {
          name: tl_alert_handler
          struct: tl
          package: tlul_pkg
          type: req_rsp
          act: req
          inst_name: peri
          width: 1
          default: ""
          domain: Main
          top_signame: alert_handler_tl
          index: -1
        }
        {
          name: tl_sram_ctrl_ret__regs
          struct: tl
          package: tlul_pkg
          type: req_rsp
          act: req
          inst_name: peri
          width: 1
          default: ""
          domain: Main
          top_signame: sram_ctrl_ret_regs_tl
          index: -1
          external: true
          conn_type: false
        }
        {
          name: tl_sram_ctrl_ret__ram
          struct: tl
          package: tlul_pkg
          type: req_rsp
          act: req
          inst_name: peri
          width: 1
          default: ""
          domain: Main
          top_signame: sram_ctrl_ret_ram_tl
          index: -1
          external: true
          conn_type: false
        }
        {
          name: tl_aon_timer
          struct: tl
          package: tlul_pkg
          type: req_rsp
          act: req
          inst_name: peri
          width: 1
          default: ""
          domain: Main
          top_signame: aon_timer_tl
          index: -1
          external: true
          conn_type: false
        }
        {
          name: tl_ast
          struct: tl
          package: tlul_pkg
          type: req_rsp
          act: req
          inst_name: peri
          width: 1
          default: ""
          external: true
          conn_type: false
          index: -1
          top_signame: ast_tl
        }
        {
          name: tl_soc_dbg_ctrl__core
          struct: tl
          package: tlul_pkg
          type: req_rsp
          act: req
          inst_name: peri
          width: 1
          default: ""
          domain: Main
          top_signame: soc_dbg_ctrl_core_tl
          index: -1
        }
      ]
    }
    {
      name: mbx
      clock_srcs:
      {
        clk_mbx_i: main
      }
      clock_group: infra
      reset: rst_mbx_ni
      reset_connections:
      {
        rst_mbx_ni:
        {
          name: lc
          domain: Main
        }
      }
      domain: Main
      clock_connections:
      {
        clk_mbx_i: clkmgr_clocks_i.clk_main_infra
      }
      connections:
      {
        mbx:
        [
          mbx0.soc
          mbx1.soc
          mbx2.soc
          mbx3.soc
          mbx4.soc
          mbx5.soc
          mbx6.soc
          mbx_pcie0.soc
          mbx_pcie1.soc
          racl_ctrl
          ac_range_check
        ]
      }
      nodes:
      [
        {
          name: mbx
          type: host
          addr_space: soc_mbx
          clock: clk_mbx_i
          reset: rst_mbx_ni
          xbar: true
          pipeline: false
          stub: false
          inst_type: ""
          req_fifo_pass: true
          rsp_fifo_pass: true
        }
        {
          name: mbx0.soc
          type: device
          addr_space: soc_mbx
          clock: clk_mbx_i
          reset: rst_mbx_ni
          pipeline: false
          inst_type: mbx
          addr_range:
          [
            {
              base_addrs:
              {
                soc_mbx: 0x1465000
              }
              size_byte: 0x20
            }
          ]
          xbar: false
          stub: false
          req_fifo_pass: true
        }
        {
          name: mbx1.soc
          type: device
          addr_space: soc_mbx
          clock: clk_mbx_i
          reset: rst_mbx_ni
          pipeline: false
          inst_type: mbx
          addr_range:
          [
            {
              base_addrs:
              {
                soc_mbx: 0x1465100
              }
              size_byte: 0x20
            }
          ]
          xbar: false
          stub: false
          req_fifo_pass: true
        }
        {
          name: mbx2.soc
          type: device
          addr_space: soc_mbx
          clock: clk_mbx_i
          reset: rst_mbx_ni
          pipeline: false
          inst_type: mbx
          addr_range:
          [
            {
              base_addrs:
              {
                soc_mbx: 0x1465200
              }
              size_byte: 0x20
            }
          ]
          xbar: false
          stub: false
          req_fifo_pass: true
        }
        {
          name: mbx3.soc
          type: device
          addr_space: soc_mbx
          clock: clk_mbx_i
          reset: rst_mbx_ni
          pipeline: false
          inst_type: mbx
          addr_range:
          [
            {
              base_addrs:
              {
                soc_mbx: 0x1465300
              }
              size_byte: 0x20
            }
          ]
          xbar: false
          stub: false
          req_fifo_pass: true
        }
        {
          name: mbx4.soc
          type: device
          addr_space: soc_mbx
          clock: clk_mbx_i
          reset: rst_mbx_ni
          pipeline: false
          inst_type: mbx
          addr_range:
          [
            {
              base_addrs:
              {
                soc_mbx: 0x1465400
              }
              size_byte: 0x20
            }
          ]
          xbar: false
          stub: false
          req_fifo_pass: true
        }
        {
          name: mbx5.soc
          type: device
          addr_space: soc_mbx
          clock: clk_mbx_i
          reset: rst_mbx_ni
          pipeline: false
          inst_type: mbx
          addr_range:
          [
            {
              base_addrs:
              {
                soc_mbx: 0x1465500
              }
              size_byte: 0x20
            }
          ]
          xbar: false
          stub: false
          req_fifo_pass: true
        }
        {
          name: mbx6.soc
          type: device
          addr_space: soc_mbx
          clock: clk_mbx_i
          reset: rst_mbx_ni
          pipeline: false
          inst_type: mbx
          addr_range:
          [
            {
              base_addrs:
              {
                soc_mbx: 0x1496000
              }
              size_byte: 0x20
            }
          ]
          xbar: false
          stub: false
          req_fifo_pass: true
        }
        {
          name: mbx_pcie0.soc
          type: device
          addr_space: soc_mbx
          clock: clk_mbx_i
          reset: rst_mbx_ni
          pipeline: false
          inst_type: mbx
          addr_range:
          [
            {
              base_addrs:
              {
                soc_mbx: 0x1460100
              }
              size_byte: 0x20
            }
          ]
          xbar: false
          stub: false
          req_fifo_pass: true
        }
        {
          name: mbx_pcie1.soc
          type: device
          addr_space: soc_mbx
          clock: clk_mbx_i
          reset: rst_mbx_ni
          pipeline: false
          inst_type: mbx
          addr_range:
          [
            {
              base_addrs:
              {
                soc_mbx: 0x1460200
              }
              size_byte: 0x20
            }
          ]
          xbar: false
          stub: false
          req_fifo_pass: true
        }
        {
          name: racl_ctrl
          type: device
          addr_space: soc_mbx
          clock: clk_mbx_i
          reset: rst_mbx_ni
          pipeline: false
          inst_type: racl_ctrl
          addr_range:
          [
            {
              base_addrs:
              {
                soc_mbx: 0x1461f00
              }
              size_byte: 0x100
            }
          ]
          xbar: false
          stub: false
          req_fifo_pass: true
        }
        {
          name: ac_range_check
          type: device
          addr_space: soc_mbx
          clock: clk_mbx_i
          reset: rst_mbx_ni
          pipeline: false
          inst_type: ac_range_check
          addr_range:
          [
            {
              base_addrs:
              {
                soc_mbx: 0x1464000
              }
              size_byte: 0x400
            }
          ]
          xbar: false
          stub: false
          req_fifo_pass: true
        }
      ]
      addr_spaces:
      [
        soc_mbx
      ]
      clock: clk_mbx_i
      type: xbar
      inter_signal_list:
      [
        {
          name: tl_mbx
          struct: tl
          package: tlul_pkg
          type: req_rsp
          act: rsp
          inst_name: mbx
          width: 1
          default: ""
          external: true
          conn_type: false
          index: -1
          top_signame: mbx_tl
        }
        {
          name: tl_mbx0__soc
          struct: tl
          package: tlul_pkg
          type: req_rsp
          act: req
          inst_name: mbx
          width: 1
          default: ""
          domain: Main
          top_signame: mbx0_soc_tl_d
          index: -1
        }
        {
          name: tl_mbx1__soc
          struct: tl
          package: tlul_pkg
          type: req_rsp
          act: req
          inst_name: mbx
          width: 1
          default: ""
          domain: Main
          top_signame: mbx1_soc_tl_d
          index: -1
        }
        {
          name: tl_mbx2__soc
          struct: tl
          package: tlul_pkg
          type: req_rsp
          act: req
          inst_name: mbx
          width: 1
          default: ""
          domain: Main
          top_signame: mbx2_soc_tl_d
          index: -1
        }
        {
          name: tl_mbx3__soc
          struct: tl
          package: tlul_pkg
          type: req_rsp
          act: req
          inst_name: mbx
          width: 1
          default: ""
          domain: Main
          top_signame: mbx3_soc_tl_d
          index: -1
        }
        {
          name: tl_mbx4__soc
          struct: tl
          package: tlul_pkg
          type: req_rsp
          act: req
          inst_name: mbx
          width: 1
          default: ""
          domain: Main
          top_signame: mbx4_soc_tl_d
          index: -1
        }
        {
          name: tl_mbx5__soc
          struct: tl
          package: tlul_pkg
          type: req_rsp
          act: req
          inst_name: mbx
          width: 1
          default: ""
          domain: Main
          top_signame: mbx5_soc_tl_d
          index: -1
        }
        {
          name: tl_mbx6__soc
          struct: tl
          package: tlul_pkg
          type: req_rsp
          act: req
          inst_name: mbx
          width: 1
          default: ""
          domain: Main
          top_signame: mbx6_soc_tl_d
          index: -1
        }
        {
          name: tl_mbx_pcie0__soc
          struct: tl
          package: tlul_pkg
          type: req_rsp
          act: req
          inst_name: mbx
          width: 1
          default: ""
          domain: Main
          top_signame: mbx_pcie0_soc_tl_d
          index: -1
        }
        {
          name: tl_mbx_pcie1__soc
          struct: tl
          package: tlul_pkg
          type: req_rsp
          act: req
          inst_name: mbx
          width: 1
          default: ""
          domain: Main
          top_signame: mbx_pcie1_soc_tl_d
          index: -1
        }
        {
          name: tl_racl_ctrl
          struct: tl
          package: tlul_pkg
          type: req_rsp
          act: req
          inst_name: mbx
          width: 1
          default: ""
          domain: Main
          top_signame: racl_ctrl_tl
          index: -1
        }
        {
          name: tl_ac_range_check
          struct: tl
          package: tlul_pkg
          type: req_rsp
          act: req
          inst_name: mbx
          width: 1
          default: ""
          domain: Main
          top_signame: ac_range_check_tl
          index: -1
        }
      ]
    }
    {
      name: dbg
      clock_srcs:
      {
        clk_dbg_i: main
        clk_peri_i: io
      }
      clock_group: infra
      reset: rst_dbg_ni
      reset_connections:
      {
        rst_dbg_ni:
        {
          name: lc
          domain: Main
        }
        rst_peri_ni:
        {
          name: lc_io
          domain: Main
        }
      }
      domain: Main
      clock_connections:
      {
        clk_dbg_i: clkmgr_clocks_i.clk_main_infra
        clk_peri_i: clkmgr_clocks_i.clk_io_infra
      }
      connections:
      {
        dbg:
        [
          rv_dm.dbg
          mbx_jtag.soc
          lc_ctrl.dmi
          soc_dbg_ctrl.jtag
        ]
      }
      nodes:
      [
        {
          name: dbg
          type: host
          addr_space: soc_dbg
          clock: clk_dbg_i
          reset: rst_dbg_ni
          xbar: true
          pipeline: false
          stub: false
          inst_type: ""
          req_fifo_pass: true
          rsp_fifo_pass: true
        }
        {
          name: rv_dm.dbg
          type: device
          clock: clk_dbg_i
          reset: rst_dbg_ni
          pipeline: false
          inst_type: rv_dm
          addr_range:
          [
            {
              base_addrs:
              {
                soc_dbg: 0x0
              }
              size_byte: 0x200
            }
          ]
          xbar: false
          stub: false
          req_fifo_pass: true
        }
        {
          name: mbx_jtag.soc
          type: device
          clock: clk_dbg_i
          reset: rst_dbg_ni
          pipeline: false
          inst_type: mbx
          addr_range:
          [
            {
              base_addrs:
              {
                soc_dbg: 0x2200
              }
              size_byte: 0x20
            }
          ]
          xbar: false
          stub: false
          req_fifo_pass: true
        }
        {
          name: lc_ctrl.dmi
          type: device
          clock: clk_peri_i
          reset: rst_peri_ni
          pipeline: false
          inst_type: lc_ctrl
          addr_range:
          [
            {
              base_addrs:
              {
                soc_dbg: 0x3000
              }
              size_byte: 0x1000
            }
          ]
          xbar: false
          stub: false
          req_fifo_pass: true
        }
        {
          name: soc_dbg_ctrl.jtag
          type: device
          clock: clk_peri_i
          reset: rst_peri_ni
          pipeline: false
          inst_type: soc_dbg_ctrl
          addr_range:
          [
            {
              base_addrs:
              {
                soc_dbg: 0x2300
              }
              size_byte: 0x20
            }
          ]
          xbar: false
          stub: false
          req_fifo_pass: true
        }
      ]
      addr_spaces:
      [
        soc_dbg
      ]
      clock: clk_dbg_i
      type: xbar
      inter_signal_list:
      [
        {
          name: tl_dbg
          struct: tl
          package: tlul_pkg
          type: req_rsp
          act: rsp
          inst_name: dbg
          width: 1
          default: ""
          external: true
          conn_type: false
          index: -1
          top_signame: dbg_tl
        }
        {
          name: tl_rv_dm__dbg
          struct: tl
          package: tlul_pkg
          type: req_rsp
          act: req
          inst_name: dbg
          width: 1
          default: ""
          domain: Main
          top_signame: rv_dm_dbg_tl_d
          index: -1
        }
        {
          name: tl_mbx_jtag__soc
          struct: tl
          package: tlul_pkg
          type: req_rsp
          act: req
          inst_name: dbg
          width: 1
          default: ""
          domain: Main
          top_signame: mbx_jtag_soc_tl_d
          index: -1
        }
        {
          name: tl_lc_ctrl__dmi
          struct: tl
          package: tlul_pkg
          type: req_rsp
          act: req
          inst_name: dbg
          width: 1
          default: ""
          domain: Main
          top_signame: lc_ctrl_dmi_tl
          index: -1
        }
        {
          name: tl_soc_dbg_ctrl__jtag
          struct: tl
          package: tlul_pkg
          type: req_rsp
          act: req
          inst_name: dbg
          width: 1
          default: ""
          domain: Main
          top_signame: soc_dbg_ctrl_jtag_tl
          index: -1
        }
      ]
    }
  ]
  pinout:
  {
    banks:
    [
      VIO
    ]
    pads:
    [
      {
        name: POR_N
        type: InputStd
        bank: VIO
        connection: manual
        desc: System reset
        idx: 0
        port_type: inout
      }
      {
        name: JTAG_TCK
        type: InputStd
        bank: VIO
        connection: manual
        desc: JTAG TCK signal
        idx: 1
        port_type: inout
      }
      {
        name: JTAG_TMS
        type: InputStd
        bank: VIO
        connection: manual
        desc: JTAG TMS signal
        idx: 2
        port_type: inout
      }
      {
        name: JTAG_TDI
        type: InputStd
        bank: VIO
        connection: manual
        desc: JTAG TDI signal
        idx: 3
        port_type: inout
      }
      {
        name: JTAG_TDO
        type: BidirStd
        bank: VIO
        connection: manual
        desc: JTAG TDO signal
        idx: 4
        port_type: inout
      }
      {
        name: JTAG_TRST_N
        type: InputStd
        bank: VIO
        connection: manual
        desc: JTAG TRST_N signal
        idx: 5
        port_type: inout
      }
      {
        name: OTP_EXT_VOLT
        type: AnalogIn1
        bank: VIO
        connection: manual
        desc: OTP external voltage input
        idx: 6
        port_type: inout
      }
      {
        name: SPI_HOST_D0
        type: BidirStd
        bank: VIO
        connection: direct
        desc: SPI host data
        idx: 7
        port_type: inout
      }
      {
        name: SPI_HOST_D1
        type: BidirStd
        bank: VIO
        connection: direct
        desc: SPI host data
        idx: 8
        port_type: inout
      }
      {
        name: SPI_HOST_D2
        type: BidirStd
        bank: VIO
        connection: direct
        desc: SPI host data
        idx: 9
        port_type: inout
      }
      {
        name: SPI_HOST_D3
        type: BidirStd
        bank: VIO
        connection: direct
        desc: SPI host data
        idx: 10
        port_type: inout
      }
      {
        name: SPI_HOST_CLK
        type: BidirStd
        bank: VIO
        connection: direct
        desc: SPI host clock
        idx: 11
        port_type: inout
      }
      {
        name: SPI_HOST_CS_L
        type: BidirStd
        bank: VIO
        connection: direct
        desc: SPI host chip select
        idx: 12
        port_type: inout
      }
      {
        name: SPI_DEV_D0
        type: BidirStd
        bank: VIO
        connection: direct
        desc: SPI device data
        idx: 13
        port_type: inout
      }
      {
        name: SPI_DEV_D1
        type: BidirStd
        bank: VIO
        connection: direct
        desc: SPI device data
        idx: 14
        port_type: inout
      }
      {
        name: SPI_DEV_D2
        type: BidirStd
        bank: VIO
        connection: direct
        desc: SPI device data
        idx: 15
        port_type: inout
      }
      {
        name: SPI_DEV_D3
        type: BidirStd
        bank: VIO
        connection: direct
        desc: SPI device data
        idx: 16
        port_type: inout
      }
      {
        name: SPI_DEV_CLK
        type: InputStd
        bank: VIO
        connection: direct
        desc: SPI device clock
        idx: 17
        port_type: inout
      }
      {
        name: SPI_DEV_CS_L
        type: InputStd
        bank: VIO
        connection: direct
        desc: SPI device chip select
        idx: 18
        port_type: inout
      }
      {
        name: SPI_DEV_TPM_CS_L
        type: InputStd
        bank: VIO
        connection: direct
        desc: SPI device TPM chip select
        idx: 19
        port_type: inout
      }
      {
        name: UART_RX
        type: InputStd
        bank: VIO
        connection: direct
        desc: UART receive
        idx: 20
        port_type: inout
      }
      {
        name: UART_TX
        type: BidirStd
        bank: VIO
        connection: direct
        desc: UART transmit
        idx: 21
        port_type: inout
      }
      {
        name: I2C_SCL
        type: BidirStd
        bank: VIO
        connection: direct
        desc: I2C clock
        idx: 22
        port_type: inout
      }
      {
        name: I2C_SDA
        type: BidirStd
        bank: VIO
        connection: direct
        desc: I2C data
        idx: 23
        port_type: inout
      }
      {
        name: GPIO0
        type: BidirStd
        bank: VIO
        connection: direct
        desc: GPIO pad
        idx: 24
        port_type: inout
      }
      {
        name: GPIO1
        type: BidirStd
        bank: VIO
        connection: direct
        desc: GPIO pad
        idx: 25
        port_type: inout
      }
      {
        name: GPIO2
        type: BidirStd
        bank: VIO
        connection: direct
        desc: GPIO pad
        idx: 26
        port_type: inout
      }
      {
        name: GPIO3
        type: BidirStd
        bank: VIO
        connection: direct
        desc: GPIO pad
        idx: 27
        port_type: inout
      }
      {
        name: GPIO4
        type: BidirStd
        bank: VIO
        connection: direct
        desc: GPIO pad
        idx: 28
        port_type: inout
      }
      {
        name: GPIO5
        type: BidirStd
        bank: VIO
        connection: direct
        desc: GPIO pad
        idx: 29
        port_type: inout
      }
      {
        name: GPIO6
        type: BidirStd
        bank: VIO
        connection: direct
        desc: GPIO pad
        idx: 30
        port_type: inout
      }
      {
        name: GPIO7
        type: BidirStd
        bank: VIO
        connection: direct
        desc: GPIO pad
        idx: 31
        port_type: inout
      }
      {
        name: GPIO8
        type: BidirStd
        bank: VIO
        connection: direct
        desc: GPIO pad
        idx: 32
        port_type: inout
      }
      {
        name: GPIO9
        type: BidirStd
        bank: VIO
        connection: direct
        desc: GPIO pad
        idx: 33
        port_type: inout
      }
      {
        name: GPIO10
        type: BidirStd
        bank: VIO
        connection: direct
        desc: GPIO pad
        idx: 34
        port_type: inout
      }
      {
        name: GPIO11
        type: BidirStd
        bank: VIO
        connection: direct
        desc: GPIO pad
        idx: 35
        port_type: inout
      }
      {
        name: GPIO12
        type: BidirStd
        bank: VIO
        connection: direct
        desc: GPIO pad
        idx: 36
        port_type: inout
      }
      {
        name: GPIO13
        type: BidirStd
        bank: VIO
        connection: direct
        desc: GPIO pad
        idx: 37
        port_type: inout
      }
      {
        name: GPIO14
        type: BidirStd
        bank: VIO
        connection: direct
        desc: GPIO pad
        idx: 38
        port_type: inout
      }
      {
        name: GPIO15
        type: BidirStd
        bank: VIO
        connection: direct
        desc: GPIO pad
        idx: 39
        port_type: inout
      }
      {
        name: GPIO16
        type: BidirStd
        bank: VIO
        connection: direct
        desc: GPIO pad
        idx: 40
        port_type: inout
      }
      {
        name: GPIO17
        type: BidirStd
        bank: VIO
        connection: direct
        desc: GPIO pad
        idx: 41
        port_type: inout
      }
      {
        name: GPIO18
        type: BidirStd
        bank: VIO
        connection: direct
        desc: GPIO pad
        idx: 42
        port_type: inout
      }
      {
        name: GPIO19
        type: BidirStd
        bank: VIO
        connection: direct
        desc: GPIO pad
        idx: 43
        port_type: inout
      }
      {
        name: GPIO20
        type: BidirStd
        bank: VIO
        connection: direct
        desc: GPIO pad
        idx: 44
        port_type: inout
      }
      {
        name: GPIO21
        type: BidirStd
        bank: VIO
        connection: direct
        desc: GPIO pad
        idx: 45
        port_type: inout
      }
      {
        name: GPIO22
        type: BidirStd
        bank: VIO
        connection: direct
        desc: GPIO pad
        idx: 46
        port_type: inout
      }
      {
        name: GPIO23
        type: BidirStd
        bank: VIO
        connection: direct
        desc: GPIO pad
        idx: 47
        port_type: inout
      }
      {
        name: GPIO24
        type: BidirStd
        bank: VIO
        connection: direct
        desc: GPIO pad
        idx: 48
        port_type: inout
      }
      {
        name: GPIO25
        type: BidirStd
        bank: VIO
        connection: direct
        desc: GPIO pad
        idx: 49
        port_type: inout
      }
      {
        name: GPIO26
        type: BidirStd
        bank: VIO
        connection: direct
        desc: GPIO pad
        idx: 50
        port_type: inout
      }
      {
        name: GPIO27
        type: BidirStd
        bank: VIO
        connection: direct
        desc: GPIO pad
        idx: 51
        port_type: inout
      }
      {
        name: GPIO28
        type: BidirStd
        bank: VIO
        connection: direct
        desc: GPIO pad
        idx: 52
        port_type: inout
      }
      {
        name: GPIO29
        type: BidirStd
        bank: VIO
        connection: direct
        desc: GPIO pad
        idx: 53
        port_type: inout
      }
      {
        name: GPIO30
        type: BidirStd
        bank: VIO
        connection: direct
        desc: GPIO pad
        idx: 54
        port_type: inout
      }
      {
        name: GPIO31
        type: BidirStd
        bank: VIO
        connection: direct
        desc: GPIO pad
        idx: 55
        port_type: inout
      }
      {
        name: SOC_GPI0
        type: InputStd
        bank: VIO
        connection: direct
        desc: SoC general purpose input
        idx: 56
        port_type: inout
      }
      {
        name: SOC_GPI1
        type: InputStd
        bank: VIO
        connection: direct
        desc: SoC general purpose input
        idx: 57
        port_type: inout
      }
      {
        name: SOC_GPI2
        type: InputStd
        bank: VIO
        connection: direct
        desc: SoC general purpose input
        idx: 58
        port_type: inout
      }
      {
        name: SOC_GPI3
        type: InputStd
        bank: VIO
        connection: direct
        desc: SoC general purpose input
        idx: 59
        port_type: inout
      }
      {
        name: SOC_GPI4
        type: InputStd
        bank: VIO
        connection: direct
        desc: SoC general purpose input
        idx: 60
        port_type: inout
      }
      {
        name: SOC_GPI5
        type: InputStd
        bank: VIO
        connection: direct
        desc: SoC general purpose input
        idx: 61
        port_type: inout
      }
      {
        name: SOC_GPI6
        type: InputStd
        bank: VIO
        connection: direct
        desc: SoC general purpose input
        idx: 62
        port_type: inout
      }
      {
        name: SOC_GPI7
        type: InputStd
        bank: VIO
        connection: direct
        desc: SoC general purpose input
        idx: 63
        port_type: inout
      }
      {
        name: SOC_GPI8
        type: InputStd
        bank: VIO
        connection: direct
        desc: SoC general purpose input
        idx: 64
        port_type: inout
      }
      {
        name: SOC_GPI9
        type: InputStd
        bank: VIO
        connection: direct
        desc: SoC general purpose input
        idx: 65
        port_type: inout
      }
      {
        name: SOC_GPI10
        type: InputStd
        bank: VIO
        connection: direct
        desc: SoC general purpose input
        idx: 66
        port_type: inout
      }
      {
        name: SOC_GPI11
        type: InputStd
        bank: VIO
        connection: direct
        desc: SoC general purpose input
        idx: 67
        port_type: inout
      }
      {
        name: SOC_GPO0
        type: BidirStd
        bank: VIO
        connection: direct
        desc: SoC general purpose output
        idx: 68
        port_type: inout
      }
      {
        name: SOC_GPO1
        type: BidirStd
        bank: VIO
        connection: direct
        desc: SoC general purpose output
        idx: 69
        port_type: inout
      }
      {
        name: SOC_GPO2
        type: BidirStd
        bank: VIO
        connection: direct
        desc: SoC general purpose output
        idx: 70
        port_type: inout
      }
      {
        name: SOC_GPO3
        type: BidirStd
        bank: VIO
        connection: direct
        desc: SoC general purpose output
        idx: 71
        port_type: inout
      }
      {
        name: SOC_GPO4
        type: BidirStd
        bank: VIO
        connection: direct
        desc: SoC general purpose output
        idx: 72
        port_type: inout
      }
      {
        name: SOC_GPO5
        type: BidirStd
        bank: VIO
        connection: direct
        desc: SoC general purpose output
        idx: 73
        port_type: inout
      }
      {
        name: SOC_GPO6
        type: BidirStd
        bank: VIO
        connection: direct
        desc: SoC general purpose output
        idx: 74
        port_type: inout
      }
      {
        name: SOC_GPO7
        type: BidirStd
        bank: VIO
        connection: direct
        desc: SoC general purpose output
        idx: 75
        port_type: inout
      }
      {
        name: SOC_GPO8
        type: BidirStd
        bank: VIO
        connection: direct
        desc: SoC general purpose output
        idx: 76
        port_type: inout
      }
      {
        name: SOC_GPO9
        type: BidirStd
        bank: VIO
        connection: direct
        desc: SoC general purpose output
        idx: 77
        port_type: inout
      }
      {
        name: SOC_GPO10
        type: BidirStd
        bank: VIO
        connection: direct
        desc: SoC general purpose output
        idx: 78
        port_type: inout
      }
      {
        name: SOC_GPO11
        type: BidirStd
        bank: VIO
        connection: direct
        desc: SoC general purpose output
        idx: 79
        port_type: inout
      }
      {
        name: MIO0
        type: BidirStd
        bank: VIO
        connection: muxed
        desc: Muxed IO pad
        idx: 0
        port_type: inout
      }
      {
        name: MIO1
        type: BidirStd
        bank: VIO
        connection: muxed
        desc: Muxed IO pad
        idx: 1
        port_type: inout
      }
      {
        name: MIO2
        type: BidirStd
        bank: VIO
        connection: muxed
        desc: Muxed IO pad
        idx: 2
        port_type: inout
      }
      {
        name: MIO3
        type: BidirStd
        bank: VIO
        connection: muxed
        desc: Muxed IO pad
        idx: 3
        port_type: inout
      }
      {
        name: MIO4
        type: BidirStd
        bank: VIO
        connection: muxed
        desc: Muxed IO pad
        idx: 4
        port_type: inout
      }
      {
        name: MIO5
        type: BidirStd
        bank: VIO
        connection: muxed
        desc: Muxed IO pad
        idx: 5
        port_type: inout
      }
      {
        name: MIO6
        type: BidirStd
        bank: VIO
        connection: muxed
        desc: Muxed IO pad
        idx: 6
        port_type: inout
      }
      {
        name: MIO7
        type: BidirStd
        bank: VIO
        connection: muxed
        desc: Muxed IO pad
        idx: 7
        port_type: inout
      }
      {
        name: MIO8
        type: BidirStd
        bank: VIO
        connection: muxed
        desc: Muxed IO pad
        idx: 8
        port_type: inout
      }
      {
        name: MIO9
        type: BidirStd
        bank: VIO
        connection: muxed
        desc: Muxed IO pad
        idx: 9
        port_type: inout
      }
      {
        name: MIO10
        type: BidirStd
        bank: VIO
        connection: muxed
        desc: Muxed IO pad
        idx: 10
        port_type: inout
      }
      {
        name: MIO11
        type: BidirStd
        bank: VIO
        connection: muxed
        desc: Muxed IO pad
        idx: 11
        port_type: inout
      }
    ]
  }
  pinmux:
  {
    signals:
    [
      {
        instance: spi_host0
        port: sck
        connection: direct
        pads:
        [
          SPI_HOST_CLK
        ]
        desc: ""
        attr: BidirStd
      }
      {
        instance: spi_host0
        port: csb
        connection: direct
        pads:
        [
          SPI_HOST_CS_L
        ]
        desc: ""
        attr: BidirStd
      }
      {
        instance: spi_host0
        port: sd[0]
        connection: direct
        pads:
        [
          SPI_HOST_D0
        ]
        desc: ""
        attr: BidirStd
      }
      {
        instance: spi_host0
        port: sd[1]
        connection: direct
        pads:
        [
          SPI_HOST_D1
        ]
        desc: ""
        attr: BidirStd
      }
      {
        instance: spi_host0
        port: sd[2]
        connection: direct
        pads:
        [
          SPI_HOST_D2
        ]
        desc: ""
        attr: BidirStd
      }
      {
        instance: spi_host0
        port: sd[3]
        connection: direct
        pads:
        [
          SPI_HOST_D3
        ]
        desc: ""
        attr: BidirStd
      }
      {
        instance: spi_device
        port: sck
        connection: direct
        pads:
        [
          SPI_DEV_CLK
        ]
        desc: ""
        attr: InputStd
      }
      {
        instance: spi_device
        port: csb
        connection: direct
        pads:
        [
          SPI_DEV_CS_L
        ]
        desc: ""
        attr: InputStd
      }
      {
        instance: spi_device
        port: sd[0]
        connection: direct
        pads:
        [
          SPI_DEV_D0
        ]
        desc: ""
        attr: BidirStd
      }
      {
        instance: spi_device
        port: sd[1]
        connection: direct
        pads:
        [
          SPI_DEV_D1
        ]
        desc: ""
        attr: BidirStd
      }
      {
        instance: spi_device
        port: sd[2]
        connection: direct
        pads:
        [
          SPI_DEV_D2
        ]
        desc: ""
        attr: BidirStd
      }
      {
        instance: spi_device
        port: sd[3]
        connection: direct
        pads:
        [
          SPI_DEV_D3
        ]
        desc: ""
        attr: BidirStd
      }
      {
        instance: spi_device
        port: tpm_csb
        connection: direct
        pads:
        [
          SPI_DEV_TPM_CS_L
        ]
        desc: ""
        attr: InputStd
      }
      {
        instance: uart0
        port: rx
        connection: direct
        pads:
        [
          UART_RX
        ]
        desc: ""
        attr: InputStd
      }
      {
        instance: uart0
        port: tx
        connection: direct
        pads:
        [
          UART_TX
        ]
        desc: ""
        attr: BidirStd
      }
      {
        instance: i2c0
        port: scl
        connection: direct
        pads:
        [
          I2C_SCL
        ]
        desc: ""
        attr: BidirStd
      }
      {
        instance: i2c0
        port: sda
        connection: direct
        pads:
        [
          I2C_SDA
        ]
        desc: ""
        attr: BidirStd
      }
      {
        instance: gpio0
        port: gpio[0]
        connection: direct
        pads:
        [
          GPIO0
        ]
        desc: ""
        attr: BidirStd
      }
      {
        instance: gpio0
        port: gpio[1]
        connection: direct
        pads:
        [
          GPIO1
        ]
        desc: ""
        attr: BidirStd
      }
      {
        instance: gpio0
        port: gpio[2]
        connection: direct
        pads:
        [
          GPIO2
        ]
        desc: ""
        attr: BidirStd
      }
      {
        instance: gpio0
        port: gpio[3]
        connection: direct
        pads:
        [
          GPIO3
        ]
        desc: ""
        attr: BidirStd
      }
      {
        instance: gpio0
        port: gpio[4]
        connection: direct
        pads:
        [
          GPIO4
        ]
        desc: ""
        attr: BidirStd
      }
      {
        instance: gpio0
        port: gpio[5]
        connection: direct
        pads:
        [
          GPIO5
        ]
        desc: ""
        attr: BidirStd
      }
      {
        instance: gpio0
        port: gpio[6]
        connection: direct
        pads:
        [
          GPIO6
        ]
        desc: ""
        attr: BidirStd
      }
      {
        instance: gpio0
        port: gpio[7]
        connection: direct
        pads:
        [
          GPIO7
        ]
        desc: ""
        attr: BidirStd
      }
      {
        instance: gpio0
        port: gpio[8]
        connection: direct
        pads:
        [
          GPIO8
        ]
        desc: ""
        attr: BidirStd
      }
      {
        instance: gpio0
        port: gpio[9]
        connection: direct
        pads:
        [
          GPIO9
        ]
        desc: ""
        attr: BidirStd
      }
      {
        instance: gpio0
        port: gpio[10]
        connection: direct
        pads:
        [
          GPIO10
        ]
        desc: ""
        attr: BidirStd
      }
      {
        instance: gpio0
        port: gpio[11]
        connection: direct
        pads:
        [
          GPIO11
        ]
        desc: ""
        attr: BidirStd
      }
      {
        instance: gpio0
        port: gpio[12]
        connection: direct
        pads:
        [
          GPIO12
        ]
        desc: ""
        attr: BidirStd
      }
      {
        instance: gpio0
        port: gpio[13]
        connection: direct
        pads:
        [
          GPIO13
        ]
        desc: ""
        attr: BidirStd
      }
      {
        instance: gpio0
        port: gpio[14]
        connection: direct
        pads:
        [
          GPIO14
        ]
        desc: ""
        attr: BidirStd
      }
      {
        instance: gpio0
        port: gpio[15]
        connection: direct
        pads:
        [
          GPIO15
        ]
        desc: ""
        attr: BidirStd
      }
      {
        instance: gpio0
        port: gpio[16]
        connection: direct
        pads:
        [
          GPIO16
        ]
        desc: ""
        attr: BidirStd
      }
      {
        instance: gpio0
        port: gpio[17]
        connection: direct
        pads:
        [
          GPIO17
        ]
        desc: ""
        attr: BidirStd
      }
      {
        instance: gpio0
        port: gpio[18]
        connection: direct
        pads:
        [
          GPIO18
        ]
        desc: ""
        attr: BidirStd
      }
      {
        instance: gpio0
        port: gpio[19]
        connection: direct
        pads:
        [
          GPIO19
        ]
        desc: ""
        attr: BidirStd
      }
      {
        instance: gpio0
        port: gpio[20]
        connection: direct
        pads:
        [
          GPIO20
        ]
        desc: ""
        attr: BidirStd
      }
      {
        instance: gpio0
        port: gpio[21]
        connection: direct
        pads:
        [
          GPIO21
        ]
        desc: ""
        attr: BidirStd
      }
      {
        instance: gpio0
        port: gpio[22]
        connection: direct
        pads:
        [
          GPIO22
        ]
        desc: ""
        attr: BidirStd
      }
      {
        instance: gpio0
        port: gpio[23]
        connection: direct
        pads:
        [
          GPIO23
        ]
        desc: ""
        attr: BidirStd
      }
      {
        instance: gpio0
        port: gpio[24]
        connection: direct
        pads:
        [
          GPIO24
        ]
        desc: ""
        attr: BidirStd
      }
      {
        instance: gpio0
        port: gpio[25]
        connection: direct
        pads:
        [
          GPIO25
        ]
        desc: ""
        attr: BidirStd
      }
      {
        instance: gpio0
        port: gpio[26]
        connection: direct
        pads:
        [
          GPIO26
        ]
        desc: ""
        attr: BidirStd
      }
      {
        instance: gpio0
        port: gpio[27]
        connection: direct
        pads:
        [
          GPIO27
        ]
        desc: ""
        attr: BidirStd
      }
      {
        instance: gpio0
        port: gpio[28]
        connection: direct
        pads:
        [
          GPIO28
        ]
        desc: ""
        attr: BidirStd
      }
      {
        instance: gpio0
        port: gpio[29]
        connection: direct
        pads:
        [
          GPIO29
        ]
        desc: ""
        attr: BidirStd
      }
      {
        instance: gpio0
        port: gpio[30]
        connection: direct
        pads:
        [
          GPIO30
        ]
        desc: ""
        attr: BidirStd
      }
      {
        instance: gpio0
        port: gpio[31]
        connection: direct
        pads:
        [
          GPIO31
        ]
        desc: ""
        attr: BidirStd
      }
      {
        instance: soc_proxy
        port: soc_gpi[0]
        connection: direct
        pads:
        [
          SOC_GPI0
        ]
        desc: ""
        attr: InputStd
      }
      {
        instance: soc_proxy
        port: soc_gpi[1]
        connection: direct
        pads:
        [
          SOC_GPI1
        ]
        desc: ""
        attr: InputStd
      }
      {
        instance: soc_proxy
        port: soc_gpi[2]
        connection: direct
        pads:
        [
          SOC_GPI2
        ]
        desc: ""
        attr: InputStd
      }
      {
        instance: soc_proxy
        port: soc_gpi[3]
        connection: direct
        pads:
        [
          SOC_GPI3
        ]
        desc: ""
        attr: InputStd
      }
      {
        instance: soc_proxy
        port: soc_gpi[4]
        connection: direct
        pads:
        [
          SOC_GPI4
        ]
        desc: ""
        attr: InputStd
      }
      {
        instance: soc_proxy
        port: soc_gpi[5]
        connection: direct
        pads:
        [
          SOC_GPI5
        ]
        desc: ""
        attr: InputStd
      }
      {
        instance: soc_proxy
        port: soc_gpi[6]
        connection: direct
        pads:
        [
          SOC_GPI6
        ]
        desc: ""
        attr: InputStd
      }
      {
        instance: soc_proxy
        port: soc_gpi[7]
        connection: direct
        pads:
        [
          SOC_GPI7
        ]
        desc: ""
        attr: InputStd
      }
      {
        instance: soc_proxy
        port: soc_gpi[8]
        connection: direct
        pads:
        [
          SOC_GPI8
        ]
        desc: ""
        attr: InputStd
      }
      {
        instance: soc_proxy
        port: soc_gpi[9]
        connection: direct
        pads:
        [
          SOC_GPI9
        ]
        desc: ""
        attr: InputStd
      }
      {
        instance: soc_proxy
        port: soc_gpi[10]
        connection: direct
        pads:
        [
          SOC_GPI10
        ]
        desc: ""
        attr: InputStd
      }
      {
        instance: soc_proxy
        port: soc_gpi[11]
        connection: direct
        pads:
        [
          SOC_GPI11
        ]
        desc: ""
        attr: InputStd
      }
      {
        instance: soc_proxy
        port: soc_gpi[12]
        connection: muxed
        pads: []
        desc: ""
        attr: ""
      }
      {
        instance: soc_proxy
        port: soc_gpi[13]
        connection: muxed
        pads: []
        desc: ""
        attr: ""
      }
      {
        instance: soc_proxy
        port: soc_gpi[14]
        connection: muxed
        pads: []
        desc: ""
        attr: ""
      }
      {
        instance: soc_proxy
        port: soc_gpi[15]
        connection: muxed
        pads: []
        desc: ""
        attr: ""
      }
      {
        instance: soc_proxy
        port: soc_gpo[0]
        connection: direct
        pads:
        [
          SOC_GPO0
        ]
        desc: ""
        attr: BidirStd
      }
      {
        instance: soc_proxy
        port: soc_gpo[1]
        connection: direct
        pads:
        [
          SOC_GPO1
        ]
        desc: ""
        attr: BidirStd
      }
      {
        instance: soc_proxy
        port: soc_gpo[2]
        connection: direct
        pads:
        [
          SOC_GPO2
        ]
        desc: ""
        attr: BidirStd
      }
      {
        instance: soc_proxy
        port: soc_gpo[3]
        connection: direct
        pads:
        [
          SOC_GPO3
        ]
        desc: ""
        attr: BidirStd
      }
      {
        instance: soc_proxy
        port: soc_gpo[4]
        connection: direct
        pads:
        [
          SOC_GPO4
        ]
        desc: ""
        attr: BidirStd
      }
      {
        instance: soc_proxy
        port: soc_gpo[5]
        connection: direct
        pads:
        [
          SOC_GPO5
        ]
        desc: ""
        attr: BidirStd
      }
      {
        instance: soc_proxy
        port: soc_gpo[6]
        connection: direct
        pads:
        [
          SOC_GPO6
        ]
        desc: ""
        attr: BidirStd
      }
      {
        instance: soc_proxy
        port: soc_gpo[7]
        connection: direct
        pads:
        [
          SOC_GPO7
        ]
        desc: ""
        attr: BidirStd
      }
      {
        instance: soc_proxy
        port: soc_gpo[8]
        connection: direct
        pads:
        [
          SOC_GPO8
        ]
        desc: ""
        attr: BidirStd
      }
      {
        instance: soc_proxy
        port: soc_gpo[9]
        connection: direct
        pads:
        [
          SOC_GPO9
        ]
        desc: ""
        attr: BidirStd
      }
      {
        instance: soc_proxy
        port: soc_gpo[10]
        connection: direct
        pads:
        [
          SOC_GPO10
        ]
        desc: ""
        attr: BidirStd
      }
      {
        instance: soc_proxy
        port: soc_gpo[11]
        connection: direct
        pads:
        [
          SOC_GPO11
        ]
        desc: ""
        attr: BidirStd
      }
      {
        instance: soc_proxy
        port: soc_gpo[12]
        connection: muxed
        pads: []
        desc: ""
        attr: ""
      }
      {
        instance: soc_proxy
        port: soc_gpo[13]
        connection: muxed
        pads: []
        desc: ""
        attr: ""
      }
      {
        instance: soc_proxy
        port: soc_gpo[14]
        connection: muxed
        pads: []
        desc: ""
        attr: ""
      }
      {
        instance: soc_proxy
        port: soc_gpo[15]
        connection: muxed
        pads: []
        desc: ""
        attr: ""
      }
      {
        instance: otp_macro
        port: test[0]
        connection: muxed
        pads: []
        desc: ""
        attr: ""
      }
    ]
    num_wkup_detect: 8
    wkup_cnt_width: 8
    enable_usb_wakeup: false
    enable_strap_sampling: false
    ios:
    [
      {
        name: spi_host0_sd
        width: 4
        type: inout
        idx: 0
        pads:
        [
          SPI_HOST_D0
        ]
        attr: BidirStd
        connection: direct
        desc: ""
        domain: Main
        glob_idx: 0
      }
      {
        name: spi_host0_sd
        width: 4
        type: inout
        idx: 1
        pads:
        [
          SPI_HOST_D1
        ]
        attr: BidirStd
        connection: direct
        desc: ""
        domain: Main
        glob_idx: 1
      }
      {
        name: spi_host0_sd
        width: 4
        type: inout
        idx: 2
        pads:
        [
          SPI_HOST_D2
        ]
        attr: BidirStd
        connection: direct
        desc: ""
        domain: Main
        glob_idx: 2
      }
      {
        name: spi_host0_sd
        width: 4
        type: inout
        idx: 3
        pads:
        [
          SPI_HOST_D3
        ]
        attr: BidirStd
        connection: direct
        desc: ""
        domain: Main
        glob_idx: 3
      }
      {
        name: spi_device_sd
        width: 4
        type: inout
        idx: 0
        pads:
        [
          SPI_DEV_D0
        ]
        attr: BidirStd
        connection: direct
        desc: ""
        domain: Main
        glob_idx: 4
      }
      {
        name: spi_device_sd
        width: 4
        type: inout
        idx: 1
        pads:
        [
          SPI_DEV_D1
        ]
        attr: BidirStd
        connection: direct
        desc: ""
        domain: Main
        glob_idx: 5
      }
      {
        name: spi_device_sd
        width: 4
        type: inout
        idx: 2
        pads:
        [
          SPI_DEV_D2
        ]
        attr: BidirStd
        connection: direct
        desc: ""
        domain: Main
        glob_idx: 6
      }
      {
        name: spi_device_sd
        width: 4
        type: inout
        idx: 3
        pads:
        [
          SPI_DEV_D3
        ]
        attr: BidirStd
        connection: direct
        desc: ""
        domain: Main
        glob_idx: 7
      }
      {
        name: i2c0_scl
        width: 1
        type: inout
        idx: -1
        pads:
        [
          I2C_SCL
        ]
        attr: BidirStd
        connection: direct
        desc: ""
        domain: Main
        glob_idx: 8
      }
      {
        name: i2c0_sda
        width: 1
        type: inout
        idx: -1
        pads:
        [
          I2C_SDA
        ]
        attr: BidirStd
        connection: direct
        desc: ""
        domain: Main
        glob_idx: 9
      }
      {
        name: gpio0_gpio
        width: 32
        type: inout
        idx: 0
        pads:
        [
          GPIO0
        ]
        attr: BidirStd
        connection: direct
        desc: ""
        domain: Main
        glob_idx: 10
      }
      {
        name: gpio0_gpio
        width: 32
        type: inout
        idx: 1
        pads:
        [
          GPIO1
        ]
        attr: BidirStd
        connection: direct
        desc: ""
        domain: Main
        glob_idx: 11
      }
      {
        name: gpio0_gpio
        width: 32
        type: inout
        idx: 2
        pads:
        [
          GPIO2
        ]
        attr: BidirStd
        connection: direct
        desc: ""
        domain: Main
        glob_idx: 12
      }
      {
        name: gpio0_gpio
        width: 32
        type: inout
        idx: 3
        pads:
        [
          GPIO3
        ]
        attr: BidirStd
        connection: direct
        desc: ""
        domain: Main
        glob_idx: 13
      }
      {
        name: gpio0_gpio
        width: 32
        type: inout
        idx: 4
        pads:
        [
          GPIO4
        ]
        attr: BidirStd
        connection: direct
        desc: ""
        domain: Main
        glob_idx: 14
      }
      {
        name: gpio0_gpio
        width: 32
        type: inout
        idx: 5
        pads:
        [
          GPIO5
        ]
        attr: BidirStd
        connection: direct
        desc: ""
        domain: Main
        glob_idx: 15
      }
      {
        name: gpio0_gpio
        width: 32
        type: inout
        idx: 6
        pads:
        [
          GPIO6
        ]
        attr: BidirStd
        connection: direct
        desc: ""
        domain: Main
        glob_idx: 16
      }
      {
        name: gpio0_gpio
        width: 32
        type: inout
        idx: 7
        pads:
        [
          GPIO7
        ]
        attr: BidirStd
        connection: direct
        desc: ""
        domain: Main
        glob_idx: 17
      }
      {
        name: gpio0_gpio
        width: 32
        type: inout
        idx: 8
        pads:
        [
          GPIO8
        ]
        attr: BidirStd
        connection: direct
        desc: ""
        domain: Main
        glob_idx: 18
      }
      {
        name: gpio0_gpio
        width: 32
        type: inout
        idx: 9
        pads:
        [
          GPIO9
        ]
        attr: BidirStd
        connection: direct
        desc: ""
        domain: Main
        glob_idx: 19
      }
      {
        name: gpio0_gpio
        width: 32
        type: inout
        idx: 10
        pads:
        [
          GPIO10
        ]
        attr: BidirStd
        connection: direct
        desc: ""
        domain: Main
        glob_idx: 20
      }
      {
        name: gpio0_gpio
        width: 32
        type: inout
        idx: 11
        pads:
        [
          GPIO11
        ]
        attr: BidirStd
        connection: direct
        desc: ""
        domain: Main
        glob_idx: 21
      }
      {
        name: gpio0_gpio
        width: 32
        type: inout
        idx: 12
        pads:
        [
          GPIO12
        ]
        attr: BidirStd
        connection: direct
        desc: ""
        domain: Main
        glob_idx: 22
      }
      {
        name: gpio0_gpio
        width: 32
        type: inout
        idx: 13
        pads:
        [
          GPIO13
        ]
        attr: BidirStd
        connection: direct
        desc: ""
        domain: Main
        glob_idx: 23
      }
      {
        name: gpio0_gpio
        width: 32
        type: inout
        idx: 14
        pads:
        [
          GPIO14
        ]
        attr: BidirStd
        connection: direct
        desc: ""
        domain: Main
        glob_idx: 24
      }
      {
        name: gpio0_gpio
        width: 32
        type: inout
        idx: 15
        pads:
        [
          GPIO15
        ]
        attr: BidirStd
        connection: direct
        desc: ""
        domain: Main
        glob_idx: 25
      }
      {
        name: gpio0_gpio
        width: 32
        type: inout
        idx: 16
        pads:
        [
          GPIO16
        ]
        attr: BidirStd
        connection: direct
        desc: ""
        domain: Main
        glob_idx: 26
      }
      {
        name: gpio0_gpio
        width: 32
        type: inout
        idx: 17
        pads:
        [
          GPIO17
        ]
        attr: BidirStd
        connection: direct
        desc: ""
        domain: Main
        glob_idx: 27
      }
      {
        name: gpio0_gpio
        width: 32
        type: inout
        idx: 18
        pads:
        [
          GPIO18
        ]
        attr: BidirStd
        connection: direct
        desc: ""
        domain: Main
        glob_idx: 28
      }
      {
        name: gpio0_gpio
        width: 32
        type: inout
        idx: 19
        pads:
        [
          GPIO19
        ]
        attr: BidirStd
        connection: direct
        desc: ""
        domain: Main
        glob_idx: 29
      }
      {
        name: gpio0_gpio
        width: 32
        type: inout
        idx: 20
        pads:
        [
          GPIO20
        ]
        attr: BidirStd
        connection: direct
        desc: ""
        domain: Main
        glob_idx: 30
      }
      {
        name: gpio0_gpio
        width: 32
        type: inout
        idx: 21
        pads:
        [
          GPIO21
        ]
        attr: BidirStd
        connection: direct
        desc: ""
        domain: Main
        glob_idx: 31
      }
      {
        name: gpio0_gpio
        width: 32
        type: inout
        idx: 22
        pads:
        [
          GPIO22
        ]
        attr: BidirStd
        connection: direct
        desc: ""
        domain: Main
        glob_idx: 32
      }
      {
        name: gpio0_gpio
        width: 32
        type: inout
        idx: 23
        pads:
        [
          GPIO23
        ]
        attr: BidirStd
        connection: direct
        desc: ""
        domain: Main
        glob_idx: 33
      }
      {
        name: gpio0_gpio
        width: 32
        type: inout
        idx: 24
        pads:
        [
          GPIO24
        ]
        attr: BidirStd
        connection: direct
        desc: ""
        domain: Main
        glob_idx: 34
      }
      {
        name: gpio0_gpio
        width: 32
        type: inout
        idx: 25
        pads:
        [
          GPIO25
        ]
        attr: BidirStd
        connection: direct
        desc: ""
        domain: Main
        glob_idx: 35
      }
      {
        name: gpio0_gpio
        width: 32
        type: inout
        idx: 26
        pads:
        [
          GPIO26
        ]
        attr: BidirStd
        connection: direct
        desc: ""
        domain: Main
        glob_idx: 36
      }
      {
        name: gpio0_gpio
        width: 32
        type: inout
        idx: 27
        pads:
        [
          GPIO27
        ]
        attr: BidirStd
        connection: direct
        desc: ""
        domain: Main
        glob_idx: 37
      }
      {
        name: gpio0_gpio
        width: 32
        type: inout
        idx: 28
        pads:
        [
          GPIO28
        ]
        attr: BidirStd
        connection: direct
        desc: ""
        domain: Main
        glob_idx: 38
      }
      {
        name: gpio0_gpio
        width: 32
        type: inout
        idx: 29
        pads:
        [
          GPIO29
        ]
        attr: BidirStd
        connection: direct
        desc: ""
        domain: Main
        glob_idx: 39
      }
      {
        name: gpio0_gpio
        width: 32
        type: inout
        idx: 30
        pads:
        [
          GPIO30
        ]
        attr: BidirStd
        connection: direct
        desc: ""
        domain: Main
        glob_idx: 40
      }
      {
        name: gpio0_gpio
        width: 32
        type: inout
        idx: 31
        pads:
        [
          GPIO31
        ]
        attr: BidirStd
        connection: direct
        desc: ""
        domain: Main
        glob_idx: 41
      }
      {
        name: spi_device_sck
        width: 1
        type: input
        idx: -1
        pads:
        [
          SPI_DEV_CLK
        ]
        attr: InputStd
        connection: direct
        desc: ""
        domain: Main
        glob_idx: 42
      }
      {
        name: spi_device_csb
        width: 1
        type: input
        idx: -1
        pads:
        [
          SPI_DEV_CS_L
        ]
        attr: InputStd
        connection: direct
        desc: ""
        domain: Main
        glob_idx: 43
      }
      {
        name: spi_device_tpm_csb
        width: 1
        type: input
        idx: -1
        pads:
        [
          SPI_DEV_TPM_CS_L
        ]
        attr: InputStd
        connection: direct
        desc: ""
        domain: Main
        glob_idx: 44
      }
      {
        name: uart0_rx
        width: 1
        type: input
        idx: -1
        pads:
        [
          UART_RX
        ]
        attr: InputStd
        connection: direct
        desc: ""
        domain: Main
        glob_idx: 45
      }
      {
        name: soc_proxy_soc_gpi
        width: 16
        type: input
        idx: 0
        pads:
        [
          SOC_GPI0
        ]
        attr: InputStd
        connection: direct
        desc: ""
        domain: Aon
        glob_idx: 46
      }
      {
        name: soc_proxy_soc_gpi
        width: 16
        type: input
        idx: 1
        pads:
        [
          SOC_GPI1
        ]
        attr: InputStd
        connection: direct
        desc: ""
        domain: Aon
        glob_idx: 47
      }
      {
        name: soc_proxy_soc_gpi
        width: 16
        type: input
        idx: 2
        pads:
        [
          SOC_GPI2
        ]
        attr: InputStd
        connection: direct
        desc: ""
        domain: Aon
        glob_idx: 48
      }
      {
        name: soc_proxy_soc_gpi
        width: 16
        type: input
        idx: 3
        pads:
        [
          SOC_GPI3
        ]
        attr: InputStd
        connection: direct
        desc: ""
        domain: Aon
        glob_idx: 49
      }
      {
        name: soc_proxy_soc_gpi
        width: 16
        type: input
        idx: 4
        pads:
        [
          SOC_GPI4
        ]
        attr: InputStd
        connection: direct
        desc: ""
        domain: Aon
        glob_idx: 50
      }
      {
        name: soc_proxy_soc_gpi
        width: 16
        type: input
        idx: 5
        pads:
        [
          SOC_GPI5
        ]
        attr: InputStd
        connection: direct
        desc: ""
        domain: Aon
        glob_idx: 51
      }
      {
        name: soc_proxy_soc_gpi
        width: 16
        type: input
        idx: 6
        pads:
        [
          SOC_GPI6
        ]
        attr: InputStd
        connection: direct
        desc: ""
        domain: Aon
        glob_idx: 52
      }
      {
        name: soc_proxy_soc_gpi
        width: 16
        type: input
        idx: 7
        pads:
        [
          SOC_GPI7
        ]
        attr: InputStd
        connection: direct
        desc: ""
        domain: Aon
        glob_idx: 53
      }
      {
        name: soc_proxy_soc_gpi
        width: 16
        type: input
        idx: 8
        pads:
        [
          SOC_GPI8
        ]
        attr: InputStd
        connection: direct
        desc: ""
        domain: Aon
        glob_idx: 54
      }
      {
        name: soc_proxy_soc_gpi
        width: 16
        type: input
        idx: 9
        pads:
        [
          SOC_GPI9
        ]
        attr: InputStd
        connection: direct
        desc: ""
        domain: Aon
        glob_idx: 55
      }
      {
        name: soc_proxy_soc_gpi
        width: 16
        type: input
        idx: 10
        pads:
        [
          SOC_GPI10
        ]
        attr: InputStd
        connection: direct
        desc: ""
        domain: Aon
        glob_idx: 56
      }
      {
        name: soc_proxy_soc_gpi
        width: 16
        type: input
        idx: 11
        pads:
        [
          SOC_GPI11
        ]
        attr: InputStd
        connection: direct
        desc: ""
        domain: Aon
        glob_idx: 57
      }
      {
        name: soc_proxy_soc_gpi
        width: 16
        type: input
        idx: 12
        pads: []
        attr: ""
        connection: muxed
        desc: ""
        domain: Aon
        glob_idx: 0
      }
      {
        name: soc_proxy_soc_gpi
        width: 16
        type: input
        idx: 13
        pads: []
        attr: ""
        connection: muxed
        desc: ""
        domain: Aon
        glob_idx: 1
      }
      {
        name: soc_proxy_soc_gpi
        width: 16
        type: input
        idx: 14
        pads: []
        attr: ""
        connection: muxed
        desc: ""
        domain: Aon
        glob_idx: 2
      }
      {
        name: soc_proxy_soc_gpi
        width: 16
        type: input
        idx: 15
        pads: []
        attr: ""
        connection: muxed
        desc: ""
        domain: Aon
        glob_idx: 3
      }
      {
        name: spi_host0_sck
        width: 1
        type: output
        idx: -1
        pads:
        [
          SPI_HOST_CLK
        ]
        attr: BidirStd
        connection: direct
        desc: ""
        domain: Main
        glob_idx: 58
      }
      {
        name: spi_host0_csb
        width: 1
        type: output
        idx: -1
        pads:
        [
          SPI_HOST_CS_L
        ]
        attr: BidirStd
        connection: direct
        desc: ""
        domain: Main
        glob_idx: 59
      }
      {
        name: uart0_tx
        width: 1
        type: output
        idx: -1
        pads:
        [
          UART_TX
        ]
        attr: BidirStd
        connection: direct
        desc: ""
        domain: Main
        glob_idx: 60
      }
      {
        name: soc_proxy_soc_gpo
        width: 16
        type: output
        idx: 0
        pads:
        [
          SOC_GPO0
        ]
        attr: BidirStd
        connection: direct
        desc: ""
        domain: Aon
        glob_idx: 61
      }
      {
        name: soc_proxy_soc_gpo
        width: 16
        type: output
        idx: 1
        pads:
        [
          SOC_GPO1
        ]
        attr: BidirStd
        connection: direct
        desc: ""
        domain: Aon
        glob_idx: 62
      }
      {
        name: soc_proxy_soc_gpo
        width: 16
        type: output
        idx: 2
        pads:
        [
          SOC_GPO2
        ]
        attr: BidirStd
        connection: direct
        desc: ""
        domain: Aon
        glob_idx: 63
      }
      {
        name: soc_proxy_soc_gpo
        width: 16
        type: output
        idx: 3
        pads:
        [
          SOC_GPO3
        ]
        attr: BidirStd
        connection: direct
        desc: ""
        domain: Aon
        glob_idx: 64
      }
      {
        name: soc_proxy_soc_gpo
        width: 16
        type: output
        idx: 4
        pads:
        [
          SOC_GPO4
        ]
        attr: BidirStd
        connection: direct
        desc: ""
        domain: Aon
        glob_idx: 65
      }
      {
        name: soc_proxy_soc_gpo
        width: 16
        type: output
        idx: 5
        pads:
        [
          SOC_GPO5
        ]
        attr: BidirStd
        connection: direct
        desc: ""
        domain: Aon
        glob_idx: 66
      }
      {
        name: soc_proxy_soc_gpo
        width: 16
        type: output
        idx: 6
        pads:
        [
          SOC_GPO6
        ]
        attr: BidirStd
        connection: direct
        desc: ""
        domain: Aon
        glob_idx: 67
      }
      {
        name: soc_proxy_soc_gpo
        width: 16
        type: output
        idx: 7
        pads:
        [
          SOC_GPO7
        ]
        attr: BidirStd
        connection: direct
        desc: ""
        domain: Aon
        glob_idx: 68
      }
      {
        name: soc_proxy_soc_gpo
        width: 16
        type: output
        idx: 8
        pads:
        [
          SOC_GPO8
        ]
        attr: BidirStd
        connection: direct
        desc: ""
        domain: Aon
        glob_idx: 69
      }
      {
        name: soc_proxy_soc_gpo
        width: 16
        type: output
        idx: 9
        pads:
        [
          SOC_GPO9
        ]
        attr: BidirStd
        connection: direct
        desc: ""
        domain: Aon
        glob_idx: 70
      }
      {
        name: soc_proxy_soc_gpo
        width: 16
        type: output
        idx: 10
        pads:
        [
          SOC_GPO10
        ]
        attr: BidirStd
        connection: direct
        desc: ""
        domain: Aon
        glob_idx: 71
      }
      {
        name: soc_proxy_soc_gpo
        width: 16
        type: output
        idx: 11
        pads:
        [
          SOC_GPO11
        ]
        attr: BidirStd
        connection: direct
        desc: ""
        domain: Aon
        glob_idx: 72
      }
      {
        name: soc_proxy_soc_gpo
        width: 16
        type: output
        idx: 12
        pads: []
        attr: ""
        connection: muxed
        desc: ""
        domain: Aon
        glob_idx: 0
      }
      {
        name: soc_proxy_soc_gpo
        width: 16
        type: output
        idx: 13
        pads: []
        attr: ""
        connection: muxed
        desc: ""
        domain: Aon
        glob_idx: 1
      }
      {
        name: soc_proxy_soc_gpo
        width: 16
        type: output
        idx: 14
        pads: []
        attr: ""
        connection: muxed
        desc: ""
        domain: Aon
        glob_idx: 2
      }
      {
        name: soc_proxy_soc_gpo
        width: 16
        type: output
        idx: 15
        pads: []
        attr: ""
        connection: muxed
        desc: ""
        domain: Aon
        glob_idx: 3
      }
      {
        name: otp_macro_test
        width: 8
        type: output
        idx: 0
        pads: []
        attr: ""
        connection: muxed
        desc: ""
        domain: Main
        glob_idx: 4
      }
    ]
    io_counts:
    {
      dedicated:
      {
        inouts: 42
        inputs: 16
        outputs: 15
        pads: 80
      }
      muxed:
      {
        inouts: 0
        inputs: 4
        outputs: 5
        pads: 12
      }
    }
  }
  targets:
  [
    {
      name: asic
      chiplevel:
      {
        port_overrides:
        {
          rv_dm.next_dm_addr:
          {
            unused: true
          }
          soc_proxy.integrator_id:
          {
            unused: true
          }
          soc_proxy.soc_lsio_trigger:
          {
            unused: true
          }
          soc_proxy.soc_gpi_async:
          {
            unused: true
          }
          soc_proxy.soc_gpo_async:
          {
            unused: true
          }
          soc_proxy.soc_wkup_async:
          {
            unused: true
          }
          soc_proxy.misc_tl_h2d:
          {
            feedthrough: true
          }
          soc_proxy.misc_tl_d2h:
          {
            feedthrough: true
          }
          ac_range_check.range_check_overwrite:
          {
            feedthrough: true
          }
          ac_range_check.ctn_filtered_tl_h2d:
          {
            signal: ctn_tl_h2d[0]
          }
          ac_range_check.ctn_filtered_tl_d2h:
          {
            signal: ctn_tl_d2h[0]
          }
          racl_ctrl.racl_policies:
          {
            unused: true
          }
          racl_ctrl.racl_error_external:
          {
            signal: ext_racl_error
          }
          clkmgr.cg_en:
          {
            unused: true
          }
          rstmgr.rst_en:
          {
            unused: true
          }
          pwrmgr.ext_rst_ack:
          {
            unused: true
          }
          pwrmgr.boot_status:
          {
            signal: pwrmgr_boot_status
          }
          soc_dbg_ctrl.halt_cpu_boot:
          {
            unused: true
          }
          soc_dbg_ctrl.soc_dbg_policy_bus:
          {
            unused: true
          }
          ast.lc_hw_debug_en:
          {
            unused: true
          }
          ast.lc_dft_en:
          {
            signal: lc_dft_en
          }
          dma.sys:
          {
            unused: true
          }
          mbx.tl_mbx:
          {
            unused: true
          }
          dbg.tl_dbg:
          {
            signal: dmi
          }
          otp_macro.ext_voltage_h:
          {
            signal: OTP_EXT_VOLT
          }
          mbx0.doe_intr:
          {
            unused: true
          }
          mbx0.doe_intr_en:
          {
            unused: true
          }
          mbx0.doe_intr_support:
          {
            unused: true
          }
          mbx0.doe_async_msg_support:
          {
            unused: true
          }
          mbx1.doe_intr:
          {
            unused: true
          }
          mbx1.doe_intr_en:
          {
            unused: true
          }
          mbx1.doe_intr_support:
          {
            unused: true
          }
          mbx1.doe_async_msg_support:
          {
            unused: true
          }
          mbx2.doe_intr:
          {
            unused: true
          }
          mbx2.doe_intr_en:
          {
            unused: true
          }
          mbx2.doe_intr_support:
          {
            unused: true
          }
          mbx2.doe_async_msg_support:
          {
            unused: true
          }
          mbx3.doe_intr:
          {
            unused: true
          }
          mbx3.doe_intr_en:
          {
            unused: true
          }
          mbx3.doe_intr_support:
          {
            unused: true
          }
          mbx3.doe_async_msg_support:
          {
            unused: true
          }
          mbx4.doe_intr:
          {
            unused: true
          }
          mbx4.doe_intr_en:
          {
            unused: true
          }
          mbx4.doe_intr_support:
          {
            unused: true
          }
          mbx4.doe_async_msg_support:
          {
            unused: true
          }
          mbx5.doe_intr:
          {
            unused: true
          }
          mbx5.doe_intr_en:
          {
            unused: true
          }
          mbx5.doe_intr_support:
          {
            unused: true
          }
          mbx5.doe_async_msg_support:
          {
            unused: true
          }
          mbx6.doe_intr:
          {
            unused: true
          }
          mbx6.doe_intr_en:
          {
            unused: true
          }
          mbx6.doe_intr_support:
          {
            unused: true
          }
          mbx6.doe_async_msg_support:
          {
            unused: true
          }
          mbx_jtag.doe_intr:
          {
            unused: true
          }
          mbx_jtag.doe_intr_en:
          {
            unused: true
          }
          mbx_jtag.doe_intr_support:
          {
            unused: true
          }
          mbx_jtag.doe_async_msg_support:
          {
            unused: true
          }
          mbx_pcie0.doe_intr:
          {
            unused: true
          }
          mbx_pcie0.doe_intr_en:
          {
            unused: true
          }
          mbx_pcie0.doe_intr_support:
          {
            unused: true
          }
          mbx_pcie0.doe_async_msg_support:
          {
            unused: true
          }
          mbx_pcie1.doe_intr:
          {
            unused: true
          }
          mbx_pcie1.doe_intr_en:
          {
            unused: true
          }
          mbx_pcie1.doe_intr_support:
          {
            unused: true
          }
          mbx_pcie1.doe_async_msg_support:
          {
            unused: true
          }
        }
      }
      pinout:
      {
        remove_ports: []
        remove_pads: []
        add_pads: []
      }
      pinmux:
      {
        special_signals: []
      }
    }
    {
      name: verilator
      chiplevel:
      {
        port_overrides:
        {
          rv_dm.next_dm_addr:
          {
            unused: true
          }
          soc_proxy.integrator_id:
          {
            unused: true
          }
          soc_proxy.soc_lsio_trigger:
          {
            unused: true
          }
          soc_proxy.soc_gpi_async:
          {
            unused: true
          }
          soc_proxy.soc_gpo_async:
          {
            unused: true
          }
          soc_proxy.soc_wkup_async:
          {
            unused: true
          }
          soc_proxy.misc_tl_h2d:
          {
            feedthrough: true
          }
          soc_proxy.misc_tl_d2h:
          {
            feedthrough: true
          }
          ac_range_check.range_check_overwrite:
          {
            feedthrough: true
          }
          ac_range_check.ctn_filtered_tl_h2d:
          {
            signal: ctn_tl_h2d[0]
          }
          ac_range_check.ctn_filtered_tl_d2h:
          {
            signal: ctn_tl_d2h[0]
          }
          racl_ctrl.racl_policies:
          {
            unused: true
          }
          racl_ctrl.racl_error_external:
          {
            signal: ext_racl_error
          }
          clkmgr.cg_en:
          {
            unused: true
          }
          rstmgr.rst_en:
          {
            unused: true
          }
          pwrmgr.ext_rst_ack:
          {
            unused: true
          }
          pwrmgr.boot_status:
          {
            signal: pwrmgr_boot_status
          }
          soc_dbg_ctrl.halt_cpu_boot:
          {
            unused: true
          }
          soc_dbg_ctrl.soc_dbg_policy_bus:
          {
            unused: true
          }
          ast.lc_hw_debug_en:
          {
            unused: true
          }
          ast.lc_dft_en:
          {
            signal: lc_dft_en
          }
          dma.sys:
          {
            unused: true
          }
          mbx.tl_mbx:
          {
            unused: true
          }
          dbg.tl_dbg:
          {
            signal: dmi
          }
          otp_macro.ext_voltage_h:
          {
            unused: true
            tie_value: ""
          }
          mbx0.doe_intr:
          {
            unused: true
          }
          mbx0.doe_intr_en:
          {
            unused: true
          }
          mbx0.doe_intr_support:
          {
            unused: true
          }
          mbx0.doe_async_msg_support:
          {
            unused: true
          }
          mbx1.doe_intr:
          {
            unused: true
          }
          mbx1.doe_intr_en:
          {
            unused: true
          }
          mbx1.doe_intr_support:
          {
            unused: true
          }
          mbx1.doe_async_msg_support:
          {
            unused: true
          }
          mbx2.doe_intr:
          {
            unused: true
          }
          mbx2.doe_intr_en:
          {
            unused: true
          }
          mbx2.doe_intr_support:
          {
            unused: true
          }
          mbx2.doe_async_msg_support:
          {
            unused: true
          }
          mbx3.doe_intr:
          {
            unused: true
          }
          mbx3.doe_intr_en:
          {
            unused: true
          }
          mbx3.doe_intr_support:
          {
            unused: true
          }
          mbx3.doe_async_msg_support:
          {
            unused: true
          }
          mbx4.doe_intr:
          {
            unused: true
          }
          mbx4.doe_intr_en:
          {
            unused: true
          }
          mbx4.doe_intr_support:
          {
            unused: true
          }
          mbx4.doe_async_msg_support:
          {
            unused: true
          }
          mbx5.doe_intr:
          {
            unused: true
          }
          mbx5.doe_intr_en:
          {
            unused: true
          }
          mbx5.doe_intr_support:
          {
            unused: true
          }
          mbx5.doe_async_msg_support:
          {
            unused: true
          }
          mbx6.doe_intr:
          {
            unused: true
          }
          mbx6.doe_intr_en:
          {
            unused: true
          }
          mbx6.doe_intr_support:
          {
            unused: true
          }
          mbx6.doe_async_msg_support:
          {
            unused: true
          }
          mbx_jtag.doe_intr:
          {
            unused: true
          }
          mbx_jtag.doe_intr_en:
          {
            unused: true
          }
          mbx_jtag.doe_intr_support:
          {
            unused: true
          }
          mbx_jtag.doe_async_msg_support:
          {
            unused: true
          }
          mbx_pcie0.doe_intr:
          {
            unused: true
          }
          mbx_pcie0.doe_intr_en:
          {
            unused: true
          }
          mbx_pcie0.doe_intr_support:
          {
            unused: true
          }
          mbx_pcie0.doe_async_msg_support:
          {
            unused: true
          }
          mbx_pcie1.doe_intr:
          {
            unused: true
          }
          mbx_pcie1.doe_intr_en:
          {
            unused: true
          }
          mbx_pcie1.doe_intr_support:
          {
            unused: true
          }
          mbx_pcie1.doe_async_msg_support:
          {
            unused: true
          }
        }
      }
      pinout:
      {
        remove_ports: []
        remove_pads: []
        add_pads: []
      }
      pinmux:
      {
        special_signals: []
      }
    }
  ]
  incoming_alert: {}
  incoming_interrupt: {}
  exported_clks: {}
  racl:
  {
    error_response: true
    ctn_uid_bit_lsb: 0
    ctn_uid_bit_msb: 4
    role_bit_lsb: 5
    role_bit_msb: 8
    roles:
    {
      ROT:
      {
        role_id: 0
      }
      ROLE1:
      {
        role_id: 1
      }
      SOC:
      {
        role_id: 2
      }
    }
    policies:
    {
      Null:
      [
        {
          name: ALL_RD_WR
          desc: Standard policies allowing all roles to access a register
          allowed_rd:
          [
            ROT
            ROLE1
            SOC
          ]
          allowed_wr:
          [
            ROT
            ROLE1
            SOC
          ]
          rd_default: 7
          wr_default: 7
        }
        {
          name: ROT_PRIVATE
          rot_private: true
          desc: Standard policies allowing only the ROT role to access a register
          allowed_rd:
          [
            ROT
          ]
          allowed_wr:
          [
            ROT
          ]
          rd_default: 1
          wr_default: 1
        }
        {
          name: SOC_ROT
          desc: Custom policy
          allowed_rd:
          [
            ROT
            SOC
          ]
          allowed_wr:
          [
            ROT
            SOC
          ]
          rd_default: 5
          wr_default: 5
        }
      ]
    }
    nr_role_bits: 4
    nr_ctn_uid_bits: 5
    nr_policies: 3
    rot_private_policy_rd: 1
    rot_private_policy_wr: 1
  }
  wakeups:
  [
    {
      name: pin_wkup_req
      width: "1"
      module: pinmux
    }
    {
      name: wkup_req
      width: "1"
      module: aon_timer
    }
    {
      name: wkup_external_req
      width: "1"
      module: soc_proxy
    }
  ]
  unmanaged_resets: {}
  exported_rsts: {}
  alert:
  [
    {
      name: uart0_fatal_fault
      width: 1
      type: alert
      async: "1"
      handler: alert_handler
      module_name: uart0
      desc: uart0 fatal_fault alert
      lpg_name: peri_lc_io_Main
      lpg_idx: 0
    }
    {
      name: gpio0_fatal_fault
      width: 1
      type: alert
      async: "1"
      handler: alert_handler
      module_name: gpio0
      desc: gpio0 fatal_fault alert
      lpg_name: peri_lc_io_Main
      lpg_idx: 0
    }
    {
      name: spi_device_fatal_fault
      width: 1
      type: alert
      async: "1"
      handler: alert_handler
      module_name: spi_device
      desc: spi_device fatal_fault alert
      lpg_name: peri_spi_device_Main
      lpg_idx: 1
    }
    {
      name: i2c0_fatal_fault
      width: 1
      type: alert
      async: "1"
      handler: alert_handler
      module_name: i2c0
      desc: i2c0 fatal_fault alert
      lpg_name: peri_i2c0_Main
      lpg_idx: 2
    }
    {
      name: rv_timer_fatal_fault
      width: 1
      type: alert
      async: "1"
      handler: alert_handler
      module_name: rv_timer
      desc: rv_timer fatal_fault alert
      lpg_name: timers_lc_io_Main
      lpg_idx: 3
    }
    {
      name: otp_ctrl_fatal_macro_error
      width: 1
      type: alert
      async: "1"
      handler: alert_handler
      module_name: otp_ctrl
      desc: otp_ctrl fatal_macro_error alert
      lpg_name: secure_lc_io_Main
      lpg_idx: 4
    }
    {
      name: otp_ctrl_fatal_check_error
      width: 1
      type: alert
      async: "1"
      handler: alert_handler
      module_name: otp_ctrl
      desc: otp_ctrl fatal_check_error alert
      lpg_name: secure_lc_io_Main
      lpg_idx: 4
    }
    {
      name: otp_ctrl_fatal_bus_integ_error
      width: 1
      type: alert
      async: "1"
      handler: alert_handler
      module_name: otp_ctrl
      desc: otp_ctrl fatal_bus_integ_error alert
      lpg_name: secure_lc_io_Main
      lpg_idx: 4
    }
    {
      name: otp_ctrl_fatal_prim_otp_alert
      width: 1
      type: alert
      async: "1"
      handler: alert_handler
      module_name: otp_ctrl
      desc: otp_ctrl fatal_prim_otp_alert alert
      lpg_name: secure_lc_io_Main
      lpg_idx: 4
    }
    {
      name: otp_ctrl_recov_prim_otp_alert
      width: 1
      type: alert
      async: "1"
      handler: alert_handler
      module_name: otp_ctrl
      desc: otp_ctrl recov_prim_otp_alert alert
      lpg_name: secure_lc_io_Main
      lpg_idx: 4
    }
    {
      name: lc_ctrl_fatal_prog_error
      width: 1
      type: alert
      async: "1"
      handler: alert_handler
      module_name: lc_ctrl
      desc: lc_ctrl fatal_prog_error alert
      lpg_name: secure_lc_io_Main
      lpg_idx: 4
    }
    {
      name: lc_ctrl_fatal_state_error
      width: 1
      type: alert
      async: "1"
      handler: alert_handler
      module_name: lc_ctrl
      desc: lc_ctrl fatal_state_error alert
      lpg_name: secure_lc_io_Main
      lpg_idx: 4
    }
    {
      name: lc_ctrl_fatal_bus_integ_error
      width: 1
      type: alert
      async: "1"
      handler: alert_handler
      module_name: lc_ctrl
      desc: lc_ctrl fatal_bus_integ_error alert
      lpg_name: secure_lc_io_Main
      lpg_idx: 4
    }
    {
      name: spi_host0_fatal_fault
      width: 1
      type: alert
      async: "1"
      handler: alert_handler
      module_name: spi_host0
      desc: spi_host0 fatal_fault alert
      lpg_name: peri_spi_host0_Main
      lpg_idx: 5
    }
    {
      name: pwrmgr_fatal_fault
      width: 1
      type: alert
      async: "1"
      handler: alert_handler
      module_name: pwrmgr
      desc: pwrmgr fatal_fault alert
      lpg_name: powerup_por_io_Aon
      lpg_idx: 6
    }
    {
      name: rstmgr_fatal_fault
      width: 1
      type: alert
      async: "1"
      handler: alert_handler
      module_name: rstmgr
      desc: rstmgr fatal_fault alert
      lpg_name: powerup_lc_io_Aon
      lpg_idx: 7
    }
    {
      name: rstmgr_fatal_cnsty_fault
      width: 1
      type: alert
      async: "1"
      handler: alert_handler
      module_name: rstmgr
      desc: rstmgr fatal_cnsty_fault alert
      lpg_name: powerup_lc_io_Aon
      lpg_idx: 7
    }
    {
      name: clkmgr_recov_fault
      width: 1
      type: alert
      async: "1"
      handler: alert_handler
      module_name: clkmgr
      desc: clkmgr recov_fault alert
      lpg_name: powerup_lc_io_Aon
      lpg_idx: 7
    }
    {
      name: clkmgr_fatal_fault
      width: 1
      type: alert
      async: "1"
      handler: alert_handler
      module_name: clkmgr
      desc: clkmgr fatal_fault alert
      lpg_name: powerup_lc_io_Aon
      lpg_idx: 7
    }
    {
      name: pinmux_fatal_fault
      width: 1
      type: alert
      async: "1"
      handler: alert_handler
      module_name: pinmux
      desc: pinmux fatal_fault alert
      lpg_name: powerup_lc_io_Aon
      lpg_idx: 7
    }
    {
      name: aon_timer_fatal_fault
      width: 1
      type: alert
      async: "1"
      handler: alert_handler
      module_name: aon_timer
      desc: aon_timer fatal_fault alert
      lpg_name: timers_lc_io_Aon
      lpg_idx: 8
    }
    {
      name: soc_proxy_fatal_alert_intg
      width: 1
      type: alert
      async: "1"
      handler: alert_handler
      module_name: soc_proxy
      desc: soc_proxy fatal_alert_intg alert
      lpg_name: infra_lc_Main
      lpg_idx: 10
    }
    {
      name: sram_ctrl_ret_fatal_error
      width: 1
      type: alert
      async: "1"
      handler: alert_handler
      module_name: sram_ctrl_ret
      desc: sram_ctrl_ret fatal_error alert
      lpg_name: infra_lc_io_Aon
      lpg_idx: 11
    }
    {
      name: rv_dm_fatal_fault
      width: 1
      type: alert
      async: "1"
      handler: alert_handler
      module_name: rv_dm
      desc: rv_dm fatal_fault alert
      lpg_name: infra_sys_Main
      lpg_idx: 12
    }
    {
      name: rv_plic_fatal_fault
      width: 1
      type: alert
      async: "1"
      handler: alert_handler
      module_name: rv_plic
      desc: rv_plic fatal_fault alert
      lpg_name: secure_lc_Main
      lpg_idx: 13
    }
    {
      name: aes_recov_ctrl_update_err
      width: 1
      type: alert
      async: "1"
      handler: alert_handler
      module_name: aes
      desc: aes recov_ctrl_update_err alert
      lpg_name: aes_trans_lc_Main
      lpg_idx: 14
    }
    {
      name: aes_fatal_fault
      width: 1
      type: alert
      async: "1"
      handler: alert_handler
      module_name: aes
      desc: aes fatal_fault alert
      lpg_name: aes_trans_lc_Main
      lpg_idx: 14
    }
    {
      name: hmac_fatal_fault
      width: 1
      type: alert
      async: "1"
      handler: alert_handler
      module_name: hmac
      desc: hmac fatal_fault alert
      lpg_name: hmac_trans_lc_Main
      lpg_idx: 15
    }
    {
      name: kmac_recov_operation_err
      width: 1
      type: alert
      async: "1"
      handler: alert_handler
      module_name: kmac
      desc: kmac recov_operation_err alert
      lpg_name: kmac_trans_lc_Main
      lpg_idx: 16
    }
    {
      name: kmac_fatal_fault_err
      width: 1
      type: alert
      async: "1"
      handler: alert_handler
      module_name: kmac
      desc: kmac fatal_fault_err alert
      lpg_name: kmac_trans_lc_Main
      lpg_idx: 16
    }
    {
      name: otbn_fatal
      width: 1
      type: alert
      async: "1"
      handler: alert_handler
      module_name: otbn
      desc: otbn fatal alert
      lpg_name: otbn_trans_lc_Main
      lpg_idx: 17
    }
    {
      name: otbn_recov
      width: 1
      type: alert
      async: "1"
      handler: alert_handler
      module_name: otbn
      desc: otbn recov alert
      lpg_name: otbn_trans_lc_Main
      lpg_idx: 17
    }
    {
      name: keymgr_dpe_recov_operation_err
      width: 1
      type: alert
      async: "1"
      handler: alert_handler
      module_name: keymgr_dpe
      desc: keymgr_dpe recov_operation_err alert
      lpg_name: secure_lc_Main
      lpg_idx: 13
    }
    {
      name: keymgr_dpe_fatal_fault_err
      width: 1
      type: alert
      async: "1"
      handler: alert_handler
      module_name: keymgr_dpe
      desc: keymgr_dpe fatal_fault_err alert
      lpg_name: secure_lc_Main
      lpg_idx: 13
    }
    {
      name: csrng_recov_alert
      width: 1
      type: alert
      async: "1"
      handler: alert_handler
      module_name: csrng
      desc: csrng recov_alert alert
      lpg_name: secure_lc_Main
      lpg_idx: 13
    }
    {
      name: csrng_fatal_alert
      width: 1
      type: alert
      async: "1"
      handler: alert_handler
      module_name: csrng
      desc: csrng fatal_alert alert
      lpg_name: secure_lc_Main
      lpg_idx: 13
    }
    {
      name: entropy_src_recov_alert
      width: 1
      type: alert
      async: "1"
      handler: alert_handler
      module_name: entropy_src
      desc: entropy_src recov_alert alert
      lpg_name: secure_lc_Main
      lpg_idx: 13
    }
    {
      name: entropy_src_fatal_alert
      width: 1
      type: alert
      async: "1"
      handler: alert_handler
      module_name: entropy_src
      desc: entropy_src fatal_alert alert
      lpg_name: secure_lc_Main
      lpg_idx: 13
    }
    {
      name: edn0_recov_alert
      width: 1
      type: alert
      async: "1"
      handler: alert_handler
      module_name: edn0
      desc: edn0 recov_alert alert
      lpg_name: secure_lc_Main
      lpg_idx: 13
    }
    {
      name: edn0_fatal_alert
      width: 1
      type: alert
      async: "1"
      handler: alert_handler
      module_name: edn0
      desc: edn0 fatal_alert alert
      lpg_name: secure_lc_Main
      lpg_idx: 13
    }
    {
      name: edn1_recov_alert
      width: 1
      type: alert
      async: "1"
      handler: alert_handler
      module_name: edn1
      desc: edn1 recov_alert alert
      lpg_name: secure_lc_Main
      lpg_idx: 13
    }
    {
      name: edn1_fatal_alert
      width: 1
      type: alert
      async: "1"
      handler: alert_handler
      module_name: edn1
      desc: edn1 fatal_alert alert
      lpg_name: secure_lc_Main
      lpg_idx: 13
    }
    {
      name: sram_ctrl_main_fatal_error
      width: 1
      type: alert
      async: "1"
      handler: alert_handler
      module_name: sram_ctrl_main
      desc: sram_ctrl_main fatal_error alert
      lpg_name: infra_lc_Main
      lpg_idx: 10
    }
    {
      name: sram_ctrl_mbox_fatal_error
      width: 1
      type: alert
      async: "1"
      handler: alert_handler
      module_name: sram_ctrl_mbox
      desc: sram_ctrl_mbox fatal_error alert
      lpg_name: infra_lc_Main
      lpg_idx: 10
    }
    {
      name: rom_ctrl0_fatal
      width: 1
      type: alert
      async: "1"
      handler: alert_handler
      module_name: rom_ctrl0
      desc: rom_ctrl0 fatal alert
      lpg_name: infra_lc_Main
      lpg_idx: 10
    }
    {
      name: rom_ctrl1_fatal
      width: 1
      type: alert
      async: "1"
      handler: alert_handler
      module_name: rom_ctrl1
      desc: rom_ctrl1 fatal alert
      lpg_name: infra_lc_Main
      lpg_idx: 10
    }
    {
      name: dma_fatal_fault
      width: 1
      type: alert
      async: "1"
      handler: alert_handler
      module_name: dma
      desc: dma fatal_fault alert
      lpg_name: infra_lc_Main
      lpg_idx: 10
    }
    {
      name: mbx0_fatal_fault
      width: 1
      type: alert
      async: "1"
      handler: alert_handler
      module_name: mbx0
      desc: mbx0 fatal_fault alert
      lpg_name: infra_lc_Main
      lpg_idx: 10
    }
    {
      name: mbx0_recov_fault
      width: 1
      type: alert
      async: "1"
      handler: alert_handler
      module_name: mbx0
      desc: mbx0 recov_fault alert
      lpg_name: infra_lc_Main
      lpg_idx: 10
    }
    {
      name: mbx1_fatal_fault
      width: 1
      type: alert
      async: "1"
      handler: alert_handler
      module_name: mbx1
      desc: mbx1 fatal_fault alert
      lpg_name: infra_lc_Main
      lpg_idx: 10
    }
    {
      name: mbx1_recov_fault
      width: 1
      type: alert
      async: "1"
      handler: alert_handler
      module_name: mbx1
      desc: mbx1 recov_fault alert
      lpg_name: infra_lc_Main
      lpg_idx: 10
    }
    {
      name: mbx2_fatal_fault
      width: 1
      type: alert
      async: "1"
      handler: alert_handler
      module_name: mbx2
      desc: mbx2 fatal_fault alert
      lpg_name: infra_lc_Main
      lpg_idx: 10
    }
    {
      name: mbx2_recov_fault
      width: 1
      type: alert
      async: "1"
      handler: alert_handler
      module_name: mbx2
      desc: mbx2 recov_fault alert
      lpg_name: infra_lc_Main
      lpg_idx: 10
    }
    {
      name: mbx3_fatal_fault
      width: 1
      type: alert
      async: "1"
      handler: alert_handler
      module_name: mbx3
      desc: mbx3 fatal_fault alert
      lpg_name: infra_lc_Main
      lpg_idx: 10
    }
    {
      name: mbx3_recov_fault
      width: 1
      type: alert
      async: "1"
      handler: alert_handler
      module_name: mbx3
      desc: mbx3 recov_fault alert
      lpg_name: infra_lc_Main
      lpg_idx: 10
    }
    {
      name: mbx4_fatal_fault
      width: 1
      type: alert
      async: "1"
      handler: alert_handler
      module_name: mbx4
      desc: mbx4 fatal_fault alert
      lpg_name: infra_lc_Main
      lpg_idx: 10
    }
    {
      name: mbx4_recov_fault
      width: 1
      type: alert
      async: "1"
      handler: alert_handler
      module_name: mbx4
      desc: mbx4 recov_fault alert
      lpg_name: infra_lc_Main
      lpg_idx: 10
    }
    {
      name: mbx5_fatal_fault
      width: 1
      type: alert
      async: "1"
      handler: alert_handler
      module_name: mbx5
      desc: mbx5 fatal_fault alert
      lpg_name: infra_lc_Main
      lpg_idx: 10
    }
    {
      name: mbx5_recov_fault
      width: 1
      type: alert
      async: "1"
      handler: alert_handler
      module_name: mbx5
      desc: mbx5 recov_fault alert
      lpg_name: infra_lc_Main
      lpg_idx: 10
    }
    {
      name: mbx6_fatal_fault
      width: 1
      type: alert
      async: "1"
      handler: alert_handler
      module_name: mbx6
      desc: mbx6 fatal_fault alert
      lpg_name: infra_lc_Main
      lpg_idx: 10
    }
    {
      name: mbx6_recov_fault
      width: 1
      type: alert
      async: "1"
      handler: alert_handler
      module_name: mbx6
      desc: mbx6 recov_fault alert
      lpg_name: infra_lc_Main
      lpg_idx: 10
    }
    {
      name: mbx_jtag_fatal_fault
      width: 1
      type: alert
      async: "1"
      handler: alert_handler
      module_name: mbx_jtag
      desc: mbx_jtag fatal_fault alert
      lpg_name: infra_lc_Main
      lpg_idx: 10
    }
    {
      name: mbx_jtag_recov_fault
      width: 1
      type: alert
      async: "1"
      handler: alert_handler
      module_name: mbx_jtag
      desc: mbx_jtag recov_fault alert
      lpg_name: infra_lc_Main
      lpg_idx: 10
    }
    {
      name: mbx_pcie0_fatal_fault
      width: 1
      type: alert
      async: "1"
      handler: alert_handler
      module_name: mbx_pcie0
      desc: mbx_pcie0 fatal_fault alert
      lpg_name: infra_lc_Main
      lpg_idx: 10
    }
    {
      name: mbx_pcie0_recov_fault
      width: 1
      type: alert
      async: "1"
      handler: alert_handler
      module_name: mbx_pcie0
      desc: mbx_pcie0 recov_fault alert
      lpg_name: infra_lc_Main
      lpg_idx: 10
    }
    {
      name: mbx_pcie1_fatal_fault
      width: 1
      type: alert
      async: "1"
      handler: alert_handler
      module_name: mbx_pcie1
      desc: mbx_pcie1 fatal_fault alert
      lpg_name: infra_lc_Main
      lpg_idx: 10
    }
    {
      name: mbx_pcie1_recov_fault
      width: 1
      type: alert
      async: "1"
      handler: alert_handler
      module_name: mbx_pcie1
      desc: mbx_pcie1 recov_fault alert
      lpg_name: infra_lc_Main
      lpg_idx: 10
    }
    {
      name: soc_dbg_ctrl_fatal_fault
      width: 1
      type: alert
      async: "1"
      handler: alert_handler
      module_name: soc_dbg_ctrl
      desc: soc_dbg_ctrl fatal_fault alert
      lpg_name: secure_lc_io_Main
      lpg_idx: 4
    }
    {
      name: soc_dbg_ctrl_recov_ctrl_update_err
      width: 1
      type: alert
      async: "1"
      handler: alert_handler
      module_name: soc_dbg_ctrl
      desc: soc_dbg_ctrl recov_ctrl_update_err alert
      lpg_name: secure_lc_io_Main
      lpg_idx: 4
    }
    {
      name: racl_ctrl_fatal_fault
      width: 1
      type: alert
      async: "1"
      handler: alert_handler
      module_name: racl_ctrl
      desc: racl_ctrl fatal_fault alert
      lpg_name: infra_lc_Main
      lpg_idx: 10
    }
    {
      name: racl_ctrl_recov_ctrl_update_err
      width: 1
      type: alert
      async: "1"
      handler: alert_handler
      module_name: racl_ctrl
      desc: racl_ctrl recov_ctrl_update_err alert
      lpg_name: infra_lc_Main
      lpg_idx: 10
    }
    {
      name: ac_range_check_recov_ctrl_update_err
      width: 1
      type: alert
      async: "1"
      handler: alert_handler
      module_name: ac_range_check
      desc: ac_range_check recov_ctrl_update_err alert
      lpg_name: secure_lc_Main
      lpg_idx: 13
    }
    {
      name: ac_range_check_fatal_fault
      width: 1
      type: alert
      async: "1"
      handler: alert_handler
      module_name: ac_range_check
      desc: ac_range_check fatal_fault alert
      lpg_name: secure_lc_Main
      lpg_idx: 13
    }
    {
      name: rv_core_ibex_fatal_sw_err
      width: 1
      type: alert
      async: "1"
      handler: alert_handler
      module_name: rv_core_ibex
      desc: rv_core_ibex fatal_sw_err alert
      lpg_name: infra_lc_Main
      lpg_idx: 10
    }
    {
      name: rv_core_ibex_recov_sw_err
      width: 1
      type: alert
      async: "1"
      handler: alert_handler
      module_name: rv_core_ibex
      desc: rv_core_ibex recov_sw_err alert
      lpg_name: infra_lc_Main
      lpg_idx: 10
    }
    {
      name: rv_core_ibex_fatal_hw_err
      width: 1
      type: alert
      async: "1"
      handler: alert_handler
      module_name: rv_core_ibex
      desc: rv_core_ibex fatal_hw_err alert
      lpg_name: infra_lc_Main
      lpg_idx: 10
    }
    {
      name: rv_core_ibex_recov_hw_err
      width: 1
      type: alert
      async: "1"
      handler: alert_handler
      module_name: rv_core_ibex
      desc: rv_core_ibex recov_hw_err alert
      lpg_name: infra_lc_Main
      lpg_idx: 10
    }
  ]
  outgoing_alert: {}
  interrupt:
  [
    {
      name: uart0_tx_watermark
      width: 1
      type: interrupt
      module_name: uart0
      desc: uart0 tx_watermark interrupt
      intr_type: IntrType.Status
      default_val: true
      incoming: false
      domain: Main
      plic: rv_plic
      outgoing: false
    }
    {
      name: uart0_rx_watermark
      width: 1
      type: interrupt
      module_name: uart0
      desc: uart0 rx_watermark interrupt
      intr_type: IntrType.Status
      default_val: false
      incoming: false
      domain: Main
      plic: rv_plic
      outgoing: false
    }
    {
      name: uart0_tx_done
      width: 1
      type: interrupt
      module_name: uart0
      desc: uart0 tx_done interrupt
      intr_type: IntrType.Event
      default_val: false
      incoming: false
      domain: Main
      plic: rv_plic
      outgoing: false
    }
    {
      name: uart0_rx_overflow
      width: 1
      type: interrupt
      module_name: uart0
      desc: uart0 rx_overflow interrupt
      intr_type: IntrType.Event
      default_val: false
      incoming: false
      domain: Main
      plic: rv_plic
      outgoing: false
    }
    {
      name: uart0_rx_frame_err
      width: 1
      type: interrupt
      module_name: uart0
      desc: uart0 rx_frame_err interrupt
      intr_type: IntrType.Event
      default_val: false
      incoming: false
      domain: Main
      plic: rv_plic
      outgoing: false
    }
    {
      name: uart0_rx_break_err
      width: 1
      type: interrupt
      module_name: uart0
      desc: uart0 rx_break_err interrupt
      intr_type: IntrType.Event
      default_val: false
      incoming: false
      domain: Main
      plic: rv_plic
      outgoing: false
    }
    {
      name: uart0_rx_timeout
      width: 1
      type: interrupt
      module_name: uart0
      desc: uart0 rx_timeout interrupt
      intr_type: IntrType.Event
      default_val: false
      incoming: false
      domain: Main
      plic: rv_plic
      outgoing: false
    }
    {
      name: uart0_rx_parity_err
      width: 1
      type: interrupt
      module_name: uart0
      desc: uart0 rx_parity_err interrupt
      intr_type: IntrType.Event
      default_val: false
      incoming: false
      domain: Main
      plic: rv_plic
      outgoing: false
    }
    {
      name: uart0_tx_empty
      width: 1
      type: interrupt
      module_name: uart0
      desc: uart0 tx_empty interrupt
      intr_type: IntrType.Status
      default_val: true
      incoming: false
      domain: Main
      plic: rv_plic
      outgoing: false
    }
    {
      name: gpio0_gpio
      width: 32
      type: interrupt
      module_name: gpio0
      desc: gpio0 gpio interrupt
      intr_type: IntrType.Event
      default_val: false
      incoming: false
      domain: Main
      plic: rv_plic
      outgoing: false
    }
    {
      name: spi_device_upload_cmdfifo_not_empty
      width: 1
      type: interrupt
      module_name: spi_device
      desc: spi_device upload_cmdfifo_not_empty interrupt
      intr_type: IntrType.Event
      default_val: false
      incoming: false
      domain: Main
      plic: rv_plic
      outgoing: false
    }
    {
      name: spi_device_upload_payload_not_empty
      width: 1
      type: interrupt
      module_name: spi_device
      desc: spi_device upload_payload_not_empty interrupt
      intr_type: IntrType.Event
      default_val: false
      incoming: false
      domain: Main
      plic: rv_plic
      outgoing: false
    }
    {
      name: spi_device_upload_payload_overflow
      width: 1
      type: interrupt
      module_name: spi_device
      desc: spi_device upload_payload_overflow interrupt
      intr_type: IntrType.Event
      default_val: false
      incoming: false
      domain: Main
      plic: rv_plic
      outgoing: false
    }
    {
      name: spi_device_readbuf_watermark
      width: 1
      type: interrupt
      module_name: spi_device
      desc: spi_device readbuf_watermark interrupt
      intr_type: IntrType.Event
      default_val: false
      incoming: false
      domain: Main
      plic: rv_plic
      outgoing: false
    }
    {
      name: spi_device_readbuf_flip
      width: 1
      type: interrupt
      module_name: spi_device
      desc: spi_device readbuf_flip interrupt
      intr_type: IntrType.Event
      default_val: false
      incoming: false
      domain: Main
      plic: rv_plic
      outgoing: false
    }
    {
      name: spi_device_tpm_header_not_empty
      width: 1
      type: interrupt
      module_name: spi_device
      desc: spi_device tpm_header_not_empty interrupt
      intr_type: IntrType.Status
      default_val: false
      incoming: false
      domain: Main
      plic: rv_plic
      outgoing: false
    }
    {
      name: spi_device_tpm_rdfifo_cmd_end
      width: 1
      type: interrupt
      module_name: spi_device
      desc: spi_device tpm_rdfifo_cmd_end interrupt
      intr_type: IntrType.Event
      default_val: false
      incoming: false
      domain: Main
      plic: rv_plic
      outgoing: false
    }
    {
      name: spi_device_tpm_rdfifo_drop
      width: 1
      type: interrupt
      module_name: spi_device
      desc: spi_device tpm_rdfifo_drop interrupt
      intr_type: IntrType.Event
      default_val: false
      incoming: false
      domain: Main
      plic: rv_plic
      outgoing: false
    }
    {
      name: i2c0_fmt_threshold
      width: 1
      type: interrupt
      module_name: i2c0
      desc: i2c0 fmt_threshold interrupt
      intr_type: IntrType.Status
      default_val: false
      incoming: false
      domain: Main
      plic: rv_plic
      outgoing: false
    }
    {
      name: i2c0_rx_threshold
      width: 1
      type: interrupt
      module_name: i2c0
      desc: i2c0 rx_threshold interrupt
      intr_type: IntrType.Status
      default_val: false
      incoming: false
      domain: Main
      plic: rv_plic
      outgoing: false
    }
    {
      name: i2c0_acq_threshold
      width: 1
      type: interrupt
      module_name: i2c0
      desc: i2c0 acq_threshold interrupt
      intr_type: IntrType.Status
      default_val: false
      incoming: false
      domain: Main
      plic: rv_plic
      outgoing: false
    }
    {
      name: i2c0_rx_overflow
      width: 1
      type: interrupt
      module_name: i2c0
      desc: i2c0 rx_overflow interrupt
      intr_type: IntrType.Event
      default_val: false
      incoming: false
      domain: Main
      plic: rv_plic
      outgoing: false
    }
    {
      name: i2c0_controller_halt
      width: 1
      type: interrupt
      module_name: i2c0
      desc: i2c0 controller_halt interrupt
      intr_type: IntrType.Status
      default_val: false
      incoming: false
      domain: Main
      plic: rv_plic
      outgoing: false
    }
    {
      name: i2c0_scl_interference
      width: 1
      type: interrupt
      module_name: i2c0
      desc: i2c0 scl_interference interrupt
      intr_type: IntrType.Event
      default_val: false
      incoming: false
      domain: Main
      plic: rv_plic
      outgoing: false
    }
    {
      name: i2c0_sda_interference
      width: 1
      type: interrupt
      module_name: i2c0
      desc: i2c0 sda_interference interrupt
      intr_type: IntrType.Event
      default_val: false
      incoming: false
      domain: Main
      plic: rv_plic
      outgoing: false
    }
    {
      name: i2c0_stretch_timeout
      width: 1
      type: interrupt
      module_name: i2c0
      desc: i2c0 stretch_timeout interrupt
      intr_type: IntrType.Event
      default_val: false
      incoming: false
      domain: Main
      plic: rv_plic
      outgoing: false
    }
    {
      name: i2c0_sda_unstable
      width: 1
      type: interrupt
      module_name: i2c0
      desc: i2c0 sda_unstable interrupt
      intr_type: IntrType.Event
      default_val: false
      incoming: false
      domain: Main
      plic: rv_plic
      outgoing: false
    }
    {
      name: i2c0_cmd_complete
      width: 1
      type: interrupt
      module_name: i2c0
      desc: i2c0 cmd_complete interrupt
      intr_type: IntrType.Event
      default_val: false
      incoming: false
      domain: Main
      plic: rv_plic
      outgoing: false
    }
    {
      name: i2c0_tx_stretch
      width: 1
      type: interrupt
      module_name: i2c0
      desc: i2c0 tx_stretch interrupt
      intr_type: IntrType.Status
      default_val: false
      incoming: false
      domain: Main
      plic: rv_plic
      outgoing: false
    }
    {
      name: i2c0_tx_threshold
      width: 1
      type: interrupt
      module_name: i2c0
      desc: i2c0 tx_threshold interrupt
      intr_type: IntrType.Status
      default_val: false
      incoming: false
      domain: Main
      plic: rv_plic
      outgoing: false
    }
    {
      name: i2c0_acq_stretch
      width: 1
      type: interrupt
      module_name: i2c0
      desc: i2c0 acq_stretch interrupt
      intr_type: IntrType.Status
      default_val: false
      incoming: false
      domain: Main
      plic: rv_plic
      outgoing: false
    }
    {
      name: i2c0_unexp_stop
      width: 1
      type: interrupt
      module_name: i2c0
      desc: i2c0 unexp_stop interrupt
      intr_type: IntrType.Event
      default_val: false
      incoming: false
      domain: Main
      plic: rv_plic
      outgoing: false
    }
    {
      name: i2c0_host_timeout
      width: 1
      type: interrupt
      module_name: i2c0
      desc: i2c0 host_timeout interrupt
      intr_type: IntrType.Event
      default_val: false
      incoming: false
      domain: Main
      plic: rv_plic
      outgoing: false
    }
    {
      name: rv_timer_timer_expired_hart0_timer0
      width: 1
      type: interrupt
      module_name: rv_timer
      desc: rv_timer timer_expired_hart0_timer0 interrupt
      intr_type: IntrType.Event
      default_val: false
      incoming: false
      domain: Main
      plic: rv_plic
      outgoing: false
    }
    {
      name: otp_ctrl_otp_operation_done
      width: 1
      type: interrupt
      module_name: otp_ctrl
      desc: otp_ctrl otp_operation_done interrupt
      intr_type: IntrType.Event
      default_val: false
      incoming: false
      domain: Main
      plic: rv_plic
      outgoing: false
    }
    {
      name: otp_ctrl_otp_error
      width: 1
      type: interrupt
      module_name: otp_ctrl
      desc: otp_ctrl otp_error interrupt
      intr_type: IntrType.Event
      default_val: false
      incoming: false
      domain: Main
      plic: rv_plic
      outgoing: false
    }
    {
      name: alert_handler_classa
      width: 1
      type: interrupt
      module_name: alert_handler
      desc: alert_handler classa interrupt
      intr_type: IntrType.Event
      default_val: false
      incoming: false
      domain: Main
      plic: rv_plic
      outgoing: false
    }
    {
      name: alert_handler_classb
      width: 1
      type: interrupt
      module_name: alert_handler
      desc: alert_handler classb interrupt
      intr_type: IntrType.Event
      default_val: false
      incoming: false
      domain: Main
      plic: rv_plic
      outgoing: false
    }
    {
      name: alert_handler_classc
      width: 1
      type: interrupt
      module_name: alert_handler
      desc: alert_handler classc interrupt
      intr_type: IntrType.Event
      default_val: false
      incoming: false
      domain: Main
      plic: rv_plic
      outgoing: false
    }
    {
      name: alert_handler_classd
      width: 1
      type: interrupt
      module_name: alert_handler
      desc: alert_handler classd interrupt
      intr_type: IntrType.Event
      default_val: false
      incoming: false
      domain: Main
      plic: rv_plic
      outgoing: false
    }
    {
      name: spi_host0_error
      width: 1
      type: interrupt
      module_name: spi_host0
      desc: spi_host0 error interrupt
      intr_type: IntrType.Event
      default_val: false
      incoming: false
      domain: Main
      plic: rv_plic
      outgoing: false
    }
    {
      name: spi_host0_spi_event
      width: 1
      type: interrupt
      module_name: spi_host0
      desc: spi_host0 spi_event interrupt
      intr_type: IntrType.Status
      default_val: false
      incoming: false
      domain: Main
      plic: rv_plic
      outgoing: false
    }
    {
      name: pwrmgr_wakeup
      width: 1
      type: interrupt
      module_name: pwrmgr
      desc: pwrmgr wakeup interrupt
      intr_type: IntrType.Event
      default_val: false
      incoming: false
      domain: Aon
      plic: rv_plic
      outgoing: false
    }
    {
      name: aon_timer_wkup_timer_expired
      width: 1
      type: interrupt
      module_name: aon_timer
      desc: aon_timer wkup_timer_expired interrupt
      intr_type: IntrType.Event
      default_val: false
      incoming: false
      domain: Aon
      plic: rv_plic
      outgoing: false
    }
    {
      name: aon_timer_wdog_timer_bark
      width: 1
      type: interrupt
      module_name: aon_timer
      desc: aon_timer wdog_timer_bark interrupt
      intr_type: IntrType.Event
      default_val: false
      incoming: false
      domain: Aon
      plic: rv_plic
      outgoing: false
    }
    {
      name: hmac_hmac_done
      width: 1
      type: interrupt
      module_name: hmac
      desc: hmac hmac_done interrupt
      intr_type: IntrType.Event
      default_val: false
      incoming: false
      domain: Main
      plic: rv_plic
      outgoing: false
    }
    {
      name: hmac_fifo_empty
      width: 1
      type: interrupt
      module_name: hmac
      desc: hmac fifo_empty interrupt
      intr_type: IntrType.Status
      default_val: false
      incoming: false
      domain: Main
      plic: rv_plic
      outgoing: false
    }
    {
      name: hmac_hmac_err
      width: 1
      type: interrupt
      module_name: hmac
      desc: hmac hmac_err interrupt
      intr_type: IntrType.Event
      default_val: false
      incoming: false
      domain: Main
      plic: rv_plic
      outgoing: false
    }
    {
      name: kmac_kmac_done
      width: 1
      type: interrupt
      module_name: kmac
      desc: kmac kmac_done interrupt
      intr_type: IntrType.Event
      default_val: false
      incoming: false
      domain: Main
      plic: rv_plic
      outgoing: false
    }
    {
      name: kmac_fifo_empty
      width: 1
      type: interrupt
      module_name: kmac
      desc: kmac fifo_empty interrupt
      intr_type: IntrType.Status
      default_val: false
      incoming: false
      domain: Main
      plic: rv_plic
      outgoing: false
    }
    {
      name: kmac_kmac_err
      width: 1
      type: interrupt
      module_name: kmac
      desc: kmac kmac_err interrupt
      intr_type: IntrType.Event
      default_val: false
      incoming: false
      domain: Main
      plic: rv_plic
      outgoing: false
    }
    {
      name: otbn_done
      width: 1
      type: interrupt
      module_name: otbn
      desc: otbn done interrupt
      intr_type: IntrType.Event
      default_val: false
      incoming: false
      domain: Main
      plic: rv_plic
      outgoing: false
    }
    {
      name: keymgr_dpe_op_done
      width: 1
      type: interrupt
      module_name: keymgr_dpe
      desc: keymgr_dpe op_done interrupt
      intr_type: IntrType.Event
      default_val: false
      incoming: false
      domain: Main
      plic: rv_plic
      outgoing: false
    }
    {
      name: csrng_cs_cmd_req_done
      width: 1
      type: interrupt
      module_name: csrng
      desc: csrng cs_cmd_req_done interrupt
      intr_type: IntrType.Event
      default_val: false
      incoming: false
      domain: Main
      plic: rv_plic
      outgoing: false
    }
    {
      name: csrng_cs_entropy_req
      width: 1
      type: interrupt
      module_name: csrng
      desc: csrng cs_entropy_req interrupt
      intr_type: IntrType.Event
      default_val: false
      incoming: false
      domain: Main
      plic: rv_plic
      outgoing: false
    }
    {
      name: csrng_cs_hw_inst_exc
      width: 1
      type: interrupt
      module_name: csrng
      desc: csrng cs_hw_inst_exc interrupt
      intr_type: IntrType.Event
      default_val: false
      incoming: false
      domain: Main
      plic: rv_plic
      outgoing: false
    }
    {
      name: csrng_cs_fatal_err
      width: 1
      type: interrupt
      module_name: csrng
      desc: csrng cs_fatal_err interrupt
      intr_type: IntrType.Event
      default_val: false
      incoming: false
      domain: Main
      plic: rv_plic
      outgoing: false
    }
    {
      name: entropy_src_es_entropy_valid
      width: 1
      type: interrupt
      module_name: entropy_src
      desc: entropy_src es_entropy_valid interrupt
      intr_type: IntrType.Event
      default_val: false
      incoming: false
      domain: Main
      plic: rv_plic
      outgoing: false
    }
    {
      name: entropy_src_es_health_test_failed
      width: 1
      type: interrupt
      module_name: entropy_src
      desc: entropy_src es_health_test_failed interrupt
      intr_type: IntrType.Event
      default_val: false
      incoming: false
      domain: Main
      plic: rv_plic
      outgoing: false
    }
    {
      name: entropy_src_es_observe_fifo_ready
      width: 1
      type: interrupt
      module_name: entropy_src
      desc: entropy_src es_observe_fifo_ready interrupt
      intr_type: IntrType.Event
      default_val: false
      incoming: false
      domain: Main
      plic: rv_plic
      outgoing: false
    }
    {
      name: entropy_src_es_fatal_err
      width: 1
      type: interrupt
      module_name: entropy_src
      desc: entropy_src es_fatal_err interrupt
      intr_type: IntrType.Event
      default_val: false
      incoming: false
      domain: Main
      plic: rv_plic
      outgoing: false
    }
    {
      name: edn0_edn_cmd_req_done
      width: 1
      type: interrupt
      module_name: edn0
      desc: edn0 edn_cmd_req_done interrupt
      intr_type: IntrType.Event
      default_val: false
      incoming: false
      domain: Main
      plic: rv_plic
      outgoing: false
    }
    {
      name: edn0_edn_fatal_err
      width: 1
      type: interrupt
      module_name: edn0
      desc: edn0 edn_fatal_err interrupt
      intr_type: IntrType.Event
      default_val: false
      incoming: false
      domain: Main
      plic: rv_plic
      outgoing: false
    }
    {
      name: edn1_edn_cmd_req_done
      width: 1
      type: interrupt
      module_name: edn1
      desc: edn1 edn_cmd_req_done interrupt
      intr_type: IntrType.Event
      default_val: false
      incoming: false
      domain: Main
      plic: rv_plic
      outgoing: false
    }
    {
      name: edn1_edn_fatal_err
      width: 1
      type: interrupt
      module_name: edn1
      desc: edn1 edn_fatal_err interrupt
      intr_type: IntrType.Event
      default_val: false
      incoming: false
      domain: Main
      plic: rv_plic
      outgoing: false
    }
    {
      name: dma_dma_done
      width: 1
      type: interrupt
      module_name: dma
      desc: dma dma_done interrupt
      intr_type: IntrType.Status
      default_val: false
      incoming: false
      domain: Main
      plic: rv_plic
      outgoing: false
    }
    {
      name: dma_dma_chunk_done
      width: 1
      type: interrupt
      module_name: dma
      desc: dma dma_chunk_done interrupt
      intr_type: IntrType.Status
      default_val: false
      incoming: false
      domain: Main
      plic: rv_plic
      outgoing: false
    }
    {
      name: dma_dma_error
      width: 1
      type: interrupt
      module_name: dma
      desc: dma dma_error interrupt
      intr_type: IntrType.Status
      default_val: false
      incoming: false
      domain: Main
      plic: rv_plic
      outgoing: false
    }
    {
      name: mbx0_mbx_ready
      width: 1
      type: interrupt
      module_name: mbx0
      desc: mbx0 mbx_ready interrupt
      intr_type: IntrType.Event
      default_val: false
      incoming: false
      domain: Main
      plic: rv_plic
      outgoing: false
    }
    {
      name: mbx0_mbx_abort
      width: 1
      type: interrupt
      module_name: mbx0
      desc: mbx0 mbx_abort interrupt
      intr_type: IntrType.Event
      default_val: false
      incoming: false
      domain: Main
      plic: rv_plic
      outgoing: false
    }
    {
      name: mbx0_mbx_error
      width: 1
      type: interrupt
      module_name: mbx0
      desc: mbx0 mbx_error interrupt
      intr_type: IntrType.Event
      default_val: false
      incoming: false
      domain: Main
      plic: rv_plic
      outgoing: false
    }
    {
      name: mbx1_mbx_ready
      width: 1
      type: interrupt
      module_name: mbx1
      desc: mbx1 mbx_ready interrupt
      intr_type: IntrType.Event
      default_val: false
      incoming: false
      domain: Main
      plic: rv_plic
      outgoing: false
    }
    {
      name: mbx1_mbx_abort
      width: 1
      type: interrupt
      module_name: mbx1
      desc: mbx1 mbx_abort interrupt
      intr_type: IntrType.Event
      default_val: false
      incoming: false
      domain: Main
      plic: rv_plic
      outgoing: false
    }
    {
      name: mbx1_mbx_error
      width: 1
      type: interrupt
      module_name: mbx1
      desc: mbx1 mbx_error interrupt
      intr_type: IntrType.Event
      default_val: false
      incoming: false
      domain: Main
      plic: rv_plic
      outgoing: false
    }
    {
      name: mbx2_mbx_ready
      width: 1
      type: interrupt
      module_name: mbx2
      desc: mbx2 mbx_ready interrupt
      intr_type: IntrType.Event
      default_val: false
      incoming: false
      domain: Main
      plic: rv_plic
      outgoing: false
    }
    {
      name: mbx2_mbx_abort
      width: 1
      type: interrupt
      module_name: mbx2
      desc: mbx2 mbx_abort interrupt
      intr_type: IntrType.Event
      default_val: false
      incoming: false
      domain: Main
      plic: rv_plic
      outgoing: false
    }
    {
      name: mbx2_mbx_error
      width: 1
      type: interrupt
      module_name: mbx2
      desc: mbx2 mbx_error interrupt
      intr_type: IntrType.Event
      default_val: false
      incoming: false
      domain: Main
      plic: rv_plic
      outgoing: false
    }
    {
      name: mbx3_mbx_ready
      width: 1
      type: interrupt
      module_name: mbx3
      desc: mbx3 mbx_ready interrupt
      intr_type: IntrType.Event
      default_val: false
      incoming: false
      domain: Main
      plic: rv_plic
      outgoing: false
    }
    {
      name: mbx3_mbx_abort
      width: 1
      type: interrupt
      module_name: mbx3
      desc: mbx3 mbx_abort interrupt
      intr_type: IntrType.Event
      default_val: false
      incoming: false
      domain: Main
      plic: rv_plic
      outgoing: false
    }
    {
      name: mbx3_mbx_error
      width: 1
      type: interrupt
      module_name: mbx3
      desc: mbx3 mbx_error interrupt
      intr_type: IntrType.Event
      default_val: false
      incoming: false
      domain: Main
      plic: rv_plic
      outgoing: false
    }
    {
      name: mbx4_mbx_ready
      width: 1
      type: interrupt
      module_name: mbx4
      desc: mbx4 mbx_ready interrupt
      intr_type: IntrType.Event
      default_val: false
      incoming: false
      domain: Main
      plic: rv_plic
      outgoing: false
    }
    {
      name: mbx4_mbx_abort
      width: 1
      type: interrupt
      module_name: mbx4
      desc: mbx4 mbx_abort interrupt
      intr_type: IntrType.Event
      default_val: false
      incoming: false
      domain: Main
      plic: rv_plic
      outgoing: false
    }
    {
      name: mbx4_mbx_error
      width: 1
      type: interrupt
      module_name: mbx4
      desc: mbx4 mbx_error interrupt
      intr_type: IntrType.Event
      default_val: false
      incoming: false
      domain: Main
      plic: rv_plic
      outgoing: false
    }
    {
      name: mbx5_mbx_ready
      width: 1
      type: interrupt
      module_name: mbx5
      desc: mbx5 mbx_ready interrupt
      intr_type: IntrType.Event
      default_val: false
      incoming: false
      domain: Main
      plic: rv_plic
      outgoing: false
    }
    {
      name: mbx5_mbx_abort
      width: 1
      type: interrupt
      module_name: mbx5
      desc: mbx5 mbx_abort interrupt
      intr_type: IntrType.Event
      default_val: false
      incoming: false
      domain: Main
      plic: rv_plic
      outgoing: false
    }
    {
      name: mbx5_mbx_error
      width: 1
      type: interrupt
      module_name: mbx5
      desc: mbx5 mbx_error interrupt
      intr_type: IntrType.Event
      default_val: false
      incoming: false
      domain: Main
      plic: rv_plic
      outgoing: false
    }
    {
      name: mbx6_mbx_ready
      width: 1
      type: interrupt
      module_name: mbx6
      desc: mbx6 mbx_ready interrupt
      intr_type: IntrType.Event
      default_val: false
      incoming: false
      domain: Main
      plic: rv_plic
      outgoing: false
    }
    {
      name: mbx6_mbx_abort
      width: 1
      type: interrupt
      module_name: mbx6
      desc: mbx6 mbx_abort interrupt
      intr_type: IntrType.Event
      default_val: false
      incoming: false
      domain: Main
      plic: rv_plic
      outgoing: false
    }
    {
      name: mbx6_mbx_error
      width: 1
      type: interrupt
      module_name: mbx6
      desc: mbx6 mbx_error interrupt
      intr_type: IntrType.Event
      default_val: false
      incoming: false
      domain: Main
      plic: rv_plic
      outgoing: false
    }
    {
      name: mbx_jtag_mbx_ready
      width: 1
      type: interrupt
      module_name: mbx_jtag
      desc: mbx_jtag mbx_ready interrupt
      intr_type: IntrType.Event
      default_val: false
      incoming: false
      domain: Main
      plic: rv_plic
      outgoing: false
    }
    {
      name: mbx_jtag_mbx_abort
      width: 1
      type: interrupt
      module_name: mbx_jtag
      desc: mbx_jtag mbx_abort interrupt
      intr_type: IntrType.Event
      default_val: false
      incoming: false
      domain: Main
      plic: rv_plic
      outgoing: false
    }
    {
      name: mbx_jtag_mbx_error
      width: 1
      type: interrupt
      module_name: mbx_jtag
      desc: mbx_jtag mbx_error interrupt
      intr_type: IntrType.Event
      default_val: false
      incoming: false
      domain: Main
      plic: rv_plic
      outgoing: false
    }
    {
      name: mbx_pcie0_mbx_ready
      width: 1
      type: interrupt
      module_name: mbx_pcie0
      desc: mbx_pcie0 mbx_ready interrupt
      intr_type: IntrType.Event
      default_val: false
      incoming: false
      domain: Main
      plic: rv_plic
      outgoing: false
    }
    {
      name: mbx_pcie0_mbx_abort
      width: 1
      type: interrupt
      module_name: mbx_pcie0
      desc: mbx_pcie0 mbx_abort interrupt
      intr_type: IntrType.Event
      default_val: false
      incoming: false
      domain: Main
      plic: rv_plic
      outgoing: false
    }
    {
      name: mbx_pcie0_mbx_error
      width: 1
      type: interrupt
      module_name: mbx_pcie0
      desc: mbx_pcie0 mbx_error interrupt
      intr_type: IntrType.Event
      default_val: false
      incoming: false
      domain: Main
      plic: rv_plic
      outgoing: false
    }
    {
      name: mbx_pcie1_mbx_ready
      width: 1
      type: interrupt
      module_name: mbx_pcie1
      desc: mbx_pcie1 mbx_ready interrupt
      intr_type: IntrType.Event
      default_val: false
      incoming: false
      domain: Main
      plic: rv_plic
      outgoing: false
    }
    {
      name: mbx_pcie1_mbx_abort
      width: 1
      type: interrupt
      module_name: mbx_pcie1
      desc: mbx_pcie1 mbx_abort interrupt
      intr_type: IntrType.Event
      default_val: false
      incoming: false
      domain: Main
      plic: rv_plic
      outgoing: false
    }
    {
      name: mbx_pcie1_mbx_error
      width: 1
      type: interrupt
      module_name: mbx_pcie1
      desc: mbx_pcie1 mbx_error interrupt
      intr_type: IntrType.Event
      default_val: false
      incoming: false
      domain: Main
      plic: rv_plic
      outgoing: false
    }
    {
      name: racl_ctrl_racl_error
      width: 1
      type: interrupt
      module_name: racl_ctrl
      desc: racl_ctrl racl_error interrupt
      intr_type: IntrType.Status
      default_val: false
      incoming: false
      domain: Main
      plic: rv_plic
      outgoing: false
    }
    {
      name: ac_range_check_deny_cnt_reached
      width: 1
      type: interrupt
      module_name: ac_range_check
      desc: ac_range_check deny_cnt_reached interrupt
      intr_type: IntrType.Status
      default_val: false
      incoming: false
      domain: Main
      plic: rv_plic
      outgoing: false
    }
  ]
  outgoing_interrupt: {}
  plic_info:
  {
    rv_plic:
    {
      domain: Main
      count_tot: 132
      count_pd:
      {
        Aon: 3
        Main: 128
      }
    }
  }
  inter_pd:
  {
    definitions:
    [
      {
        package: ""
        struct: logic
        domain: chip
        signame: intr_vector_pd_aon
        width: 3
        type: uni
        special: interrupt
        end_idx: -1
        act: req
        suffix: ""
        default: "'0"
      }
      {
        package: prim_alert_pkg
        struct: alert_tx
        domain: chip
        signame: alert_tx_pd_aon
        width: 8
        type: uni
        special: alert
        end_idx: -1
        act: req
        suffix: ""
        default: "'0"
      }
      {
        package: prim_alert_pkg
        struct: alert_rx
        domain: chip
        signame: alert_rx_pd_aon
        width: 8
        type: uni
        special: alert
        end_idx: -1
        act: req
        suffix: ""
        default: "'0"
      }
      {
        package: alert_handler_pkg
        struct: alert_crashdump
        domain: chip
        signame: alert_handler_crashdump
        width: 1
        type: uni
        end_idx: -1
        act: req
        suffix: ""
        default: alert_handler_pkg::ALERT_CRASHDUMP_DEFAULT
      }
      {
        package: prim_esc_pkg
        struct: esc_rx
        domain: chip
        signame: alert_handler_esc_rx
        width: 1
        type: uni
        end_idx: -1
        act: rcv
        suffix: ""
        default: "{4{prim_esc_pkg::ESC_RX_DEFAULT}}"
      }
      {
        package: prim_esc_pkg
        struct: esc_tx
        domain: chip
        signame: alert_handler_esc_tx
        width: 1
        type: uni
        end_idx: -1
        act: req
        suffix: ""
        default: "{4{prim_esc_pkg::ESC_TX_DEFAULT}}"
      }
      {
        package: ""
        struct: logic
        domain: chip
        signame: aon_timer_nmi_wdog_timer_bark
        width: 1
        type: uni
        end_idx: -1
        act: req
        suffix: ""
        default: 1'b0
      }
      {
        package: otp_ctrl_pkg
        struct: sram_otp_key_req
        domain: chip
        signame: otp_ctrl_sram_otp_key_req
        width: 1
        type: req_rsp
        end_idx: -1
        act: rsp
        suffix: req
        default: "'0"
      }
      {
        package: otp_ctrl_pkg
        struct: sram_otp_key_rsp
        domain: chip
        signame: otp_ctrl_sram_otp_key_rsp
        width: 1
        type: req_rsp
        end_idx: -1
        act: rsp
        suffix: rsp
        default: "'0"
      }
      {
        package: pwrmgr_pkg
        struct: pwr_otp_req
        domain: chip
        signame: pwrmgr_pwr_otp_req
        width: 1
        type: req_rsp
        end_idx: -1
        act: req
        suffix: req
        default: pwrmgr_pkg::PWR_OTP_REQ_DEFAULT
      }
      {
        package: pwrmgr_pkg
        struct: pwr_otp_rsp
        domain: chip
        signame: pwrmgr_pwr_otp_rsp
        width: 1
        type: req_rsp
        end_idx: -1
        act: req
        suffix: rsp
        default: pwrmgr_pkg::PWR_OTP_RSP_DEFAULT
      }
      {
        package: lc_ctrl_pkg
        struct: pwr_lc_req
        domain: chip
        signame: pwrmgr_pwr_lc_req
        width: 1
        type: req_rsp
        end_idx: -1
        act: req
        suffix: req
        default: lc_ctrl_pkg::PWR_LC_REQ_DEFAULT
      }
      {
        package: lc_ctrl_pkg
        struct: pwr_lc_rsp
        domain: chip
        signame: pwrmgr_pwr_lc_rsp
        width: 1
        type: req_rsp
        end_idx: -1
        act: req
        suffix: rsp
        default: lc_ctrl_pkg::PWR_LC_RSP_DEFAULT
      }
      {
        package: ""
        struct: logic
        domain: chip
        signame: pwrmgr_strap
        width: 1
        type: uni
        end_idx: -1
        act: req
        suffix: ""
        default: 1'b0
      }
      {
        package: ""
        struct: logic
        domain: chip
        signame: pwrmgr_low_power
        width: 1
        type: uni
        end_idx: -1
        act: req
        suffix: ""
        default: 1'b0
      }
      {
        package: lc_ctrl_pkg
        struct: lc_tx
        domain: chip
        signame: pwrmgr_fetch_en
        width: 1
        type: uni
        end_idx: -1
        act: req
        suffix: ""
        default: lc_ctrl_pkg::LC_TX_DEFAULT
      }
      {
        package: rom_ctrl_pkg
        struct: pwrmgr_data
        domain: chip
        signame: pwrmgr_rom_ctrl
        width: 3
        type: uni
        end_idx: -1
        act: rcv
        suffix: ""
        default: rom_ctrl_pkg::PWRMGR_DATA_DEFAULT
      }
      {
        package: pwrmgr_pkg
        struct: pwr_boot_status
        domain: chip
        signame: pwrmgr_boot_status
        width: 1
        type: uni
        end_idx: -1
        act: req
        suffix: ""
        default: pwrmgr_pkg::PWR_BOOT_STATUS_DEFAULT
      }
      {
        package: dma_pkg
        struct: lsio_trigger
        domain: chip
        signame: dma_lsio_trigger
        width: 1
        type: uni
        end_idx: -1
        act: rcv
        suffix: ""
        default: dma_pkg::LSIO_TRIGGER_DEFAULT
      }
      {
        package: ""
        struct: logic
        domain: chip
        signame: i2c0_lsio_trigger
        width: 1
        type: uni
        end_idx: -1
        act: req
        suffix: ""
        default: 1'b0
      }
      {
        package: ""
        struct: logic
        domain: chip
        signame: spi_host0_lsio_trigger
        width: 1
        type: uni
        end_idx: -1
        act: req
        suffix: ""
        default: 1'b0
      }
      {
        package: ""
        struct: logic
        domain: chip
        signame: uart0_lsio_trigger
        width: 1
        type: uni
        end_idx: -1
        act: req
        suffix: ""
        default: 1'b0
      }
      {
        package: prim_mubi_pkg
        struct: mubi4
        domain: chip
        signame: clkmgr_idle
        width: 4
        type: uni
        end_idx: -1
        act: rcv
        suffix: ""
        default: "{4{prim_mubi_pkg::MUBI4_DEFAULT}}"
      }
      {
        package: lc_ctrl_pkg
        struct: lc_tx
        domain: chip
        signame: lc_ctrl_lc_dft_en
        width: 1
        type: uni
        end_idx: -1
        act: req
        suffix: ""
        default: lc_ctrl_pkg::Off
      }
      {
        package: lc_ctrl_pkg
        struct: lc_tx
        domain: chip
        signame: lc_ctrl_lc_hw_debug_en
        width: 1
        type: uni
        end_idx: -1
        act: req
        suffix: ""
        default: lc_ctrl_pkg::Off
      }
      {
        package: lc_ctrl_pkg
        struct: lc_tx
        domain: chip
        signame: lc_ctrl_lc_escalate_en
        width: 1
        type: uni
        end_idx: -1
        act: req
        suffix: ""
        default: lc_ctrl_pkg::Off
      }
      {
        package: rv_core_ibex_pkg
        struct: cpu_crash_dump
        domain: chip
        signame: rv_core_ibex_crash_dump
        width: 1
        type: uni
        end_idx: -1
        act: req
        suffix: ""
        default: rv_core_ibex_pkg::CPU_CRASH_DUMP_DEFAULT
      }
      {
        package: rv_core_ibex_pkg
        struct: cpu_pwrmgr
        domain: chip
        signame: rv_core_ibex_pwrmgr
        width: 1
        type: uni
        end_idx: -1
        act: req
        suffix: ""
        default: rv_core_ibex_pkg::CPU_PWRMGR_DEFAULT
      }
      {
        package: ""
        struct: logic
        domain: chip
        signame: rv_dm_ndmreset_req
        width: 1
        type: uni
        end_idx: -1
        act: req
        suffix: ""
        default: 1'b0
      }
      {
        package: tlul_pkg
        struct: tl_h2d
        domain: chip
        signame: soc_proxy_dma_tl_h2d
        width: 1
        type: uni
        end_idx: -1
        act: rcv
        suffix: ""
        default: tlul_pkg::TL_H2D_DEFAULT
      }
      {
        package: tlul_pkg
        struct: tl_d2h
        domain: chip
        signame: soc_proxy_dma_tl_d2h
        width: 1
        type: uni
        end_idx: -1
        act: req
        suffix: ""
        default: tlul_pkg::TL_D2H_DEFAULT
      }
      {
        package: tlul_pkg
        struct: tl_h2d
        domain: chip
        signame: soc_proxy_ctn_tl_h2d
        width: 1
        type: uni
        end_idx: -1
        act: req
        suffix: ""
        default: tlul_pkg::TL_H2D_DEFAULT
      }
      {
        package: tlul_pkg
        struct: tl_d2h
        domain: chip
        signame: soc_proxy_ctn_tl_d2h
        width: 1
        type: uni
        end_idx: -1
        act: rcv
        suffix: ""
        default: tlul_pkg::TL_D2H_DEFAULT
      }
      {
        package: ""
        struct: logic
        domain: chip
        signame: pwrmgr_wakeups
        width: 1
        type: uni
        end_idx: -1
        act: rcv
        suffix: ""
        default: "'0"
      }
      {
        package: tlul_pkg
        struct: tl_h2d
        domain: chip
        signame: soc_proxy_core_tl_req
        width: 1
        type: req_rsp
        end_idx: -1
        act: rsp
        suffix: req
        default: tlul_pkg::TL_H2D_DEFAULT
      }
      {
        package: tlul_pkg
        struct: tl_d2h
        domain: chip
        signame: soc_proxy_core_tl_rsp
        width: 1
        type: req_rsp
        end_idx: -1
        act: rsp
        suffix: rsp
        default: tlul_pkg::TL_D2H_DEFAULT
      }
      {
        package: tlul_pkg
        struct: tl_h2d
        domain: chip
        signame: soc_proxy_ctn_tl_req
        width: 1
        type: req_rsp
        end_idx: -1
        act: rsp
        suffix: req
        default: tlul_pkg::TL_H2D_DEFAULT
      }
      {
        package: tlul_pkg
        struct: tl_d2h
        domain: chip
        signame: soc_proxy_ctn_tl_rsp
        width: 1
        type: req_rsp
        end_idx: -1
        act: rsp
        suffix: rsp
        default: tlul_pkg::TL_D2H_DEFAULT
      }
      {
        package: tlul_pkg
        struct: tl_h2d
        domain: chip
        signame: pwrmgr_tl_req
        width: 1
        type: req_rsp
        end_idx: -1
        act: rsp
        suffix: req
        default: tlul_pkg::TL_H2D_DEFAULT
      }
      {
        package: tlul_pkg
        struct: tl_d2h
        domain: chip
        signame: pwrmgr_tl_rsp
        width: 1
        type: req_rsp
        end_idx: -1
        act: rsp
        suffix: rsp
        default: tlul_pkg::TL_D2H_DEFAULT
      }
      {
        package: tlul_pkg
        struct: tl_h2d
        domain: chip
        signame: rstmgr_tl_req
        width: 1
        type: req_rsp
        end_idx: -1
        act: rsp
        suffix: req
        default: tlul_pkg::TL_H2D_DEFAULT
      }
      {
        package: tlul_pkg
        struct: tl_d2h
        domain: chip
        signame: rstmgr_tl_rsp
        width: 1
        type: req_rsp
        end_idx: -1
        act: rsp
        suffix: rsp
        default: tlul_pkg::TL_D2H_DEFAULT
      }
      {
        package: tlul_pkg
        struct: tl_h2d
        domain: chip
        signame: clkmgr_tl_req
        width: 1
        type: req_rsp
        end_idx: -1
        act: rsp
        suffix: req
        default: tlul_pkg::TL_H2D_DEFAULT
      }
      {
        package: tlul_pkg
        struct: tl_d2h
        domain: chip
        signame: clkmgr_tl_rsp
        width: 1
        type: req_rsp
        end_idx: -1
        act: rsp
        suffix: rsp
        default: tlul_pkg::TL_D2H_DEFAULT
      }
      {
        package: tlul_pkg
        struct: tl_h2d
        domain: chip
        signame: sram_ctrl_ret_regs_tl_req
        width: 1
        type: req_rsp
        end_idx: -1
        act: rsp
        suffix: req
        default: tlul_pkg::TL_H2D_DEFAULT
      }
      {
        package: tlul_pkg
        struct: tl_d2h
        domain: chip
        signame: sram_ctrl_ret_regs_tl_rsp
        width: 1
        type: req_rsp
        end_idx: -1
        act: rsp
        suffix: rsp
        default: tlul_pkg::TL_D2H_DEFAULT
      }
      {
        package: tlul_pkg
        struct: tl_h2d
        domain: chip
        signame: sram_ctrl_ret_ram_tl_req
        width: 1
        type: req_rsp
        end_idx: -1
        act: rsp
        suffix: req
        default: tlul_pkg::TL_H2D_DEFAULT
      }
      {
        package: tlul_pkg
        struct: tl_d2h
        domain: chip
        signame: sram_ctrl_ret_ram_tl_rsp
        width: 1
        type: req_rsp
        end_idx: -1
        act: rsp
        suffix: rsp
        default: tlul_pkg::TL_D2H_DEFAULT
      }
      {
        package: tlul_pkg
        struct: tl_h2d
        domain: chip
        signame: aon_timer_tl_req
        width: 1
        type: req_rsp
        end_idx: -1
        act: rsp
        suffix: req
        default: tlul_pkg::TL_H2D_DEFAULT
      }
      {
        package: tlul_pkg
        struct: tl_d2h
        domain: chip
        signame: aon_timer_tl_rsp
        width: 1
        type: req_rsp
        end_idx: -1
        act: rsp
        suffix: rsp
        default: tlul_pkg::TL_D2H_DEFAULT
      }
      {
        package: ""
        struct: logic
        domain: chip
        signame: cio_soc_proxy_soc_gpi_p2d
        width: 16
        type: uni
        end_idx: -1
        act: ""
        suffix: ""
        default: "'0"
      }
      {
        package: ""
        struct: logic
        domain: chip
        signame: cio_soc_proxy_soc_gpo_d2p
        width: 16
        type: uni
        end_idx: -1
        act: ""
        suffix: ""
        default: "'0"
      }
      {
        package: ""
        struct: logic
        domain: chip
        signame: cio_soc_proxy_soc_gpo_en_d2p
        width: 16
        type: uni
        end_idx: -1
        act: ""
        suffix: ""
        default: "'0"
      }
    ]
  }
  alert_module:
  [
    uart0
    gpio0
    spi_device
    i2c0
    rv_timer
    otp_ctrl
    lc_ctrl
    spi_host0
    pwrmgr
    rstmgr
    clkmgr
    pinmux
    aon_timer
    soc_proxy
    sram_ctrl_ret
    rv_dm
    rv_plic
    aes
    hmac
    kmac
    otbn
    keymgr_dpe
    csrng
    entropy_src
    edn0
    edn1
    sram_ctrl_main
    sram_ctrl_mbox
    rom_ctrl0
    rom_ctrl1
    dma
    mbx0
    mbx1
    mbx2
    mbx3
    mbx4
    mbx5
    mbx6
    mbx_jtag
    mbx_pcie0
    mbx_pcie1
    soc_dbg_ctrl
    racl_ctrl
    ac_range_check
    rv_core_ibex
  ]
  alert_connections:
  {
    module_uart0:
    {
      tx_expr: alert_tx[0]
      rx_expr: alert_rx[0]
      async_expr: alert_handler_reg_pkg::AsyncOn[0]
      comments:
      [
        alert_handler[0]: fatal_fault
      ]
    }
    module_gpio0:
    {
      tx_expr: alert_tx[1]
      rx_expr: alert_rx[1]
      async_expr: alert_handler_reg_pkg::AsyncOn[1]
      comments:
      [
        alert_handler[1]: fatal_fault
      ]
    }
    module_spi_device:
    {
      tx_expr: alert_tx[2]
      rx_expr: alert_rx[2]
      async_expr: alert_handler_reg_pkg::AsyncOn[2]
      comments:
      [
        alert_handler[2]: fatal_fault
      ]
    }
    module_i2c0:
    {
      tx_expr: alert_tx[3]
      rx_expr: alert_rx[3]
      async_expr: alert_handler_reg_pkg::AsyncOn[3]
      comments:
      [
        alert_handler[3]: fatal_fault
      ]
    }
    module_rv_timer:
    {
      tx_expr: alert_tx[4]
      rx_expr: alert_rx[4]
      async_expr: alert_handler_reg_pkg::AsyncOn[4]
      comments:
      [
        alert_handler[4]: fatal_fault
      ]
    }
    module_otp_ctrl:
    {
      tx_expr: alert_tx[9:5]
      rx_expr: alert_rx[9:5]
      async_expr: alert_handler_reg_pkg::AsyncOn[9:5]
      comments:
      [
        alert_handler[5]: fatal_macro_error
        alert_handler[6]: fatal_check_error
        alert_handler[7]: fatal_bus_integ_error
        alert_handler[8]: fatal_prim_otp_alert
        alert_handler[9]: recov_prim_otp_alert
      ]
    }
    module_lc_ctrl:
    {
      tx_expr: alert_tx[12:10]
      rx_expr: alert_rx[12:10]
      async_expr: alert_handler_reg_pkg::AsyncOn[12:10]
      comments:
      [
        alert_handler[10]: fatal_prog_error
        alert_handler[11]: fatal_state_error
        alert_handler[12]: fatal_bus_integ_error
      ]
    }
    module_spi_host0:
    {
      tx_expr: alert_tx[13]
      rx_expr: alert_rx[13]
      async_expr: alert_handler_reg_pkg::AsyncOn[13]
      comments:
      [
        alert_handler[13]: fatal_fault
      ]
    }
    module_pwrmgr:
    {
      tx_expr: alert_tx_o[0]
      rx_expr: alert_rx_i[0]
      async_expr: alert_handler_reg_pkg::AsyncOn[14]
      comments:
      [
        alert_handler[14]: fatal_fault
      ]
    }
    module_rstmgr:
    {
      tx_expr: alert_tx_o[2:1]
      rx_expr: alert_rx_i[2:1]
      async_expr: alert_handler_reg_pkg::AsyncOn[16:15]
      comments:
      [
        alert_handler[15]: fatal_fault
        alert_handler[16]: fatal_cnsty_fault
      ]
    }
    module_clkmgr:
    {
      tx_expr: alert_tx_o[4:3]
      rx_expr: alert_rx_i[4:3]
      async_expr: alert_handler_reg_pkg::AsyncOn[18:17]
      comments:
      [
        alert_handler[17]: recov_fault
        alert_handler[18]: fatal_fault
      ]
    }
    module_pinmux:
    {
      tx_expr: alert_tx[19]
      rx_expr: alert_rx[19]
      async_expr: alert_handler_reg_pkg::AsyncOn[19]
      comments:
      [
        alert_handler[19]: fatal_fault
      ]
    }
    module_aon_timer:
    {
      tx_expr: alert_tx_o[5]
      rx_expr: alert_rx_i[5]
      async_expr: alert_handler_reg_pkg::AsyncOn[20]
      comments:
      [
        alert_handler[20]: fatal_fault
      ]
    }
    module_soc_proxy:
    {
      tx_expr: alert_tx_o[6]
      rx_expr: alert_rx_i[6]
      async_expr: alert_handler_reg_pkg::AsyncOn[21]
      comments:
      [
        alert_handler[21]: fatal_alert_intg
      ]
    }
    module_sram_ctrl_ret:
    {
      tx_expr: alert_tx_o[7]
      rx_expr: alert_rx_i[7]
      async_expr: alert_handler_reg_pkg::AsyncOn[22]
      comments:
      [
        alert_handler[22]: fatal_error
      ]
    }
    module_rv_dm:
    {
      tx_expr: alert_tx[23]
      rx_expr: alert_rx[23]
      async_expr: alert_handler_reg_pkg::AsyncOn[23]
      comments:
      [
        alert_handler[23]: fatal_fault
      ]
    }
    module_rv_plic:
    {
      tx_expr: alert_tx[24]
      rx_expr: alert_rx[24]
      async_expr: alert_handler_reg_pkg::AsyncOn[24]
      comments:
      [
        alert_handler[24]: fatal_fault
      ]
    }
    module_aes:
    {
      tx_expr: alert_tx[26:25]
      rx_expr: alert_rx[26:25]
      async_expr: alert_handler_reg_pkg::AsyncOn[26:25]
      comments:
      [
        alert_handler[25]: recov_ctrl_update_err
        alert_handler[26]: fatal_fault
      ]
    }
    module_hmac:
    {
      tx_expr: alert_tx[27]
      rx_expr: alert_rx[27]
      async_expr: alert_handler_reg_pkg::AsyncOn[27]
      comments:
      [
        alert_handler[27]: fatal_fault
      ]
    }
    module_kmac:
    {
      tx_expr: alert_tx[29:28]
      rx_expr: alert_rx[29:28]
      async_expr: alert_handler_reg_pkg::AsyncOn[29:28]
      comments:
      [
        alert_handler[28]: recov_operation_err
        alert_handler[29]: fatal_fault_err
      ]
    }
    module_otbn:
    {
      tx_expr: alert_tx[31:30]
      rx_expr: alert_rx[31:30]
      async_expr: alert_handler_reg_pkg::AsyncOn[31:30]
      comments:
      [
        alert_handler[30]: fatal
        alert_handler[31]: recov
      ]
    }
    module_keymgr_dpe:
    {
      tx_expr: alert_tx[33:32]
      rx_expr: alert_rx[33:32]
      async_expr: alert_handler_reg_pkg::AsyncOn[33:32]
      comments:
      [
        alert_handler[32]: recov_operation_err
        alert_handler[33]: fatal_fault_err
      ]
    }
    module_csrng:
    {
      tx_expr: alert_tx[35:34]
      rx_expr: alert_rx[35:34]
      async_expr: alert_handler_reg_pkg::AsyncOn[35:34]
      comments:
      [
        alert_handler[34]: recov_alert
        alert_handler[35]: fatal_alert
      ]
    }
    module_entropy_src:
    {
      tx_expr: alert_tx[37:36]
      rx_expr: alert_rx[37:36]
      async_expr: alert_handler_reg_pkg::AsyncOn[37:36]
      comments:
      [
        alert_handler[36]: recov_alert
        alert_handler[37]: fatal_alert
      ]
    }
    module_edn0:
    {
      tx_expr: alert_tx[39:38]
      rx_expr: alert_rx[39:38]
      async_expr: alert_handler_reg_pkg::AsyncOn[39:38]
      comments:
      [
        alert_handler[38]: recov_alert
        alert_handler[39]: fatal_alert
      ]
    }
    module_edn1:
    {
      tx_expr: alert_tx[41:40]
      rx_expr: alert_rx[41:40]
      async_expr: alert_handler_reg_pkg::AsyncOn[41:40]
      comments:
      [
        alert_handler[40]: recov_alert
        alert_handler[41]: fatal_alert
      ]
    }
    module_sram_ctrl_main:
    {
      tx_expr: alert_tx[42]
      rx_expr: alert_rx[42]
      async_expr: alert_handler_reg_pkg::AsyncOn[42]
      comments:
      [
        alert_handler[42]: fatal_error
      ]
    }
    module_sram_ctrl_mbox:
    {
      tx_expr: alert_tx[43]
      rx_expr: alert_rx[43]
      async_expr: alert_handler_reg_pkg::AsyncOn[43]
      comments:
      [
        alert_handler[43]: fatal_error
      ]
    }
    module_rom_ctrl0:
    {
      tx_expr: alert_tx[44]
      rx_expr: alert_rx[44]
      async_expr: alert_handler_reg_pkg::AsyncOn[44]
      comments:
      [
        alert_handler[44]: fatal
      ]
    }
    module_rom_ctrl1:
    {
      tx_expr: alert_tx[45]
      rx_expr: alert_rx[45]
      async_expr: alert_handler_reg_pkg::AsyncOn[45]
      comments:
      [
        alert_handler[45]: fatal
      ]
    }
    module_dma:
    {
      tx_expr: alert_tx[46]
      rx_expr: alert_rx[46]
      async_expr: alert_handler_reg_pkg::AsyncOn[46]
      comments:
      [
        alert_handler[46]: fatal_fault
      ]
    }
    module_mbx0:
    {
      tx_expr: alert_tx[48:47]
      rx_expr: alert_rx[48:47]
      async_expr: alert_handler_reg_pkg::AsyncOn[48:47]
      comments:
      [
        alert_handler[47]: fatal_fault
        alert_handler[48]: recov_fault
      ]
    }
    module_mbx1:
    {
      tx_expr: alert_tx[50:49]
      rx_expr: alert_rx[50:49]
      async_expr: alert_handler_reg_pkg::AsyncOn[50:49]
      comments:
      [
        alert_handler[49]: fatal_fault
        alert_handler[50]: recov_fault
      ]
    }
    module_mbx2:
    {
      tx_expr: alert_tx[52:51]
      rx_expr: alert_rx[52:51]
      async_expr: alert_handler_reg_pkg::AsyncOn[52:51]
      comments:
      [
        alert_handler[51]: fatal_fault
        alert_handler[52]: recov_fault
      ]
    }
    module_mbx3:
    {
      tx_expr: alert_tx[54:53]
      rx_expr: alert_rx[54:53]
      async_expr: alert_handler_reg_pkg::AsyncOn[54:53]
      comments:
      [
        alert_handler[53]: fatal_fault
        alert_handler[54]: recov_fault
      ]
    }
    module_mbx4:
    {
      tx_expr: alert_tx[56:55]
      rx_expr: alert_rx[56:55]
      async_expr: alert_handler_reg_pkg::AsyncOn[56:55]
      comments:
      [
        alert_handler[55]: fatal_fault
        alert_handler[56]: recov_fault
      ]
    }
    module_mbx5:
    {
      tx_expr: alert_tx[58:57]
      rx_expr: alert_rx[58:57]
      async_expr: alert_handler_reg_pkg::AsyncOn[58:57]
      comments:
      [
        alert_handler[57]: fatal_fault
        alert_handler[58]: recov_fault
      ]
    }
    module_mbx6:
    {
      tx_expr: alert_tx[60:59]
      rx_expr: alert_rx[60:59]
      async_expr: alert_handler_reg_pkg::AsyncOn[60:59]
      comments:
      [
        alert_handler[59]: fatal_fault
        alert_handler[60]: recov_fault
      ]
    }
    module_mbx_jtag:
    {
      tx_expr: alert_tx[62:61]
      rx_expr: alert_rx[62:61]
      async_expr: alert_handler_reg_pkg::AsyncOn[62:61]
      comments:
      [
        alert_handler[61]: fatal_fault
        alert_handler[62]: recov_fault
      ]
    }
    module_mbx_pcie0:
    {
      tx_expr: alert_tx[64:63]
      rx_expr: alert_rx[64:63]
      async_expr: alert_handler_reg_pkg::AsyncOn[64:63]
      comments:
      [
        alert_handler[63]: fatal_fault
        alert_handler[64]: recov_fault
      ]
    }
    module_mbx_pcie1:
    {
      tx_expr: alert_tx[66:65]
      rx_expr: alert_rx[66:65]
      async_expr: alert_handler_reg_pkg::AsyncOn[66:65]
      comments:
      [
        alert_handler[65]: fatal_fault
        alert_handler[66]: recov_fault
      ]
    }
    module_soc_dbg_ctrl:
    {
      tx_expr: alert_tx[68:67]
      rx_expr: alert_rx[68:67]
      async_expr: alert_handler_reg_pkg::AsyncOn[68:67]
      comments:
      [
        alert_handler[67]: fatal_fault
        alert_handler[68]: recov_ctrl_update_err
      ]
    }
    module_racl_ctrl:
    {
      tx_expr: alert_tx[70:69]
      rx_expr: alert_rx[70:69]
      async_expr: alert_handler_reg_pkg::AsyncOn[70:69]
      comments:
      [
        alert_handler[69]: fatal_fault
        alert_handler[70]: recov_ctrl_update_err
      ]
    }
    module_ac_range_check:
    {
      tx_expr: alert_tx[72:71]
      rx_expr: alert_rx[72:71]
      async_expr: alert_handler_reg_pkg::AsyncOn[72:71]
      comments:
      [
        alert_handler[71]: recov_ctrl_update_err
        alert_handler[72]: fatal_fault
      ]
    }
    module_rv_core_ibex:
    {
      tx_expr: alert_tx[76:73]
      rx_expr: alert_rx[76:73]
      async_expr: alert_handler_reg_pkg::AsyncOn[76:73]
      comments:
      [
        alert_handler[73]: fatal_sw_err
        alert_handler[74]: recov_sw_err
        alert_handler[75]: fatal_hw_err
        alert_handler[76]: recov_hw_err
      ]
    }
  }
  alert_handler_info:
  {
    alert_handler:
    {
      domain: Main
      count_tot: 77
      count_pd:
      {
        Aon: 8
        Main: 69
      }
      connect_pd:
      {
        14:
        {
          src_pd: Aon
          idx: 0
        }
        15:
        {
          src_pd: Aon
          idx: 1
        }
        16:
        {
          src_pd: Aon
          idx: 2
        }
        17:
        {
          src_pd: Aon
          idx: 3
        }
        18:
        {
          src_pd: Aon
          idx: 4
        }
        20:
        {
          src_pd: Aon
          idx: 5
        }
        21:
        {
          src_pd: Aon
          idx: 6
        }
        22:
        {
          src_pd: Aon
          idx: 7
        }
      }
    }
  }
  interrupt_module:
  [
    uart0
    gpio0
    spi_device
    i2c0
    rv_timer
    otp_ctrl
    alert_handler
    spi_host0
    pwrmgr
    aon_timer
    hmac
    kmac
    otbn
    keymgr_dpe
    csrng
    entropy_src
    edn0
    edn1
    dma
    mbx0
    mbx1
    mbx2
    mbx3
    mbx4
    mbx5
    mbx6
    mbx_jtag
    mbx_pcie0
    mbx_pcie1
    racl_ctrl
    ac_range_check
  ]
  outgoing_alert_module: {}
  outgoing_interrupt_module: {}
  alert_lpgs:
  [
    {
      name: peri_lc_io_Main
      clock_group:
      {
        name: peri
        src: top
        sw_cg: yes
        unique: no
        clocks:
        {
          clk_io_peri: io
        }
      }
      clock_connection: clkmgr_clocks_i.clk_io_peri
      unmanaged_clock: false
      unmanaged_reset: false
      reset_connection:
      {
        name: lc_io
        domain: Main
      }
    }
    {
      name: peri_spi_device_Main
      clock_group:
      {
        name: peri
        src: top
        sw_cg: yes
        unique: no
        clocks:
        {
          clk_io_peri: io
        }
      }
      clock_connection: clkmgr_clocks_i.clk_io_peri
      unmanaged_clock: false
      unmanaged_reset: false
      reset_connection:
      {
        name: spi_device
        domain: Main
      }
    }
    {
      name: peri_i2c0_Main
      clock_group:
      {
        name: peri
        src: top
        sw_cg: yes
        unique: no
        clocks:
        {
          clk_io_peri: io
        }
      }
      clock_connection: clkmgr_clocks_i.clk_io_peri
      unmanaged_clock: false
      unmanaged_reset: false
      reset_connection:
      {
        name: i2c0
        domain: Main
      }
    }
    {
      name: timers_lc_io_Main
      clock_group:
      {
        name: timers
        src: top
        sw_cg: no
        unique: no
        clocks:
        {
          clk_io_timers: io
          clk_aon_timers: aon
        }
      }
      clock_connection: clkmgr_clocks_i.clk_io_timers
      unmanaged_clock: false
      unmanaged_reset: false
      reset_connection:
      {
        name: lc_io
        domain: Main
      }
    }
    {
      name: secure_lc_io_Main
      clock_group:
      {
        name: secure
        src: top
        sw_cg: no
        unique: no
        clocks:
        {
          clk_io_secure: io
          clk_main_secure: main
        }
      }
      clock_connection: clkmgr_clocks_i.clk_io_secure
      unmanaged_clock: false
      unmanaged_reset: false
      reset_connection:
      {
        name: lc_io
        domain: Main
      }
    }
    {
      name: peri_spi_host0_Main
      clock_group:
      {
        name: peri
        src: top
        sw_cg: yes
        unique: no
        clocks:
        {
          clk_io_peri: io
        }
      }
      clock_connection: clkmgr_clocks_i.clk_io_peri
      unmanaged_clock: false
      unmanaged_reset: false
      reset_connection:
      {
        name: spi_host0
        domain: Main
      }
    }
    {
      name: powerup_por_io_Aon
      clock_group:
      {
        name: powerup
        src: top
        sw_cg: no
        unique: no
        clocks:
        {
          clk_io_powerup: io
          clk_aon_powerup: aon
          clk_main_powerup: main
        }
      }
      clock_connection: clkmgr_clocks.clk_io_powerup
      unmanaged_clock: false
      unmanaged_reset: false
      reset_connection:
      {
        name: por_io
        domain: Aon
      }
    }
    {
      name: powerup_lc_io_Aon
      clock_group:
      {
        name: powerup
        src: top
        sw_cg: no
        unique: no
        clocks:
        {
          clk_io_powerup: io
          clk_aon_powerup: aon
          clk_main_powerup: main
        }
      }
      clock_connection: clkmgr_clocks.clk_io_powerup
      unmanaged_clock: false
      unmanaged_reset: false
      reset_connection:
      {
        name: lc_io
        domain: Aon
      }
    }
    {
      name: timers_lc_io_Aon
      clock_group:
      {
        name: timers
        src: top
        sw_cg: no
        unique: no
        clocks:
        {
          clk_io_timers: io
          clk_aon_timers: aon
        }
      }
      clock_connection: clkmgr_clocks.clk_io_timers
      unmanaged_clock: false
      unmanaged_reset: false
      reset_connection:
      {
        name: lc_io
        domain: Aon
      }
    }
    {
      name: infra_lc_io_Main
      clock_group:
      {
        name: infra
        src: top
        sw_cg: no
        unique: no
        clocks:
        {
          clk_io_infra: io
          clk_main_infra: main
          clk_aon_infra: aon
        }
      }
      clock_connection: clkmgr_clocks_i.clk_io_infra
      unmanaged_clock: false
      unmanaged_reset: false
      reset_connection:
      {
        name: lc_io
        domain: Main
      }
    }
    {
      name: infra_lc_Main
      clock_group:
      {
        name: infra
        src: top
        sw_cg: no
        unique: no
        clocks:
        {
          clk_io_infra: io
          clk_main_infra: main
          clk_aon_infra: aon
        }
      }
      clock_connection: clkmgr_clocks.clk_main_infra
      unmanaged_clock: false
      unmanaged_reset: false
      reset_connection:
      {
        name: lc
        domain: Main
      }
    }
    {
      name: infra_lc_io_Aon
      clock_group:
      {
        name: infra
        src: top
        sw_cg: no
        unique: no
        clocks:
        {
          clk_io_infra: io
          clk_main_infra: main
          clk_aon_infra: aon
        }
      }
      clock_connection: clkmgr_clocks.clk_io_infra
      unmanaged_clock: false
      unmanaged_reset: false
      reset_connection:
      {
        name: lc_io
        domain: Aon
      }
    }
    {
      name: infra_sys_Main
      clock_group:
      {
        name: infra
        src: top
        sw_cg: no
        unique: no
        clocks:
        {
          clk_io_infra: io
          clk_main_infra: main
          clk_aon_infra: aon
        }
      }
      clock_connection: clkmgr_clocks_i.clk_main_infra
      unmanaged_clock: false
      unmanaged_reset: false
      reset_connection:
      {
        name: sys
        domain: Main
      }
    }
    {
      name: secure_lc_Main
      clock_group:
      {
        name: secure
        src: top
        sw_cg: no
        unique: no
        clocks:
        {
          clk_io_secure: io
          clk_main_secure: main
        }
      }
      clock_connection: clkmgr_clocks_i.clk_main_secure
      unmanaged_clock: false
      unmanaged_reset: false
      reset_connection:
      {
        name: lc
        domain: Main
      }
    }
    {
      name: aes_trans_lc_Main
      clock_group:
      {
        name: trans
        src: top
        sw_cg: hint
        unique: yes
        clocks:
        {
          clk_main_aes: main
          clk_main_hmac: main
          clk_main_kmac: main
          clk_main_otbn: main
        }
      }
      clock_connection: clkmgr_clocks_i.clk_main_aes
      unmanaged_clock: false
      unmanaged_reset: false
      reset_connection:
      {
        name: lc
        domain: Main
      }
    }
    {
      name: hmac_trans_lc_Main
      clock_group:
      {
        name: trans
        src: top
        sw_cg: hint
        unique: yes
        clocks:
        {
          clk_main_aes: main
          clk_main_hmac: main
          clk_main_kmac: main
          clk_main_otbn: main
        }
      }
      clock_connection: clkmgr_clocks_i.clk_main_hmac
      unmanaged_clock: false
      unmanaged_reset: false
      reset_connection:
      {
        name: lc
        domain: Main
      }
    }
    {
      name: kmac_trans_lc_Main
      clock_group:
      {
        name: trans
        src: top
        sw_cg: hint
        unique: yes
        clocks:
        {
          clk_main_aes: main
          clk_main_hmac: main
          clk_main_kmac: main
          clk_main_otbn: main
        }
      }
      clock_connection: clkmgr_clocks_i.clk_main_kmac
      unmanaged_clock: false
      unmanaged_reset: false
      reset_connection:
      {
        name: lc
        domain: Main
      }
    }
    {
      name: otbn_trans_lc_Main
      clock_group:
      {
        name: trans
        src: top
        sw_cg: hint
        unique: yes
        clocks:
        {
          clk_main_aes: main
          clk_main_hmac: main
          clk_main_kmac: main
          clk_main_otbn: main
        }
      }
      clock_connection: clkmgr_clocks_i.clk_main_otbn
      unmanaged_clock: false
      unmanaged_reset: false
      reset_connection:
      {
        name: lc
        domain: Main
      }
    }
  ]
  outgoing_alert_lpgs: {}
  inter_signal:
  {
    signals:
    [
      {
        name: lsio_trigger
        desc:
          '''
          Self-clearing status trigger for the DMA.
          Set when RX or TX FIFOs are past their configured watermarks matching watermark interrupt behaviour.
          '''
        struct: logic
        type: uni
        act: req
        width: 1
        inst_name: uart0
        default: ""
        package: ""
        end_idx: -1
        top_type: broadcast
        top_signame: uart0_lsio_trigger
        index: -1
        external: true
        conn_type: false
      }
      {
        name: racl_policies
        desc:
          '''
          Incoming RACL policy vector from a racl_ctrl instance.
          The policy selection vector (parameter) selects the policy for each register.
          '''
        struct: racl_policy_vec
        package: top_racl_pkg
        type: uni
        act: rcv
        width: 1
        inst_name: uart0
        index: -1
      }
      {
        name: racl_error
        desc: RACL error log information of this module.
        struct: racl_error_log
        package: top_racl_pkg
        type: uni
        act: req
        width: 1
        inst_name: uart0
        index: -1
      }
      {
        name: tl
        struct: tl
        package: tlul_pkg
        type: req_rsp
        act: rsp
        width: 1
        inst_name: uart0
        default: ""
        end_idx: -1
        top_type: one-to-one
        top_signame: uart0_tl
        index: -1
      }
      {
        name: strap_en
        desc:
          '''
          The strap enable signal tells gpio to take a snapshot of the input pins.
          The behaviour of this signal after that event will have no effect.
          '''
        struct: logic
        type: uni
        act: rcv
        width: 1
        default: 1'b0
        inst_name: gpio0
        package: ""
        domain: Main
        top_signame: pwrmgr_strap
        index: -1
        external: true
        conn_type: false
      }
      {
        name: sampled_straps
        desc: This vector contains the sampled strap values.
        struct: gpio_straps
        package: gpio_pkg
        type: uni
        act: req
        width: 1
        default: "'0"
        inst_name: gpio0
        index: -1
      }
      {
        name: racl_policies
        desc:
          '''
          Incoming RACL policy vector from a racl_ctrl instance.
          The policy selection vector (parameter) selects the policy for each register.
          '''
        struct: racl_policy_vec
        package: top_racl_pkg
        type: uni
        act: rcv
        width: 1
        inst_name: gpio0
        index: -1
      }
      {
        name: racl_error
        desc: RACL error log information of this module.
        struct: racl_error_log
        package: top_racl_pkg
        type: uni
        act: req
        width: 1
        inst_name: gpio0
        index: -1
      }
      {
        name: tl
        struct: tl
        package: tlul_pkg
        type: req_rsp
        act: rsp
        width: 1
        inst_name: gpio0
        default: ""
        end_idx: -1
        top_type: one-to-one
        top_signame: gpio0_tl
        index: -1
      }
      {
        name: ram_cfg_sys2spi
        struct: ram_1r1w_cfg
        package: prim_ram_1r1w_pkg
        type: req_rsp
        act: rsp
        width: 1
        inst_name: spi_device
        default: ""
        external: true
        conn_type: false
        index: -1
        top_signame: spi_device_sys2spi_ram_cfg
      }
      {
        name: ram_cfg_spi2sys
        struct: ram_1r1w_cfg
        package: prim_ram_1r1w_pkg
        type: req_rsp
        act: rsp
        width: 1
        inst_name: spi_device
        default: ""
        external: true
        conn_type: false
        index: -1
        top_signame: spi_device_spi2sys_ram_cfg
      }
      {
        name: passthrough
        struct: passthrough
        package: spi_device_pkg
        type: req_rsp
        act: req
        width: 1
        inst_name: spi_device
        default: ""
        end_idx: -1
        top_type: one-to-one
        top_signame: spi_device_passthrough
        index: -1
      }
      {
        name: mbist_en
        struct: logic
        type: uni
        act: rcv
        width: 1
        inst_name: spi_device
        index: -1
      }
      {
        name: sck_monitor
        struct: logic
        type: uni
        act: req
        width: 1
        inst_name: spi_device
        default: ""
        package: ""
        external: true
        conn_type: false
        index: -1
        top_signame: sck_monitor
      }
      {
        name: racl_policies
        desc:
          '''
          Incoming RACL policy vector from a racl_ctrl instance.
          The policy selection vector (parameter) selects the policy for each register.
          '''
        struct: racl_policy_vec
        package: top_racl_pkg
        type: uni
        act: rcv
        width: 1
        inst_name: spi_device
        index: -1
      }
      {
        name: racl_error
        desc: RACL error log information of this module.
        struct: racl_error_log
        package: top_racl_pkg
        type: uni
        act: req
        width: 1
        inst_name: spi_device
        index: -1
      }
      {
        name: tl
        struct: tl
        package: tlul_pkg
        type: req_rsp
        act: rsp
        width: 1
        inst_name: spi_device
        default: ""
        end_idx: -1
        top_type: one-to-one
        top_signame: spi_device_tl
        index: -1
      }
      {
        name: ram_cfg
        struct: ram_1p_cfg
        package: prim_ram_1p_pkg
        type: req_rsp
        act: rsp
        width: 1
        inst_name: i2c0
        default: ""
        external: true
        conn_type: false
        index: -1
        top_signame: i2c0_ram_cfg
      }
      {
        name: lsio_trigger
        desc:
          '''
          Self-clearing status trigger for the DMA.
          Set when RX TX FIFO is past their configured watermark matching watermark interrupt behaviour.
          '''
        struct: logic
        type: uni
        act: req
        width: 1
        inst_name: i2c0
        default: ""
        package: ""
        end_idx: -1
        top_type: broadcast
        top_signame: i2c0_lsio_trigger
        index: -1
        external: true
        conn_type: false
      }
      {
        name: racl_policies
        desc:
          '''
          Incoming RACL policy vector from a racl_ctrl instance.
          The policy selection vector (parameter) selects the policy for each register.
          '''
        struct: racl_policy_vec
        package: top_racl_pkg
        type: uni
        act: rcv
        width: 1
        inst_name: i2c0
        index: -1
      }
      {
        name: racl_error
        desc: RACL error log information of this module.
        struct: racl_error_log
        package: top_racl_pkg
        type: uni
        act: req
        width: 1
        inst_name: i2c0
        index: -1
      }
      {
        name: tl
        struct: tl
        package: tlul_pkg
        type: req_rsp
        act: rsp
        width: 1
        inst_name: i2c0
        default: ""
        end_idx: -1
        top_type: one-to-one
        top_signame: i2c0_tl
        index: -1
      }
      {
        name: racl_policies
        desc:
          '''
          Incoming RACL policy vector from a racl_ctrl instance.
          The policy selection vector (parameter) selects the policy for each register.
          '''
        struct: racl_policy_vec
        package: top_racl_pkg
        type: uni
        act: rcv
        width: 1
        inst_name: rv_timer
        index: -1
      }
      {
        name: racl_error
        desc: RACL error log information of this module.
        struct: racl_error_log
        package: top_racl_pkg
        type: uni
        act: req
        width: 1
        inst_name: rv_timer
        index: -1
      }
      {
        name: tl
        struct: tl
        package: tlul_pkg
        type: req_rsp
        act: rsp
        width: 1
        inst_name: rv_timer
        default: ""
        end_idx: -1
        top_type: one-to-one
        top_signame: rv_timer_tl
        index: -1
      }
      {
        name: edn
        desc: Entropy request to the entropy distribution network for LFSR reseeding and ephemeral key derivation.
        struct: edn
        package: edn_pkg
        type: req_rsp
        act: req
        width: 1
        inst_name: otp_ctrl
        default: ""
        domain: Main
        top_signame: edn0_edn
        index: 1
      }
      {
        name: pwr_otp
        desc: Initialization request/acknowledge from/to power manager.
        struct: pwr_otp
        package: pwrmgr_pkg
        type: req_rsp
        act: rsp
        width: 1
        default: "'0"
        inst_name: otp_ctrl
        domain: Main
        top_signame: pwrmgr_pwr_otp
        index: -1
        external: true
        conn_type: false
      }
      {
        name: lc_otp_program
        desc: Life cycle state transition interface.
        struct: lc_otp_program
        package: otp_ctrl_pkg
        type: req_rsp
        act: rsp
        width: 1
        default: "'0"
        inst_name: otp_ctrl
        domain: Main
        top_signame: lc_ctrl_lc_otp_program
        index: -1
      }
      {
        name: otp_lc_data
        desc:
          '''
          Life cycle state output holding the current life cycle state,
          the value of the transition counter and the tokens needed for life cycle transitions.
          '''
        struct: otp_lc_data
        package: otp_ctrl_pkg
        type: uni
        act: req
        width: 1
        default: "'0"
        inst_name: otp_ctrl
        end_idx: -1
        top_type: broadcast
        top_signame: otp_ctrl_otp_lc_data
        index: -1
      }
      {
        name: lc_escalate_en
        desc:
          '''
          Life cycle escalation enable coming from life cycle controller.
          This signal moves all FSMs within OTP into the error state.
          '''
        struct: lc_tx
        package: lc_ctrl_pkg
        type: uni
        act: rcv
        width: 1
        default: lc_ctrl_pkg::Off
        inst_name: otp_ctrl
        domain: Main
        top_signame: lc_ctrl_lc_escalate_en
        index: -1
      }
      {
        name: lc_creator_seed_sw_rw_en
        desc:
          '''
          Provision enable qualifier coming from life cycle controller.
          This signal enables SW read / write access to the RMA_TOKEN and CREATOR_ROOT_KEY_SHARE0 and CREATOR_ROOT_KEY_SHARE1.
          '''
        struct: lc_tx
        package: lc_ctrl_pkg
        type: uni
        act: rcv
        width: 1
        default: lc_ctrl_pkg::Off
        inst_name: otp_ctrl
        domain: Main
        top_signame: lc_ctrl_lc_creator_seed_sw_rw_en
        index: -1
      }
      {
        name: lc_owner_seed_sw_rw_en
        desc:
          '''
          Provision enable qualifier coming from life cycle controller.
          This signal enables SW read / write access to the OWNER_SEED.
          '''
        struct: lc_tx
        package: lc_ctrl_pkg
        type: uni
        act: rcv
        width: 1
        default: lc_ctrl_pkg::Off
        inst_name: otp_ctrl
        domain: Main
        top_signame: lc_ctrl_lc_owner_seed_sw_rw_en
        index: -1
      }
      {
        name: lc_seed_hw_rd_en
        desc:
          '''
          Seed read enable coming from life cycle controller.
          This signal enables HW read access to the:
          - CREATOR_ROOT_KEY_SHARE0 and CREATOR_ROOT_KEY_SHARE1
          '''
        struct: lc_tx
        package: lc_ctrl_pkg
        type: uni
        act: rcv
        width: 1
        default: lc_ctrl_pkg::Off
        inst_name: otp_ctrl
        domain: Main
        top_signame: lc_ctrl_lc_seed_hw_rd_en
        index: -1
      }
      {
        name: lc_rma_state
        desc:
          '''
          This signal states whether the current life cycle is RMA.
          It is used to enable SW read access to (read-locked) partitions in the RMA state.
          '''
        struct: lc_tx
        package: lc_ctrl_pkg
        type: uni
        act: rcv
        width: 1
        default: lc_ctrl_pkg::Off
        inst_name: otp_ctrl
        domain: Main
        top_signame: lc_ctrl_lc_rma_state
        index: -1
      }
      {
        name: lc_check_byp_en
        desc:
          '''
          Life cycle partition check bypass signal.
          This signal causes the life cycle partition to bypass consistency checks during life cycle state transitions in order to prevent spurious consistency check failures.
          '''
        struct: lc_tx
        package: lc_ctrl_pkg
        type: uni
        act: rcv
        width: 1
        default: lc_ctrl_pkg::Off
        inst_name: otp_ctrl
        domain: Main
        top_signame: lc_ctrl_lc_check_byp_en
        index: -1
      }
      {
        name: keymgr_creator_root_key
        desc: Key output to the key manager holding CREATOR_ROOT_KEY_SHARE0 and CREATOR_ROOT_KEY_SHARE1.
        struct: keymgr_dpe_creator_root_key
        package: keymgr_dpe_pkg
        type: uni
        act: req
        width: 1
        default: "'0"
        inst_name: otp_ctrl
        end_idx: -1
        top_type: broadcast
        top_signame: otp_ctrl_keymgr_creator_root_key
        index: -1
      }
      {
        name: keymgr_creator_seed
        desc: Creator seed output to the key manager
        struct: keymgr_dpe_creator_seed
        package: keymgr_dpe_pkg
        type: uni
        act: req
        width: 1
        default: "'0"
        inst_name: otp_ctrl
        end_idx: -1
        top_type: broadcast
        top_signame: otp_ctrl_keymgr_creator_seed
        index: -1
      }
      {
        name: keymgr_owner_seed
        desc: Owner seed output to the key manager
        struct: keymgr_dpe_owner_seed
        package: keymgr_dpe_pkg
        type: uni
        act: req
        width: 1
        default: "'0"
        inst_name: otp_ctrl
        end_idx: -1
        top_type: broadcast
        top_signame: otp_ctrl_keymgr_owner_seed
        index: -1
      }
      {
        name: sram_otp_key
        desc: Array with key derivation interfaces for SRAM scrambling devices.
        struct: sram_otp_key
        package: otp_ctrl_pkg
        type: req_rsp
        act: rsp
        width: 4
        default: "'0"
        inst_name: otp_ctrl
        end_idx: -1
        top_type: one-to-N
        top_signame: otp_ctrl_sram_otp_key
        index: 1
        external: true
        conn_type: true
      }
      {
        name: otbn_otp_key
        desc: Key derivation interface for OTBN scrambling devices.
        struct: otbn_otp_key
        package: otp_ctrl_pkg
        type: req_rsp
        act: rsp
        width: 1
        default: "'0"
        inst_name: otp_ctrl
        end_idx: -1
        top_type: one-to-one
        top_signame: otp_ctrl_otbn_otp_key
        index: -1
      }
      {
        name: otp_broadcast
        desc: Output of the HW partitions with breakout data types.
        struct: otp_broadcast
        package: otp_ctrl_part_pkg
        type: uni
        act: req
        width: 1
        default: "'0"
        inst_name: otp_ctrl
        top_signame: otp_ctrl_otp_broadcast
        index: -1
      }
      {
        name: otp_macro
        desc: Data interface for the OTP macro.
        struct: otp_ctrl_macro
        package: otp_ctrl_macro_pkg
        type: req_rsp
        act: req
        width: 1
        default: "'0"
        inst_name: otp_ctrl
        end_idx: -1
        top_type: one-to-one
        top_signame: otp_ctrl_otp_macro
        index: -1
      }
      {
        name: core_tl
        struct: tl
        package: tlul_pkg
        type: req_rsp
        act: rsp
        width: 1
        inst_name: otp_ctrl
        default: ""
        end_idx: -1
        top_type: one-to-one
        top_signame: otp_ctrl_core_tl
        index: -1
      }
      {
        name: obs_ctrl
        desc: AST observability control signals.
        struct: ast_obs_ctrl
        package: ast_pkg
        type: uni
        act: rcv
        width: 1
        inst_name: otp_macro
        default: ""
        domain: Main
        top_signame: ast_obs_ctrl
        index: -1
      }
      {
        name: otp_obs
        desc: AST observability bus.
        struct: logic
        type: uni
        act: req
        width: 8
        inst_name: otp_macro
        default: ""
        package: ""
        external: true
        conn_type: false
        index: -1
        top_signame: otp_obs
      }
      {
        name: pwr_seq
        desc: Power sequencing signals to AST (VDD domain).
        struct: pwr_seq
        package: otp_macro_pkg
        type: uni
        act: req
        width: 1
        default: "'0"
        inst_name: otp_macro
        external: true
        conn_type: false
        index: -1
        top_signame: otp_macro_pwr_seq
      }
      {
        name: pwr_seq_h
        desc: Power sequencing signals coming from AST (VCC domain).
        struct: pwr_seq
        package: otp_macro_pkg
        type: uni
        act: rcv
        width: 1
        default: "'0"
        inst_name: otp_macro
        external: true
        conn_type: false
        index: -1
        top_signame: otp_macro_pwr_seq_h
      }
      {
        name: ext_voltage_h
        struct: ""
        type: io
        act: none
        width: 1
        default: "'0"
        inst_name: otp_macro
        package: ""
        external: true
        conn_type: false
        index: -1
        top_signame: otp_ext_voltage_h
      }
      {
        name: lc_dft_en
        desc:
          '''
          Test enable qualifier coming from life cycle controller.
          This signals enables the TL-UL access port.
          '''
        struct: lc_tx
        package: lc_ctrl_pkg
        type: uni
        act: rcv
        width: 1
        default: lc_ctrl_pkg::Off
        inst_name: otp_macro
        domain: Main
        top_signame: lc_ctrl_lc_dft_en
        index: -1
      }
      {
        name: test
        desc: Vendor test control signals from/to the life cycle TAP.
        struct: otp_test
        package: otp_macro_pkg
        type: req_rsp
        act: rsp
        width: 1
        default: "'0"
        inst_name: otp_macro
        domain: Main
        top_signame: lc_ctrl_lc_otp_vendor_test
        index: -1
      }
      {
        name: otp
        desc: Data interface for the OTP macro.
        struct: otp_ctrl_macro
        package: otp_ctrl_macro_pkg
        type: req_rsp
        act: rsp
        width: 1
        default: "'0"
        inst_name: otp_macro
        domain: Main
        top_signame: otp_ctrl_otp_macro
        index: -1
      }
      {
        name: cfg
        struct: otp_cfg
        package: otp_macro_pkg
        type: uni
        act: rcv
        width: 1
        default: "'0"
        inst_name: otp_macro
        external: true
        conn_type: false
        index: -1
        top_signame: otp_cfg
      }
      {
        name: cfg_rsp
        struct: otp_cfg_rsp
        package: otp_macro_pkg
        type: uni
        act: req
        width: 1
        default: "'0"
        inst_name: otp_macro
        index: -1
      }
      {
        name: racl_policies
        desc:
          '''
          Incoming RACL policy vector from a racl_ctrl instance.
          The policy selection vector (parameter) selects the policy for each register.
          '''
        struct: racl_policy_vec
        package: top_racl_pkg
        type: uni
        act: rcv
        width: 1
        inst_name: otp_macro
        index: -1
      }
      {
        name: racl_error
        desc: RACL error log information of this module.
        struct: racl_error_log
        package: top_racl_pkg
        type: uni
        act: req
        width: 1
        inst_name: otp_macro
        index: -1
      }
      {
        name: prim_tl
        struct: tl
        package: tlul_pkg
        type: req_rsp
        act: rsp
        width: 1
        inst_name: otp_macro
        default: ""
        end_idx: -1
        top_type: one-to-one
        top_signame: otp_macro_prim_tl
        index: -1
      }
      {
        name: jtag
        struct: jtag
        package: jtag_pkg
        type: req_rsp
        act: rsp
        width: 1
        inst_name: lc_ctrl
        index: -1
      }
      {
        name: esc_scrap_state0_tx
        struct: esc_tx
        package: prim_esc_pkg
        type: uni
        act: rcv
        width: 1
        inst_name: lc_ctrl
        default: ""
        domain: Main
        top_signame: alert_handler_esc_tx
        index: 1
      }
      {
        name: esc_scrap_state0_rx
        struct: esc_rx
        package: prim_esc_pkg
        type: uni
        act: req
        width: 1
        inst_name: lc_ctrl
        default: ""
        domain: Main
        top_signame: alert_handler_esc_rx
        index: 1
      }
      {
        name: esc_scrap_state1_tx
        struct: esc_tx
        package: prim_esc_pkg
        type: uni
        act: rcv
        width: 1
        inst_name: lc_ctrl
        default: ""
        domain: Main
        top_signame: alert_handler_esc_tx
        index: 2
      }
      {
        name: esc_scrap_state1_rx
        struct: esc_rx
        package: prim_esc_pkg
        type: uni
        act: req
        width: 1
        inst_name: lc_ctrl
        default: ""
        domain: Main
        top_signame: alert_handler_esc_rx
        index: 2
      }
      {
        name: pwr_lc
        struct: pwr_lc
        package: lc_ctrl_pkg
        type: req_rsp
        act: rsp
        width: 1
        inst_name: lc_ctrl
        default: ""
        domain: Main
        top_signame: pwrmgr_pwr_lc
        index: -1
        external: true
        conn_type: false
      }
      {
        name: lc_otp_vendor_test
        struct: otp_test
        package: otp_macro_pkg
        type: req_rsp
        act: req
        width: 1
        default: "'0"
        inst_name: lc_ctrl
        end_idx: -1
        top_type: one-to-one
        top_signame: lc_ctrl_lc_otp_vendor_test
        index: -1
      }
      {
        name: otp_lc_data
        struct: otp_lc_data
        package: otp_ctrl_pkg
        type: uni
        act: rcv
        width: 1
        default: otp_ctrl_pkg::OTP_LC_DATA_DEFAULT
        inst_name: lc_ctrl
        domain: Main
        top_signame: otp_ctrl_otp_lc_data
        index: -1
      }
      {
        name: lc_otp_program
        struct: lc_otp_program
        package: otp_ctrl_pkg
        type: req_rsp
        act: req
        width: 1
        default: "'0"
        inst_name: lc_ctrl
        end_idx: -1
        top_type: one-to-one
        top_signame: lc_ctrl_lc_otp_program
        index: -1
      }
      {
        name: kmac_data
        struct: app
        package: kmac_pkg
        type: req_rsp
        act: req
        width: 1
        default: "'0"
        inst_name: lc_ctrl
        domain: Main
        top_signame: kmac_app
        index: 1
      }
      {
        name: lc_init_done
        desc:
          '''
          Indicates that life cycle initialization is complete and the broadcast signals are valid; see `INIT_DONE` in the Theory of Operation doc for details.
          This signal is Off while lc_ctrl is in reset.
          Once On, it stays On until lc_ctrl is reset.
          '''
        struct: lc_tx
        package: lc_ctrl_pkg
        type: uni
        act: req
        width: 1
        default: lc_ctrl_pkg::Off
        inst_name: lc_ctrl
        end_idx: -1
        top_type: broadcast
        top_signame: lc_ctrl_lc_init_done
        index: -1
      }
      {
        name: lc_raw_test_rma
        struct: lc_tx
        package: lc_ctrl_pkg
        type: uni
        act: req
        width: 1
        default: lc_ctrl_pkg::Off
        inst_name: lc_ctrl
        end_idx: -1
        top_type: broadcast
        top_signame: lc_ctrl_lc_raw_test_rma
        index: -1
      }
      {
        name: lc_dft_en
        struct: lc_tx
        package: lc_ctrl_pkg
        type: uni
        act: req
        width: 1
        default: lc_ctrl_pkg::Off
        inst_name: lc_ctrl
        end_idx: -1
        top_type: broadcast
        top_signame: lc_ctrl_lc_dft_en
        index: -1
        external: true
        conn_type: true
      }
      {
        name: lc_nvm_debug_en
        struct: lc_tx
        package: lc_ctrl_pkg
        type: uni
        act: req
        width: 1
        default: lc_ctrl_pkg::Off
        inst_name: lc_ctrl
        index: -1
      }
      {
        name: lc_hw_debug_clr
        desc:
          '''
          Clear HW debug functionality; see `HW_DEBUG_CLR` in the Theory of Operation doc for details.

          This signal is used to clear stored copies of `lc_hw_debug_en` when HW debug functionality gets disabled outside a reset of `lc_ctrl`.
          This signal is On in the SCRAP, INVALID, POST_TRANSITION and ESCALATION states, in which `lc_hw_debug_en` is Off.
          Once On, it remains On until lc_ctrl is reset.
          Flops storing the value of `lc_hw_debug_en` (see below) must be cleared whenever this signal is not Off.
          '''
        struct: lc_tx
        package: lc_ctrl_pkg
        type: uni
        act: req
        width: 1
        default: lc_ctrl_pkg::Off
        inst_name: lc_ctrl
        end_idx: -1
        top_type: broadcast
        top_signame: lc_ctrl_lc_hw_debug_clr
        index: -1
      }
      {
        name: lc_hw_debug_en
        desc:
          '''
          Enable HW debug functionality; see `HW_DEBUG_EN` in the Theory of Operation doc for details.

          This signal is Off while lc_ctrl is in reset.
          In order to prevent a JTAG disconnect during non-debug-module (NDM) reset, this signal should be flopped outside the NDM reset domain.
          Such a flop must be cleared whenever `lc_hw_debug_clr` is not Off; see above.
          '''
        struct: lc_tx
        package: lc_ctrl_pkg
        type: uni
        act: req
        width: 1
        default: lc_ctrl_pkg::Off
        inst_name: lc_ctrl
        end_idx: -1
        top_type: broadcast
        top_signame: lc_ctrl_lc_hw_debug_en
        index: -1
        external: true
        conn_type: true
      }
      {
        name: lc_cpu_en
        struct: lc_tx
        package: lc_ctrl_pkg
        type: uni
        act: req
        width: 1
        default: lc_ctrl_pkg::Off
        inst_name: lc_ctrl
        end_idx: -1
        top_type: broadcast
        top_signame: lc_ctrl_lc_cpu_en
        index: -1
      }
      {
        name: lc_keymgr_en
        struct: lc_tx
        package: lc_ctrl_pkg
        type: uni
        act: req
        width: 1
        default: lc_ctrl_pkg::Off
        inst_name: lc_ctrl
        end_idx: -1
        top_type: broadcast
        top_signame: lc_ctrl_lc_keymgr_en
        index: -1
      }
      {
        name: lc_escalate_en
        struct: lc_tx
        package: lc_ctrl_pkg
        type: uni
        act: req
        width: 1
        default: lc_ctrl_pkg::Off
        inst_name: lc_ctrl
        end_idx: -1
        top_type: broadcast
        top_signame: lc_ctrl_lc_escalate_en
        index: -1
        external: true
        conn_type: true
      }
      {
        name: lc_clk_byp_req
        struct: lc_tx
        package: lc_ctrl_pkg
        type: uni
        act: req
        width: 1
        default: lc_ctrl_pkg::Off
        inst_name: lc_ctrl
        domain: Main
        top_signame: lc_ctrl_lc_clk_byp_ack
        index: -1
      }
      {
        name: lc_clk_byp_ack
        struct: lc_tx
        package: lc_ctrl_pkg
        type: uni
        act: rcv
        width: 1
        default: lc_ctrl_pkg::Off
        inst_name: lc_ctrl
        end_idx: -1
        top_type: broadcast
        top_signame: lc_ctrl_lc_clk_byp_ack
        index: -1
      }
      {
        name: lc_nvm_rma_req
        struct: lc_tx
        package: lc_ctrl_pkg
        type: uni
        act: req
        width: 1
        default: lc_ctrl_pkg::Off
        inst_name: lc_ctrl
        end_idx: -1
        top_type: broadcast
        top_signame: lc_ctrl_lc_nvm_rma_req
        index: -1
      }
      {
        name: lc_nvm_rma_ack
        struct: lc_tx
        package: lc_ctrl_pkg
        type: uni
        act: rcv
        width: 2
        default: lc_ctrl_pkg::On
        inst_name: lc_ctrl
        domain: Main
        top_signame: otbn_lc_rma_ack
        index: -1
      }
      {
        name: lc_nvm_rma_seed
        struct: lc_nvm_rma_seed
        package: lc_ctrl_pkg
        type: uni
        act: req
        width: 1
        default: "'0"
        inst_name: lc_ctrl
        index: -1
      }
      {
        name: lc_check_byp_en
        struct: lc_tx
        package: lc_ctrl_pkg
        type: uni
        act: req
        width: 1
        default: lc_ctrl_pkg::Off
        inst_name: lc_ctrl
        end_idx: -1
        top_type: broadcast
        top_signame: lc_ctrl_lc_check_byp_en
        index: -1
      }
      {
        name: lc_creator_seed_sw_rw_en
        struct: lc_tx
        package: lc_ctrl_pkg
        type: uni
        act: req
        width: 1
        default: lc_ctrl_pkg::Off
        inst_name: lc_ctrl
        end_idx: -1
        top_type: broadcast
        top_signame: lc_ctrl_lc_creator_seed_sw_rw_en
        index: -1
      }
      {
        name: lc_owner_seed_sw_rw_en
        struct: lc_tx
        package: lc_ctrl_pkg
        type: uni
        act: req
        width: 1
        default: lc_ctrl_pkg::Off
        inst_name: lc_ctrl
        end_idx: -1
        top_type: broadcast
        top_signame: lc_ctrl_lc_owner_seed_sw_rw_en
        index: -1
      }
      {
        name: lc_iso_part_sw_rd_en
        struct: lc_tx
        package: lc_ctrl_pkg
        type: uni
        act: req
        width: 1
        default: lc_ctrl_pkg::Off
        inst_name: lc_ctrl
        index: -1
      }
      {
        name: lc_iso_part_sw_wr_en
        struct: lc_tx
        package: lc_ctrl_pkg
        type: uni
        act: req
        width: 1
        default: lc_ctrl_pkg::Off
        inst_name: lc_ctrl
        index: -1
      }
      {
        name: lc_seed_hw_rd_en
        struct: lc_tx
        package: lc_ctrl_pkg
        type: uni
        act: req
        width: 1
        default: lc_ctrl_pkg::Off
        inst_name: lc_ctrl
        end_idx: -1
        top_type: broadcast
        top_signame: lc_ctrl_lc_seed_hw_rd_en
        index: -1
      }
      {
        name: lc_rma_state
        struct: lc_tx
        package: lc_ctrl_pkg
        type: uni
        act: req
        width: 1
        default: lc_ctrl_pkg::Off
        inst_name: lc_ctrl
        end_idx: -1
        top_type: broadcast
        top_signame: lc_ctrl_lc_rma_state
        index: -1
      }
      {
        name: lc_keymgr_div
        struct: lc_keymgr_div
        package: lc_ctrl_pkg
        type: uni
        act: req
        width: 1
        default: "'0"
        inst_name: lc_ctrl
        end_idx: -1
        top_type: broadcast
        top_signame: lc_ctrl_lc_keymgr_div
        index: -1
      }
      {
        name: otp_device_id
        struct: otp_device_id
        package: otp_ctrl_pkg
        type: uni
        act: rcv
        width: 1
        default: "'0"
        inst_name: lc_ctrl
        top_signame: lc_ctrl_otp_device_id
        index: -1
      }
      {
        name: otp_manuf_state
        struct: otp_manuf_state
        package: otp_ctrl_pkg
        type: uni
        act: rcv
        width: 1
        default: "'0"
        inst_name: lc_ctrl
        top_signame: lc_ctrl_otp_manuf_state
        index: -1
      }
      {
        name: hw_rev
        struct: lc_hw_rev
        package: lc_ctrl_pkg
        type: uni
        act: req
        width: 1
        default: "'0"
        inst_name: lc_ctrl
        index: -1
      }
      {
        name: strap_en_override
        desc:
          '''
          This signal transitions from 0 -> 1 by the lc_ctrl manager after volatile RAW_UNLOCK in order to re-sample the HW straps.
          The signal stays at 1 until reset.
          Note that this is only used in test chips when SecVolatileRawUnlockEn = 1.
          Otherwise this signal is tied off to 0.
          '''
        struct: logic
        type: uni
        act: req
        width: 1
        default: 1'b0
        inst_name: lc_ctrl
        package: ""
        end_idx: -1
        top_type: broadcast
        top_signame: lc_ctrl_strap_en_override
        index: -1
      }
      {
        name: regs_tl
        struct: tl
        package: tlul_pkg
        type: req_rsp
        act: rsp
        width: 1
        inst_name: lc_ctrl
        default: ""
        end_idx: -1
        top_type: one-to-one
        top_signame: lc_ctrl_regs_tl
        index: -1
      }
      {
        name: dmi_tl
        struct: tl
        package: tlul_pkg
        type: req_rsp
        act: rsp
        width: 1
        inst_name: lc_ctrl
        default: ""
        end_idx: -1
        top_type: one-to-one
        top_signame: lc_ctrl_dmi_tl
        index: -1
      }
      {
        name: crashdump
        struct: alert_crashdump
        package: alert_handler_pkg
        type: uni
        act: req
        width: 1
        inst_name: alert_handler
        default: ""
        end_idx: -1
        top_type: broadcast
        top_signame: alert_handler_crashdump
        index: -1
        external: true
        conn_type: false
      }
      {
        name: edn
        struct: edn
        package: edn_pkg
        type: req_rsp
        act: req
        width: 1
        inst_name: alert_handler
        default: ""
        domain: Main
        top_signame: edn0_edn
        index: 3
      }
      {
        name: esc_rx
        struct: esc_rx
        package: prim_esc_pkg
        type: uni
        act: rcv
        width: 4
        inst_name: alert_handler
        default: ""
        end_idx: -1
        top_type: one-to-N
        top_signame: alert_handler_esc_rx
        index: 3
        external: true
        conn_type: true
      }
      {
        name: esc_tx
        struct: esc_tx
        package: prim_esc_pkg
        type: uni
        act: req
        width: 4
        inst_name: alert_handler
        default: ""
        end_idx: -1
        top_type: one-to-N
        top_signame: alert_handler_esc_tx
        index: 3
        external: true
        conn_type: true
      }
      {
        name: tl
        struct: tl
        package: tlul_pkg
        type: req_rsp
        act: rsp
        width: 1
        inst_name: alert_handler
        default: ""
        end_idx: -1
        top_type: one-to-one
        top_signame: alert_handler_tl
        index: -1
      }
      {
        name: passthrough
        struct: passthrough
        package: spi_device_pkg
        type: req_rsp
        act: rsp
        width: 1
        inst_name: spi_host0
        default: ""
        domain: Main
        top_signame: spi_device_passthrough
        index: -1
      }
      {
        name: lsio_trigger
        desc:
          '''
          Self-clearing status trigger for the DMA.
          Set when RX or TX FIFOs are past their configured watermarks matching watermark interrupt behaviour.
          '''
        struct: logic
        type: uni
        act: req
        width: 1
        inst_name: spi_host0
        default: ""
        package: ""
        end_idx: -1
        top_type: broadcast
        top_signame: spi_host0_lsio_trigger
        index: -1
        external: true
        conn_type: false
      }
      {
        name: racl_policies
        desc:
          '''
          Incoming RACL policy vector from a racl_ctrl instance.
          The policy selection vector (parameter) selects the policy for each register.
          '''
        struct: racl_policy_vec
        package: top_racl_pkg
        type: uni
        act: rcv
        width: 1
        inst_name: spi_host0
        index: -1
      }
      {
        name: racl_error
        desc: RACL error log information of this module.
        struct: racl_error_log
        package: top_racl_pkg
        type: uni
        act: req
        width: 1
        inst_name: spi_host0
        index: -1
      }
      {
        name: tl
        struct: tl
        package: tlul_pkg
        type: req_rsp
        act: rsp
        width: 1
        inst_name: spi_host0
        default: ""
        end_idx: -1
        top_type: one-to-one
        top_signame: spi_host0_tl
        index: -1
      }
      {
        name: boot_status
        struct: pwr_boot_status
        package: pwrmgr_pkg
        type: uni
        act: req
        width: 1
        inst_name: pwrmgr
        default: ""
        end_idx: -1
        top_type: broadcast
        top_signame: pwrmgr_boot_status
        index: -1
        external: true
        conn_type: true
      }
      {
        name: ext_rst_ack
        struct: logic
        type: uni
        act: rcv
        width: 1
        inst_name: pwrmgr
        default: ""
        package: ""
        external: true
        conn_type: false
        index: -1
        top_signame: pwrmgr_ext_rst_ack
      }
      {
        name: pwr_ast
        struct: pwr_ast
        package: pwrmgr_pkg
        type: req_rsp
        act: req
        width: 1
        inst_name: pwrmgr
        default: ""
        external: true
        conn_type: false
        index: -1
        top_signame: pwrmgr_ast
      }
      {
        name: pwr_rst
        struct: pwr_rst
        package: pwrmgr_pkg
        type: req_rsp
        act: req
        width: 1
        inst_name: pwrmgr
        default: ""
        end_idx: -1
        top_type: one-to-one
        top_signame: pwrmgr_pwr_rst
        index: -1
      }
      {
        name: pwr_clk
        struct: pwr_clk
        package: pwrmgr_pkg
        type: req_rsp
        act: req
        width: 1
        inst_name: pwrmgr
        default: ""
        end_idx: -1
        top_type: one-to-one
        top_signame: pwrmgr_pwr_clk
        index: -1
      }
      {
        name: pwr_otp
        struct: pwr_otp
        package: pwrmgr_pkg
        type: req_rsp
        act: req
        width: 1
        inst_name: pwrmgr
        default: ""
        end_idx: -1
        top_type: one-to-one
        top_signame: pwrmgr_pwr_otp
        index: -1
        external: true
        conn_type: false
      }
      {
        name: pwr_lc
        struct: pwr_lc
        package: lc_ctrl_pkg
        type: req_rsp
        act: req
        width: 1
        inst_name: pwrmgr
        default: ""
        end_idx: -1
        top_type: one-to-one
        top_signame: pwrmgr_pwr_lc
        index: -1
        external: true
        conn_type: false
      }
      {
        name: pwr_nvm
        struct: pwr_nvm
        package: pwrmgr_pkg
        type: uni
        act: rcv
        width: 1
        inst_name: pwrmgr
        index: -1
      }
      {
        name: esc_rst_tx
        struct: esc_tx
        package: prim_esc_pkg
        type: uni
        act: rcv
        width: 1
        inst_name: pwrmgr
        default: ""
        domain: Aon
        top_signame: alert_handler_esc_tx
        index: -1
        external: true
        conn_type: false
      }
      {
        name: esc_rst_rx
        struct: esc_rx
        package: prim_esc_pkg
        type: uni
        act: req
        width: 1
        inst_name: pwrmgr
        default: ""
        domain: Aon
        top_signame: alert_handler_esc_rx
        index: -1
        external: true
        conn_type: false
      }
      {
        name: pwr_cpu
        struct: cpu_pwrmgr
        package: rv_core_ibex_pkg
        type: uni
        act: rcv
        width: 1
        inst_name: pwrmgr
        default: ""
        domain: Aon
        top_signame: rv_core_ibex_pwrmgr
        index: -1
        external: true
        conn_type: false
      }
      {
        name: wakeups
        struct: logic
        type: uni
        act: rcv
        width: 3
        inst_name: pwrmgr
        default: ""
        package: ""
        end_idx: -1
        top_type: one-to-N
        top_signame: pwrmgr_wakeups
        index: 0
        external: true
        conn_type: true
      }
      {
        name: rstreqs
        struct: logic
        type: uni
        act: rcv
        width: 2
        inst_name: pwrmgr
        default: ""
        package: ""
        end_idx: -1
        top_type: one-to-N
        top_signame: pwrmgr_rstreqs
        index: -1
      }
      {
        name: ndmreset_req
        struct: logic
        type: uni
        act: rcv
        width: 1
        inst_name: pwrmgr
        default: ""
        package: ""
        domain: Aon
        top_signame: rv_dm_ndmreset_req
        index: -1
        external: true
        conn_type: false
      }
      {
        name: strap
        struct: logic
        type: uni
        act: req
        width: 1
        inst_name: pwrmgr
        default: ""
        package: ""
        end_idx: -1
        top_type: broadcast
        top_signame: pwrmgr_strap
        index: -1
        external: true
        conn_type: false
      }
      {
        name: low_power
        struct: logic
        type: uni
        act: req
        width: 1
        inst_name: pwrmgr
        default: ""
        package: ""
        end_idx: -1
        top_type: broadcast
        top_signame: pwrmgr_low_power
        index: -1
        external: true
        conn_type: true
      }
      {
        name: rom_ctrl
        struct: pwrmgr_data
        package: rom_ctrl_pkg
        type: uni
        act: rcv
        width: 3
        default: rom_ctrl_pkg::PWRMGR_DATA_DEFAULT
        inst_name: pwrmgr
        end_idx: -1
        top_type: one-to-N
        top_signame: pwrmgr_rom_ctrl
        index: -1
        external: true
        conn_type: false
      }
      {
        name: fetch_en
        struct: lc_tx
        package: lc_ctrl_pkg
        type: uni
        act: req
        width: 1
        inst_name: pwrmgr
        default: ""
        end_idx: -1
        top_type: broadcast
        top_signame: pwrmgr_fetch_en
        index: -1
        external: true
        conn_type: false
      }
      {
        name: lc_dft_en
        struct: lc_tx
        package: lc_ctrl_pkg
        type: uni
        act: rcv
        width: 1
        inst_name: pwrmgr
        default: ""
        domain: Aon
        top_signame: lc_ctrl_lc_dft_en
        index: -1
        external: true
        conn_type: false
      }
      {
        name: lc_hw_debug_en
        struct: lc_tx
        package: lc_ctrl_pkg
        type: uni
        act: rcv
        width: 1
        inst_name: pwrmgr
        default: ""
        domain: Aon
        top_signame: lc_ctrl_lc_hw_debug_en
        index: -1
        external: true
        conn_type: false
      }
      {
        name: sw_rst_req
        struct: mubi4
        package: prim_mubi_pkg
        type: uni
        act: rcv
        width: 1
        inst_name: pwrmgr
        default: ""
        domain: Aon
        top_signame: rstmgr_sw_rst_req
        index: -1
      }
      {
        name: tl
        struct: tl
        package: tlul_pkg
        type: req_rsp
        act: rsp
        width: 1
        inst_name: pwrmgr
        default: ""
        end_idx: -1
        top_type: one-to-one
        top_signame: pwrmgr_tl
        index: -1
        external: true
        conn_type: false
      }
      {
        name: por_n
        desc:
          '''
          Root power on reset signals from ast.
          There is one root reset signal for each core power domain.
          '''
        struct: logic
        type: uni
        act: rcv
        width: 2
        inst_name: rstmgr
        default: ""
        package: ""
        external: true
        conn_type: false
        index: -1
        top_signame: por_n
      }
      {
        name: pwr
        desc:
          '''
          Reset request signals from power manager.
          Power manager can request for specific domains of the lc/sys reset tree to assert.
          '''
        struct: pwr_rst
        type: req_rsp
        act: rsp
        width: 1
        inst_name: rstmgr
        default: ""
        package: pwrmgr_pkg
        domain: Aon
        top_signame: pwrmgr_pwr_rst
        index: -1
      }
      {
        name: resets
        desc: Leaf resets fed to the system.
        struct: rstmgr_out
        package: rstmgr_pkg
        type: uni
        act: req
        width: 1
        inst_name: rstmgr
        default: ""
        top_signame: rstmgr_resets
        index: -1
        external: true
        conn_type: true
      }
      {
        name: rst_en
        desc: Low-power-group outputs used by alert handler.
        struct: rstmgr_rst_en
        package: rstmgr_pkg
        type: uni
        act: req
        width: 1
        inst_name: rstmgr
        default: ""
        top_signame: rstmgr_rst_en
        index: -1
        external: true
        conn_type: true
      }
      {
        name: alert_dump
        desc: Alert handler crash dump information.
        struct: alert_crashdump
        package: alert_handler_pkg
        type: uni
        act: rcv
        width: 1
        inst_name: rstmgr
        default: ""
        domain: Aon
        top_signame: alert_handler_crashdump
        index: -1
        external: true
        conn_type: false
      }
      {
        name: cpu_dump
        desc: Main processing element crash dump information.
        struct: cpu_crash_dump
        package: rv_core_ibex_pkg
        type: uni
        act: rcv
        width: 1
        inst_name: rstmgr
        default: ""
        domain: Aon
        top_signame: rv_core_ibex_crash_dump
        index: -1
        external: true
        conn_type: false
      }
      {
        name: sw_rst_req
        desc: Software requested system reset to pwrmgr.
        struct: mubi4
        package: prim_mubi_pkg
        type: uni
        act: req
        width: 1
        inst_name: rstmgr
        default: ""
        end_idx: -1
        top_type: broadcast
        top_signame: rstmgr_sw_rst_req
        index: -1
      }
      {
        name: tl
        struct: tl
        package: tlul_pkg
        type: req_rsp
        act: rsp
        width: 1
        inst_name: rstmgr
        default: ""
        end_idx: -1
        top_type: one-to-one
        top_signame: rstmgr_tl
        index: -1
        external: true
        conn_type: false
      }
      {
        name: clocks
        struct: clkmgr_out
        package: clkmgr_pkg
        type: uni
        act: req
        width: 1
        inst_name: clkmgr
        default: ""
        top_signame: clkmgr_clocks
        index: -1
        external: true
        conn_type: true
      }
      {
        name: cg_en
        struct: clkmgr_cg_en
        package: clkmgr_pkg
        type: uni
        act: req
        width: 1
        inst_name: clkmgr
        default: ""
        top_signame: clkmgr_cg_en
        index: -1
        external: true
        conn_type: true
      }
      {
        name: jitter_en
        struct: mubi4
        package: prim_mubi_pkg
        type: uni
        act: req
        width: 1
        inst_name: clkmgr
        default: ""
        external: true
        conn_type: false
        index: -1
        top_signame: clk_main_jitter_en
      }
      {
        name: pwr
        struct: pwr_clk
        type: req_rsp
        act: rsp
        width: 1
        inst_name: clkmgr
        default: ""
        package: pwrmgr_pkg
        domain: Aon
        top_signame: pwrmgr_pwr_clk
        index: -1
      }
      {
        name: idle
        struct: mubi4
        package: prim_mubi_pkg
        type: uni
        act: rcv
        width: 4
        inst_name: clkmgr
        default: ""
        end_idx: -1
        top_type: one-to-N
        top_signame: clkmgr_idle
        index: -1
        external: true
        conn_type: false
      }
      {
        name: tl
        struct: tl
        package: tlul_pkg
        type: req_rsp
        act: rsp
        width: 1
        inst_name: clkmgr
        default: ""
        end_idx: -1
        top_type: one-to-one
        top_signame: clkmgr_tl
        index: -1
        external: true
        conn_type: false
      }
      {
        name: sleep_en
        desc: Level signal that is asserted when the power manager enters sleep.
        struct: logic
        type: uni
        act: rcv
        width: 1
        default: 1'b0
        inst_name: pinmux
        package: ""
        domain: Main
        top_signame: pwrmgr_low_power
        index: -1
        external: true
        conn_type: false
      }
      {
        name: pin_wkup_req
        desc: Wakeup request from wakeup detectors, to the power manager, running on the AON clock.
        struct: logic
        type: uni
        act: req
        width: 1
        default: 1'b0
        inst_name: pinmux
        package: ""
        domain: Main
        top_signame: pwrmgr_wakeups
        index: -1
        external: true
        conn_type: false
      }
      {
        name: tl
        struct: tl
        package: tlul_pkg
        type: req_rsp
        act: rsp
        width: 1
        inst_name: pinmux
        default: ""
        end_idx: -1
        top_type: one-to-one
        top_signame: pinmux_tl
        index: -1
      }
      {
        name: nmi_wdog_timer_bark
        struct: logic
        type: uni
        act: req
        width: 1
        default: 1'b0
        inst_name: aon_timer
        package: ""
        end_idx: -1
        top_type: broadcast
        top_signame: aon_timer_nmi_wdog_timer_bark
        index: -1
        external: true
        conn_type: false
      }
      {
        name: wkup_req
        struct: logic
        type: uni
        act: req
        width: 1
        default: 1'b0
        inst_name: aon_timer
        package: ""
        domain: Aon
        top_signame: pwrmgr_wakeups
        index: 1
      }
      {
        name: aon_timer_rst_req
        struct: logic
        type: uni
        act: req
        width: 1
        default: 1'b0
        inst_name: aon_timer
        package: ""
        domain: Aon
        top_signame: pwrmgr_rstreqs
        index: 0
      }
      {
        name: lc_escalate_en
        struct: lc_tx
        package: lc_ctrl_pkg
        type: uni
        act: rcv
        width: 1
        default: lc_ctrl_pkg::Off
        inst_name: aon_timer
        domain: Aon
        top_signame: lc_ctrl_lc_escalate_en
        index: -1
        external: true
        conn_type: false
      }
      {
        name: sleep_mode
        struct: logic
        type: uni
        act: rcv
        width: 1
        inst_name: aon_timer
        default: ""
        package: ""
        domain: Aon
        top_signame: pwrmgr_low_power
        index: -1
      }
      {
        name: racl_policies
        desc:
          '''
          Incoming RACL policy vector from a racl_ctrl instance.
          The policy selection vector (parameter) selects the policy for each register.
          '''
        struct: racl_policy_vec
        package: top_racl_pkg
        type: uni
        act: rcv
        width: 1
        inst_name: aon_timer
        index: -1
      }
      {
        name: racl_error
        desc: RACL error log information of this module.
        struct: racl_error_log
        package: top_racl_pkg
        type: uni
        act: req
        width: 1
        inst_name: aon_timer
        index: -1
      }
      {
        name: tl
        struct: tl
        package: tlul_pkg
        type: req_rsp
        act: rsp
        width: 1
        inst_name: aon_timer
        default: ""
        end_idx: -1
        top_type: one-to-one
        top_signame: aon_timer_tl
        index: -1
        external: true
        conn_type: false
      }
      {
        name: tl
        struct: tl
        package: tlul_pkg
        type: req_rsp
        act: rsp
        width: 1
        inst_name: ast
        index: -1
      }
      {
        name: dma_tl_h2d
        desc: TL-UL host port for the DMA to egress into CTN (request part), synchronous
        struct: tl_h2d
        package: tlul_pkg
        type: uni
        act: rcv
        width: 1
        inst_name: soc_proxy
        default: ""
        end_idx: -1
        top_type: broadcast
        top_signame: soc_proxy_dma_tl_h2d
        index: -1
        external: true
        conn_type: false
      }
      {
        name: dma_tl_d2h
        desc: TL-UL host port for the DMA to egress into CTN (response part), synchronous
        struct: tl_d2h
        package: tlul_pkg
        type: uni
        act: req
        width: 1
        inst_name: soc_proxy
        default: ""
        end_idx: -1
        top_type: broadcast
        top_signame: soc_proxy_dma_tl_d2h
        index: -1
        external: true
        conn_type: false
      }
      {
        name: misc_tl_h2d
        desc: TL-UL host port for the MISC to egress into CTN (request part), synchronous
        struct: tl_h2d
        package: tlul_pkg
        type: uni
        act: rcv
        width: 1
        inst_name: soc_proxy
        default: ""
        external: true
        conn_type: false
        index: -1
        top_signame: ctn_misc_tl_h2d
      }
      {
        name: misc_tl_d2h
        desc: TL-UL host port for the MISC to egress into CTN (response part), synchronous
        struct: tl_d2h
        package: tlul_pkg
        type: uni
        act: req
        width: 1
        inst_name: soc_proxy
        default: ""
        external: true
        conn_type: false
        index: -1
        top_signame: ctn_misc_tl_d2h
      }
      {
        name: wkup_external_req
        struct: logic
        type: uni
        act: req
        width: 1
        inst_name: soc_proxy
        default: ""
        package: ""
        domain: Aon
        top_signame: pwrmgr_wakeups
        index: 2
      }
      {
        name: rst_req_external
        struct: logic
        type: uni
        act: req
        width: 1
        inst_name: soc_proxy
        default: ""
        package: ""
        domain: Aon
        top_signame: pwrmgr_rstreqs
        index: 1
      }
      {
        name: ctn_tl_h2d
        desc: TL-UL host port for egress into CTN (request part), synchronous
        struct: tl_h2d
        package: tlul_pkg
        type: uni
        act: req
        width: 1
        inst_name: soc_proxy
        default: ""
        end_idx: -1
        top_type: broadcast
        top_signame: soc_proxy_ctn_tl_h2d
        index: -1
        external: true
        conn_type: false
      }
      {
        name: ctn_tl_d2h
        desc: TL-UL host port for egress into CTN (response part), synchronous
        struct: tl_d2h
        package: tlul_pkg
        type: uni
        act: rcv
        width: 1
        inst_name: soc_proxy
        default: ""
        end_idx: -1
        top_type: broadcast
        top_signame: soc_proxy_ctn_tl_d2h
        index: -1
        external: true
        conn_type: false
      }
      {
        name: i2c_lsio_trigger
        desc: LSIO trigger signal from I2C
        struct: logic
        type: uni
        act: rcv
        width: 1
        inst_name: soc_proxy
        default: ""
        package: ""
        domain: Aon
        top_signame: i2c0_lsio_trigger
        index: -1
        external: true
        conn_type: false
      }
      {
        name: spi_host_lsio_trigger
        desc: LSIO trigger signal from SPI Host
        struct: logic
        type: uni
        act: rcv
        width: 1
        inst_name: soc_proxy
        default: ""
        package: ""
        domain: Aon
        top_signame: spi_host0_lsio_trigger
        index: -1
        external: true
        conn_type: false
      }
      {
        name: uart_lsio_trigger
        desc: LSIO trigger signal from UART
        struct: logic
        type: uni
        act: rcv
        width: 1
        inst_name: soc_proxy
        default: ""
        package: ""
        domain: Aon
        top_signame: uart0_lsio_trigger
        index: -1
        external: true
        conn_type: false
      }
      {
        name: soc_lsio_trigger
        desc: LSIO trigger signal from SoC, synchronous
        struct: logic
        type: uni
        act: rcv
        width: 8
        inst_name: soc_proxy
        default: ""
        package: ""
        external: true
        conn_type: false
        index: -1
        top_signame: soc_lsio_trigger
      }
      {
        name: dma_lsio_trigger
        desc: Collated synchronous LSIO trigger signals for DMA
        struct: lsio_trigger
        package: dma_pkg
        type: uni
        act: req
        width: 1
        inst_name: soc_proxy
        default: ""
        domain: Aon
        top_signame: dma_lsio_trigger
        index: -1
        external: true
        conn_type: false
      }
      {
        name: soc_wkup_async
        desc: Wakeup request from SoC, asynchronous, level-encoded
        struct: logic
        type: uni
        act: rcv
        width: 1
        inst_name: soc_proxy
        default: ""
        package: ""
        external: true
        conn_type: false
        index: -1
        top_signame: soc_wkup_async
      }
      {
        name: soc_rst_req_async
        desc: Reset request from SoC, asynchronous, level-encoded
        struct: logic
        type: uni
        act: rcv
        width: 1
        inst_name: soc_proxy
        default: ""
        package: ""
        external: true
        conn_type: false
        index: -1
        top_signame: soc_rst_req_async
      }
      {
        name: soc_gpi_async
        desc: GPI from SoC, async
        struct: logic
        type: uni
        act: req
        width: 16
        inst_name: soc_proxy
        default: ""
        package: ""
        external: true
        conn_type: false
        index: -1
        top_signame: soc_gpi_async
      }
      {
        name: soc_gpo_async
        desc: GPO from SoC, async
        struct: logic
        type: uni
        act: rcv
        width: 16
        inst_name: soc_proxy
        default: ""
        package: ""
        external: true
        conn_type: false
        index: -1
        top_signame: soc_gpo_async
      }
      {
        name: integrator_id
        desc: Integrator ID signal used in BAT
        struct: logic
        type: uni
        act: rcv
        width: 4
        inst_name: soc_proxy
        default: ""
        package: ""
        external: true
        conn_type: false
        index: -1
        top_signame: integrator_id
      }
      {
        name: core_tl
        struct: tl
        package: tlul_pkg
        type: req_rsp
        act: rsp
        width: 1
        inst_name: soc_proxy
        default: ""
        end_idx: -1
        top_type: one-to-one
        top_signame: soc_proxy_core_tl
        index: -1
        external: true
        conn_type: false
      }
      {
        name: ctn_tl
        struct: tl
        package: tlul_pkg
        type: req_rsp
        act: rsp
        width: 1
        inst_name: soc_proxy
        default: ""
        end_idx: -1
        top_type: one-to-one
        top_signame: soc_proxy_ctn_tl
        index: -1
        external: true
        conn_type: false
      }
      {
        name: sram_otp_key
        struct: sram_otp_key
        package: otp_ctrl_pkg
        type: req_rsp
        act: req
        width: 1
        inst_name: sram_ctrl_ret
        default: ""
        domain: Aon
        top_signame: otp_ctrl_sram_otp_key
        index: -1
        external: true
        conn_type: false
      }
      {
        name: ram_cfg
        struct: ram_1p_cfg
        package: prim_ram_1p_pkg
        type: req_rsp
        act: rsp
        width:
        {
          name: NumRamInst
          desc: Number of internal RAM instances. Must be the same as ceil(MemSizeRam / InstSize) .
          param_type: int
          unpacked_dimensions: null
          default: 1
          local: false
          expose: true
          name_top: SramCtrlRetNumRamInst
        }
        inst_name: sram_ctrl_ret
        default: ""
        external: true
        conn_type: false
        index: -1
        top_signame: sram_ctrl_ret_ram_cfg
      }
      {
        name: lc_escalate_en
        struct: lc_tx
        package: lc_ctrl_pkg
        type: uni
        act: rcv
        width: 1
        default: lc_ctrl_pkg::Off
        inst_name: sram_ctrl_ret
        domain: Aon
        top_signame: lc_ctrl_lc_escalate_en
        index: -1
        external: true
        conn_type: false
      }
      {
        name: lc_hw_debug_en
        struct: lc_tx
        package: lc_ctrl_pkg
        type: uni
        act: rcv
        width: 1
        default: lc_ctrl_pkg::Off
        inst_name: sram_ctrl_ret
        index: -1
      }
      {
        name: otp_en_sram_ifetch
        struct: mubi8
        package: prim_mubi_pkg
        type: uni
        act: rcv
        width: 1
        default: prim_mubi_pkg::MuBi8False
        inst_name: sram_ctrl_ret
        index: -1
      }
      {
        name: racl_policies
        desc:
          '''
          Incoming RACL policy vector from a racl_ctrl instance.
          The policy selection vector (parameter) selects the policy for each register.
          '''
        struct: racl_policy_vec
        package: top_racl_pkg
        type: uni
        act: rcv
        width: 1
        inst_name: sram_ctrl_ret
        index: -1
      }
      {
        name: racl_error
        desc: RACL error log information of this module.
        struct: racl_error_log
        package: top_racl_pkg
        type: uni
        act: req
        width: 1
        inst_name: sram_ctrl_ret
        index: -1
      }
      {
        name: sram_rerror
        desc: SRAM read error indicating correctable and uncorrectable ECC errors.
        struct: sram_error_t
        package: sram_ctrl_pkg
        type: uni
        act: req
        width: 1
        inst_name: sram_ctrl_ret
        index: -1
      }
      {
        name: regs_tl
        struct: tl
        package: tlul_pkg
        type: req_rsp
        act: rsp
        width: 1
        inst_name: sram_ctrl_ret
        default: ""
        end_idx: -1
        top_type: one-to-one
        top_signame: sram_ctrl_ret_regs_tl
        index: -1
        external: true
        conn_type: false
      }
      {
        name: ram_tl
        struct: tl
        package: tlul_pkg
        type: req_rsp
        act: rsp
        width: 1
        inst_name: sram_ctrl_ret
        default: ""
        end_idx: -1
        top_type: one-to-one
        top_signame: sram_ctrl_ret_ram_tl
        index: -1
        external: true
        conn_type: false
      }
      {
        name: next_dm_addr
        desc:
          '''
          32bit word address of the next debug module.
          Set to 0x0 if this is the last debug module in the chain.
          '''
        struct: next_dm_addr
        package: rv_dm_pkg
        type: uni
        act: rcv
        width: 1
        default: "'0"
        inst_name: rv_dm
        external: true
        conn_type: false
        index: -1
        top_signame: rv_dm_next_dm_addr
      }
      {
        name: jtag
        desc: JTAG signals for the RISC-V TAP.
        struct: jtag
        package: jtag_pkg
        type: req_rsp
        act: rsp
        width: 1
        inst_name: rv_dm
        index: -1
      }
      {
        name: cheriot_ena
        desc:
          '''
          CHERIoT mode enable.
          Selects which ROM and which abstract command encodings the debug module uses.
          Ignored unless CheriotSupport is set.
          '''
        struct: mubi4
        package: prim_mubi_pkg
        type: uni
        act: rcv
        width: 1
        default: prim_mubi_pkg::MuBi4False
        inst_name: rv_dm
        index: -1
      }
      {
        name: lc_init_done
        desc: Lifecycle initialization done signal coming from life cycle controller.
        struct: lc_tx
        package: lc_ctrl_pkg
        type: uni
        act: rcv
        width: 1
        default: lc_ctrl_pkg::Off
        inst_name: rv_dm
        domain: Main
        top_signame: lc_ctrl_lc_init_done
        index: -1
      }
      {
        name: lc_hw_debug_clr
        desc:
          '''
          Multibit life cycle hardware debug clear signal coming from life cycle controller,
          asserted when the hardware debug mechanism was enabled and gets disabled.
          '''
        struct: lc_tx
        package: lc_ctrl_pkg
        type: uni
        act: rcv
        width: 1
        default: lc_ctrl_pkg::Off
        inst_name: rv_dm
        domain: Main
        top_signame: lc_ctrl_lc_hw_debug_clr
        index: -1
      }
      {
        name: lc_hw_debug_en
        desc:
          '''
          Multibit life cycle hardware debug enable signal coming from life cycle controller,
          asserted when the hardware debug mechanisms are enabled in the system.
          '''
        struct: lc_tx
        package: lc_ctrl_pkg
        type: uni
        act: rcv
        width: 1
        default: lc_ctrl_pkg::Off
        inst_name: rv_dm
        domain: Main
        top_signame: lc_ctrl_lc_hw_debug_en
        index: -1
      }
      {
        name: lc_dft_en
        desc:
          '''
          Multibit life cycle hardware debug enable signal coming from life cycle controller,
          asserted when the DFT mechanisms are enabled in the system.
          '''
        struct: lc_tx
        package: lc_ctrl_pkg
        type: uni
        act: rcv
        width: 1
        default: lc_ctrl_pkg::Off
        inst_name: rv_dm
        domain: Main
        top_signame: lc_ctrl_lc_dft_en
        index: -1
      }
      {
        name: pinmux_hw_debug_en
        desc:
          '''
          Multibit life cycle hardware debug enable signal coming from pinmux.
          This is a latched version of the lc_hw_debug_en signal and is only used to
          gate the JTAG / TAP side of the RV_DM. It is used to keep a debug session live
          while the rest of the system undergoes an NDM reset.
          '''
        struct: lc_tx
        package: lc_ctrl_pkg
        type: uni
        act: rcv
        width: 1
        default: lc_ctrl_pkg::Off
        inst_name: rv_dm
        index: -1
      }
      {
        name: otp_dis_rv_dm_late_debug
        struct: mubi8
        package: prim_mubi_pkg
        type: uni
        act: rcv
        width: 1
        default: prim_mubi_pkg::MuBi8False
        inst_name: rv_dm
        top_signame: rv_dm_otp_dis_rv_dm_late_debug
        index: -1
      }
      {
        name: unavailable
        desc:
          '''
          This signal indicates to the debug module that the main processor is not available
          for debug (e.g. due to a low-power state).
          '''
        struct: logic
        type: uni
        act: rcv
        width: 1
        default: 1'b0
        inst_name: rv_dm
        index: -1
      }
      {
        name: ndmreset_req
        desc: Non-debug module reset request going to the system reset infrastructure.
        struct: logic
        type: uni
        act: req
        width: 1
        inst_name: rv_dm
        default: ""
        package: ""
        end_idx: -1
        top_type: broadcast
        top_signame: rv_dm_ndmreset_req
        index: -1
        external: true
        conn_type: false
      }
      {
        name: dmactive
        desc:
          '''
          This signal indicates whether the debug module is active and can be used to prevent
          power down of the core and bus-attached peripherals.
          '''
        struct: logic
        type: uni
        act: req
        width: 1
        inst_name: rv_dm
        index: -1
      }
      {
        name: debug_req
        desc: This is the debug request interrupt going to the main processor.
        struct: logic [rv_dm_reg_pkg::NrHarts-1:0]
        type: uni
        act: req
        width: 1
        inst_name: rv_dm
        default: ""
        package: ""
        end_idx: -1
        top_type: broadcast
        top_signame: rv_dm_debug_req
        index: -1
      }
      {
        name: lc_escalate_en
        desc:
          '''
          Escalation enable signal coming from life cycle controller, used for invalidating
          the latched lc_hw_debug_en state inside the strap sampling logic.
          '''
        struct: lc_tx
        package: lc_ctrl_pkg
        type: uni
        act: rcv
        width: 1
        default: lc_ctrl_pkg::Off
        inst_name: rv_dm
        domain: Main
        top_signame: lc_ctrl_lc_escalate_en
        index: -1
      }
      {
        name: lc_check_byp_en
        desc:
          '''
          Check bypass enable signal coming from life cycle controller, used for invalidating
          the latched lc_hw_debug_en state inside the strap sampling logic. This signal is asserted
          whenever the life cycle controller performs a life cycle transition. Its main use is
          to skip any background checks inside the life cycle partition of the OTP controller while
          a life cycle transition is in progress.
          '''
        struct: lc_tx
        package: lc_ctrl_pkg
        type: uni
        act: rcv
        width: 1
        default: lc_ctrl_pkg::Off
        inst_name: rv_dm
        domain: Main
        top_signame: lc_ctrl_lc_check_byp_en
        index: -1
      }
      {
        name: strap_en
        desc: This signal is pulsed high by the power manager after reset in order to sample the HW straps.
        struct: logic
        type: uni
        act: rcv
        width: 1
        default: 1'b0
        inst_name: rv_dm
        package: ""
        domain: Main
        top_signame: pwrmgr_strap
        index: -1
        external: true
        conn_type: false
      }
      {
        name: strap_en_override
        desc:
          '''
          This signal transitions from 0 -> 1 by the lc_ctrl manager after volatile RAW_UNLOCK in order to re-sample the HW straps.
          The signal must stay at 1 until reset.
          Note that this is only used in test chips when SecVolatileRawUnlockEn = 1.
          Otherwise this signal is unused.
          '''
        struct: logic
        type: uni
        act: rcv
        width: 1
        default: 1'b0
        inst_name: rv_dm
        package: ""
        domain: Main
        top_signame: lc_ctrl_strap_en_override
        index: -1
      }
      {
        name: racl_policies
        desc:
          '''
          Incoming RACL policy vector from a racl_ctrl instance.
          The policy selection vector (parameter) selects the policy for each register.
          '''
        struct: racl_policy_vec
        package: top_racl_pkg
        type: uni
        act: rcv
        width: 1
        inst_name: rv_dm
        index: -1
      }
      {
        name: racl_error
        desc: RACL error log information of this module.
        struct: racl_error_log
        package: top_racl_pkg
        type: uni
        act: req
        width: 1
        inst_name: rv_dm
        index: -1
      }
      {
        name: sba_tl_h
        struct: tl
        package: tlul_pkg
        type: req_rsp
        act: req
        width: 1
        inst_name: rv_dm
        default: ""
        domain: Main
        top_signame: main_tl_rv_dm__sba
        index: -1
      }
      {
        name: regs_tl_d
        struct: tl
        package: tlul_pkg
        type: req_rsp
        act: rsp
        width: 1
        inst_name: rv_dm
        default: ""
        end_idx: -1
        top_type: one-to-one
        top_signame: rv_dm_regs_tl_d
        index: -1
      }
      {
        name: mem_tl_d
        struct: tl
        package: tlul_pkg
        type: req_rsp
        act: rsp
        width: 1
        inst_name: rv_dm
        default: ""
        end_idx: -1
        top_type: one-to-one
        top_signame: rv_dm_mem_tl_d
        index: -1
      }
      {
        name: dbg_tl_d
        struct: tl
        package: tlul_pkg
        type: req_rsp
        act: rsp
        width: 1
        inst_name: rv_dm
        default: ""
        end_idx: -1
        top_type: one-to-one
        top_signame: rv_dm_dbg_tl_d
        index: -1
      }
      {
        name: irq
        struct: logic
        type: uni
        act: req
        width: 1
        inst_name: rv_plic
        default: ""
        package: ""
        end_idx: -1
        top_type: broadcast
        top_signame: rv_plic_irq
        index: -1
      }
      {
        name: irq_id
        struct: logic
        type: uni
        act: req
        width: 1
        inst_name: rv_plic
        index: -1
      }
      {
        name: msip
        struct: logic
        type: uni
        act: req
        width: 1
        inst_name: rv_plic
        default: ""
        package: ""
        end_idx: -1
        top_type: broadcast
        top_signame: rv_plic_msip
        index: -1
      }
      {
        name: tl
        struct: tl
        package: tlul_pkg
        type: req_rsp
        act: rsp
        width: 1
        inst_name: rv_plic
        default: ""
        end_idx: -1
        top_type: one-to-one
        top_signame: rv_plic_tl
        index: -1
      }
      {
        name: idle
        struct: mubi4
        package: prim_mubi_pkg
        type: uni
        act: req
        width: 1
        inst_name: aes
        default: ""
        domain: Main
        top_signame: clkmgr_idle
        index: 0
        external: true
        conn_type: false
      }
      {
        name: output_valid
        struct: logic
        type: uni
        act: req
        width: 1
        inst_name: aes
        index: -1
      }
      {
        name: input_ready
        struct: logic
        type: uni
        act: req
        width: 1
        inst_name: aes
        index: -1
      }
      {
        name: lc_escalate_en
        struct: lc_tx
        package: lc_ctrl_pkg
        type: uni
        act: rcv
        width: 1
        default: lc_ctrl_pkg::Off
        inst_name: aes
        domain: Main
        top_signame: lc_ctrl_lc_escalate_en
        index: -1
      }
      {
        name: edn
        struct: edn
        package: edn_pkg
        type: req_rsp
        act: req
        width: 1
        inst_name: aes
        default: ""
        domain: Main
        top_signame: edn0_edn
        index: 4
      }
      {
        name: keymgr_key
        struct: hw_key_req
        package: keymgr_dpe_pkg
        type: uni
        act: rcv
        width: 1
        inst_name: aes
        default: ""
        domain: Main
        top_signame: keymgr_dpe_aes_key
        index: -1
      }
      {
        name: tl
        struct: tl
        package: tlul_pkg
        type: req_rsp
        act: rsp
        width: 1
        inst_name: aes
        default: ""
        end_idx: -1
        top_type: one-to-one
        top_signame: aes_tl
        index: -1
      }
      {
        name: idle
        struct: mubi4
        package: prim_mubi_pkg
        type: uni
        act: req
        width: 1
        inst_name: hmac
        default: ""
        domain: Main
        top_signame: clkmgr_idle
        index: 1
        external: true
        conn_type: false
      }
      {
        name: keymgr_key
        struct: wide_hw_key_req
        package: keymgr_dpe_pkg
        type: uni
        act: rcv
        width: 1
        inst_name: hmac
        default: ""
        domain: Main
        top_signame: keymgr_dpe_hmac_key
        index: -1
      }
      {
        name: tl
        struct: tl
        package: tlul_pkg
        type: req_rsp
        act: rsp
        width: 1
        inst_name: hmac
        default: ""
        end_idx: -1
        top_type: one-to-one
        top_signame: hmac_tl
        index: -1
      }
      {
        name: keymgr_key
        struct: hw_key_req
        package: keymgr_dpe_pkg
        type: uni
        act: rcv
        width: 1
        inst_name: kmac
        default: ""
        domain: Main
        top_signame: keymgr_dpe_kmac_key
        index: -1
      }
      {
        name: app
        struct: app
        package: kmac_pkg
        type: req_rsp
        act: rsp
        width:
        {
          name: NumAppIntf
          desc: Number of application interfaces
          param_type: int
          unpacked_dimensions: null
          default: 4
          local: false
          expose: true
          name_top: KmacNumAppIntf
        }
        default: kmac_pkg::APP_REQ_DEFAULT
        inst_name: kmac
        end_idx: -1
        top_type: one-to-N
        top_signame: kmac_app
        index: -1
      }
      {
        name: keymgr_sensitive_key
        struct: mubi4
        package: prim_mubi_pkg
        type: uni
        act: rcv
        width: 1
        default: prim_mubi_pkg::MuBi4False
        inst_name: kmac
        end_idx: -1
        top_type: broadcast
        top_signame: kmac_keymgr_sensitive_key
        index: -1
      }
      {
        name: entropy
        struct: edn
        package: edn_pkg
        type: req_rsp
        act: req
        width: 1
        inst_name: kmac
        default: ""
        domain: Main
        top_signame: edn0_edn
        index: 2
      }
      {
        name: idle
        struct: mubi4
        package: prim_mubi_pkg
        type: uni
        act: req
        width: 1
        inst_name: kmac
        default: ""
        domain: Main
        top_signame: clkmgr_idle
        index: 2
        external: true
        conn_type: false
      }
      {
        name: en_masking
        struct: logic
        type: uni
        act: req
        width: 1
        inst_name: kmac
        default: ""
        package: ""
        end_idx: -1
        top_type: broadcast
        top_signame: kmac_en_masking
        index: -1
      }
      {
        name: lc_escalate_en
        struct: lc_tx
        package: lc_ctrl_pkg
        type: uni
        act: rcv
        width: 1
        default: lc_ctrl_pkg::Off
        inst_name: kmac
        domain: Main
        top_signame: lc_ctrl_lc_escalate_en
        index: -1
      }
      {
        name: tl
        struct: tl
        package: tlul_pkg
        type: req_rsp
        act: rsp
        width: 1
        inst_name: kmac
        default: ""
        end_idx: -1
        top_type: one-to-one
        top_signame: kmac_tl
        index: -1
      }
      {
        name: otbn_otp_key
        struct: otbn_otp_key
        package: otp_ctrl_pkg
        type: req_rsp
        act: req
        width: 1
        default: "'0"
        inst_name: otbn
        domain: Main
        top_signame: otp_ctrl_otbn_otp_key
        index: -1
      }
      {
        name: edn_rnd
        struct: edn
        package: edn_pkg
        type: req_rsp
        act: req
        width: 1
        inst_name: otbn
        default: ""
        domain: Main
        top_signame: edn1_edn
        index: 0
      }
      {
        name: edn_urnd
        struct: edn
        package: edn_pkg
        type: req_rsp
        act: req
        width: 1
        inst_name: otbn
        default: ""
        domain: Main
        top_signame: edn0_edn
        index: 5
      }
      {
        name: idle
        struct: mubi4
        package: prim_mubi_pkg
        type: uni
        act: req
        width: 1
        inst_name: otbn
        default: ""
        domain: Main
        top_signame: clkmgr_idle
        index: 3
        external: true
        conn_type: false
      }
      {
        name: ram_cfg_imem
        struct: ram_1p_cfg
        package: prim_ram_1p_pkg
        type: req_rsp
        act: rsp
        width: 1
        inst_name: otbn
        default: ""
        external: true
        conn_type: false
        index: -1
        top_signame: otbn_imem_ram_cfg
      }
      {
        name: ram_cfg_dmem
        struct: ram_1p_cfg
        package: prim_ram_1p_pkg
        type: req_rsp
        act: rsp
        width: 1
        inst_name: otbn
        default: ""
        external: true
        conn_type: false
        index: -1
        top_signame: otbn_dmem_ram_cfg
      }
      {
        name: lc_escalate_en
        struct: lc_tx
        package: lc_ctrl_pkg
        type: uni
        act: rcv
        width: 1
        default: lc_ctrl_pkg::Off
        inst_name: otbn
        domain: Main
        top_signame: lc_ctrl_lc_escalate_en
        index: -1
      }
      {
        name: lc_rma_req
        struct: lc_tx
        package: lc_ctrl_pkg
        type: uni
        act: rcv
        width: 1
        default: lc_ctrl_pkg::Off
        inst_name: otbn
        domain: Main
        top_signame: lc_ctrl_lc_nvm_rma_req
        index: -1
      }
      {
        name: lc_rma_ack
        struct: lc_tx
        package: lc_ctrl_pkg
        type: uni
        act: req
        width: 1
        default: lc_ctrl_pkg::Off
        inst_name: otbn
        end_idx: -1
        top_type: broadcast
        top_signame: otbn_lc_rma_ack
        index: -1
      }
      {
        name: keymgr_key
        struct: wide_hw_key_req
        package: keymgr_dpe_pkg
        type: uni
        act: rcv
        width: 1
        inst_name: otbn
        default: ""
        domain: Main
        top_signame: keymgr_dpe_otbn_key
        index: -1
      }
      {
        name: kmac_app
        struct: app
        package: kmac_pkg
        type: req_rsp
        act: req
        width: 1
        inst_name: otbn
        index: -1
      }
      {
        name: keymgr_app
        struct: app
        package: kmac_pkg
        type: req_rsp
        act: rsp
        width: 1
        inst_name: otbn
        default: ""
        end_idx: -1
        top_type: one-to-one
        top_signame: otbn_keymgr_app
        index: -1
      }
      {
        name: keymgr_sensitive_key
        struct: mubi4
        package: prim_mubi_pkg
        type: uni
        act: rcv
        width: 1
        default: prim_mubi_pkg::MuBi4False
        inst_name: otbn
        end_idx: -1
        top_type: broadcast
        top_signame: otbn_keymgr_sensitive_key
        index: -1
      }
      {
        name: tl
        struct: tl
        package: tlul_pkg
        type: req_rsp
        act: rsp
        width: 1
        inst_name: otbn
        default: ""
        end_idx: -1
        top_type: one-to-one
        top_signame: otbn_tl
        index: -1
      }
      {
        name: edn
        struct: edn
        package: edn_pkg
        type: req_rsp
        act: req
        width: 1
        inst_name: keymgr_dpe
        default: ""
        domain: Main
        top_signame: edn0_edn
        index: 0
      }
      {
        name: aes_key
        struct: hw_key_req
        package: keymgr_dpe_pkg
        type: uni
        act: req
        width: 1
        inst_name: keymgr_dpe
        default: ""
        end_idx: -1
        top_type: broadcast
        top_signame: keymgr_dpe_aes_key
        index: -1
      }
      {
        name: kmac_key
        struct: hw_key_req
        package: keymgr_dpe_pkg
        type: uni
        act: req
        width: 1
        inst_name: keymgr_dpe
        default: ""
        end_idx: -1
        top_type: broadcast
        top_signame: keymgr_dpe_kmac_key
        index: -1
      }
      {
        name: hmac_key
        struct: wide_hw_key_req
        package: keymgr_dpe_pkg
        type: uni
        act: req
        width: 1
        inst_name: keymgr_dpe
        default: ""
        end_idx: -1
        top_type: broadcast
        top_signame: keymgr_dpe_hmac_key
        index: -1
      }
      {
        name: otbn_key
        struct: wide_hw_key_req
        package: keymgr_dpe_pkg
        type: uni
        act: req
        width: 1
        inst_name: keymgr_dpe
        default: ""
        end_idx: -1
        top_type: broadcast
        top_signame: keymgr_dpe_otbn_key
        index: -1
      }
      {
        name: kmac_app
        struct: app
        package: kmac_pkg
        type: req_rsp
        act: req
        width: 1
        inst_name: keymgr_dpe
        default: ""
        domain: Main
        top_signame: kmac_app
        index: 0
      }
      {
        name: kmac_sensitive_key
        struct: mubi4
        package: prim_mubi_pkg
        type: uni
        act: req
        width: 1
        default: prim_mubi_pkg::MuBi4False
        inst_name: keymgr_dpe
        domain: Main
        top_signame: kmac_keymgr_sensitive_key
        index: -1
      }
      {
        name: otbn_app
        struct: app
        package: kmac_pkg
        type: req_rsp
        act: req
        width: 1
        inst_name: keymgr_dpe
        default: ""
        domain: Main
        top_signame: otbn_keymgr_app
        index: -1
      }
      {
        name: otbn_sensitive_key
        struct: mubi4
        package: prim_mubi_pkg
        type: uni
        act: req
        width: 1
        default: prim_mubi_pkg::MuBi4False
        inst_name: keymgr_dpe
        domain: Main
        top_signame: otbn_keymgr_sensitive_key
        index: -1
      }
      {
        name: creator_root_key
        struct: keymgr_dpe_creator_root_key
        package: keymgr_dpe_pkg
        type: uni
        act: rcv
        width: 1
        inst_name: keymgr_dpe
        default: ""
        domain: Main
        top_signame: otp_ctrl_keymgr_creator_root_key
        index: -1
      }
      {
        name: secondary_root_key
        struct: keymgr_dpe_creator_root_key
        package: keymgr_dpe_pkg
        type: uni
        act: rcv
        width: 1
        default: keymgr_dpe_pkg::KEYMGR_DPE_SECONDARY_ROOT_KEY_DEFAULT
        inst_name: keymgr_dpe
        index: -1
      }
      {
        name: creator_seed
        struct: keymgr_dpe_creator_seed
        package: keymgr_dpe_pkg
        type: uni
        act: rcv
        width: 1
        inst_name: keymgr_dpe
        default: ""
        domain: Main
        top_signame: otp_ctrl_keymgr_creator_seed
        index: -1
      }
      {
        name: owner_seed
        struct: keymgr_dpe_owner_seed
        package: keymgr_dpe_pkg
        type: uni
        act: rcv
        width: 1
        inst_name: keymgr_dpe
        default: ""
        domain: Main
        top_signame: otp_ctrl_keymgr_owner_seed
        index: -1
      }
      {
        name: device_id
        struct: keymgr_dpe_device_id
        package: keymgr_dpe_pkg
        type: uni
        act: rcv
        width: 1
        inst_name: keymgr_dpe
        default: ""
        top_signame: keymgr_dpe_device_id
        index: -1
      }
      {
        name: field_entropy
        struct: keymgr_dpe_field_entropy
        package: keymgr_dpe_pkg
        type: uni
        act: rcv
        width: 1
        inst_name: keymgr_dpe
        index: -1
      }
      {
        name: lc_keymgr_en
        struct: lc_tx
        package: lc_ctrl_pkg
        type: uni
        act: rcv
        width: 1
        default: lc_ctrl_pkg::On
        inst_name: keymgr_dpe
        domain: Main
        top_signame: lc_ctrl_lc_keymgr_en
        index: -1
      }
      {
        name: lc_keymgr_div
        struct: lc_keymgr_div
        package: lc_ctrl_pkg
        type: uni
        act: rcv
        width: 1
        inst_name: keymgr_dpe
        default: ""
        domain: Main
        top_signame: lc_ctrl_lc_keymgr_div
        index: -1
      }
      {
        name: rom_digest
        struct: keymgr_data
        package: rom_ctrl_pkg
        type: uni
        act: rcv
        width:
        {
          name: NumRomDigestInputs
          desc: Number of digest inputs from ROM_CTRL
          param_type: int
          unpacked_dimensions: null
          default: 1
          local: true
          expose: true
          name_top: KeymgrDpeNumRomDigestInputs
        }
        default: rom_ctrl_pkg::KEYMGR_DATA_DEFAULT
        inst_name: keymgr_dpe
        end_idx: -1
        top_type: one-to-N
        top_signame: keymgr_dpe_rom_digest
        index: -1
      }
      {
        name: kmac_en_masking
        struct: logic
        type: uni
        act: rcv
        width: 1
        inst_name: keymgr_dpe
        default: ""
        package: ""
        domain: Main
        top_signame: kmac_en_masking
        index: -1
      }
      {
        name: tl
        struct: tl
        package: tlul_pkg
        type: req_rsp
        act: rsp
        width: 1
        inst_name: keymgr_dpe
        default: ""
        end_idx: -1
        top_type: one-to-one
        top_signame: keymgr_dpe_tl
        index: -1
      }
      {
        name: csrng_cmd
        struct: csrng
        package: csrng_pkg
        type: req_rsp
        act: rsp
        width: 2
        inst_name: csrng
        default: ""
        end_idx: -1
        top_type: one-to-N
        top_signame: csrng_csrng_cmd
        index: -1
      }
      {
        name: entropy_src_hw_if
        struct: entropy_src_hw_if
        package: entropy_src_pkg
        type: req_rsp
        act: req
        width: 1
        inst_name: csrng
        default: ""
        end_idx: -1
        top_type: one-to-one
        top_signame: csrng_entropy_src_hw_if
        index: -1
      }
      {
        name: lc_hw_debug_en
        struct: lc_tx
        package: lc_ctrl_pkg
        type: uni
        act: rcv
        width: 1
        default: lc_ctrl_pkg::Off
        inst_name: csrng
        domain: Main
        top_signame: lc_ctrl_lc_hw_debug_en
        index: -1
      }
      {
        name: tl
        struct: tl
        package: tlul_pkg
        type: req_rsp
        act: rsp
        width: 1
        inst_name: csrng
        default: ""
        end_idx: -1
        top_type: one-to-one
        top_signame: csrng_tl
        index: -1
      }
      {
        name: entropy_src_hw_if
        struct: entropy_src_hw_if
        package: entropy_src_pkg
        type: req_rsp
        act: rsp
        width: 1
        inst_name: entropy_src
        default: ""
        domain: Main
        top_signame: csrng_entropy_src_hw_if
        index: -1
      }
      {
        name: entropy_src_rng_enable
        desc:
          '''
          Signal through which entropy_src enables the noise source.
          entropy_src will keep this signal high as long as it expects the noise source to operate.
          This is *not* a flow control signal through which entropy_src would exert backpressure on the noise source; rather this signal stays high while entropy_src is enabled.
          '''
        struct: logic
        type: uni
        act: req
        width: 1
        inst_name: entropy_src
        default: ""
        package: ""
        external: true
        conn_type: false
        index: -1
        top_signame: es_rng_enable
      }
      {
        name: entropy_src_rng_valid
        desc:
          '''
          Acknowledgement signal from the noise source.
          When '1', it indicates that the `entropy_src_rng_bit` data is valid and ready to be consumed.
          '''
        struct: logic
        type: uni
        act: rcv
        width: 1
        inst_name: entropy_src
        default: ""
        package: ""
        external: true
        conn_type: false
        index: -1
        top_signame: es_rng_valid
      }
      {
        name: entropy_src_rng_bits
        desc:
          '''
          Output data bus carrying the raw entropy bits from the noise source.
          These bits are valid when `entropy_src_rng_valid` is asserted.
          The width is determined by `RngBusWidth` parametrization.
          '''
        struct: logic
        type: uni
        act: rcv
        width:
        {
          name: RngBusWidth
          desc:
            '''
            Defines the bit-width of the noise source data.
            Must be between 4 and 256 (inclusive) and divisible by 4.
            The divisibility by 4 is a prerequisite for the bucket health test.
            '''
          param_type: int
          unpacked_dimensions: null
          default: 4
          local: false
          expose: true
          name_top: EntropySrcRngBusWidth
        }
        inst_name: entropy_src
        default: ""
        package: ""
        external: true
        conn_type: false
        index: -1
        top_signame: es_rng_bit
      }
      {
        name: entropy_src_xht_valid
        desc:
          '''
          Valid signal for the external health test interface.
          When asserted, it indicates that `entropy_src_xht_bits`, `entropy_src_xht_bit_sel`, and `entropy_src_xht_meta` are valid for consumption by the external health test.
          '''
        struct: logic
        type: uni
        act: req
        width: 1
        inst_name: entropy_src
        index: -1
      }
      {
        name: entropy_src_xht_bits
        desc:
          '''
          Carries the raw entropy data from the entropy source to be consumed by the external health test module.
          The data on this bus is valid when `entropy_src_xht_valid` is asserted.
          The width is determined by `RngBusWidth` parametrization.
          '''
        struct: logic
        type: uni
        act: req
        width:
        {
          name: RngBusWidth
          desc:
            '''
            Defines the bit-width of the noise source data.
            Must be between 4 and 256 (inclusive) and divisible by 4.
            The divisibility by 4 is a prerequisite for the bucket health test.
            '''
          param_type: int
          unpacked_dimensions: null
          default: 4
          local: false
          expose: true
          name_top: EntropySrcRngBusWidth
        }
        inst_name: entropy_src
        index: -1
      }
      {
        name: entropy_src_xht_bit_sel
        desc:
          '''
          Provides bit selection information for the raw entropy data.
          It specifies which specific bit or subset of bits from `entropy_src_xht_bit` should be used.
          The width is determined by `RngBusBitSelWidth` parametrization.
          '''
        struct: logic
        type: uni
        act: req
        width:
        {
          name: RngBusBitSelWidth
          desc: Explicit parameter defining the width of the RNG bit selection vector (log2(RngBusWidth))
          param_type: int
          unpacked_dimensions: null
          default: 2
          local: false
          expose: true
          name_top: EntropySrcRngBusBitSelWidth
        }
        inst_name: entropy_src
        index: -1
      }
      {
        name: entropy_src_xht_health_test_window
        desc: Provides the window size of the health in bits.
        struct: logic
        type: uni
        act: req
        width:
        {
          name: HealthTestWindowWidth
          desc: Explicit parameter defining the width of the health test window (16 + log2(RngBusWidth))
          param_type: int
          unpacked_dimensions: null
          default: 18
          local: false
          expose: true
          name_top: EntropySrcHealthTestWindowWidth
        }
        inst_name: entropy_src
        index: -1
      }
      {
        name: entropy_src_xht_meta
        struct: entropy_src_xht_meta
        package: entropy_src_pkg
        type: req_rsp
        act: req
        width: 1
        inst_name: entropy_src
        index: -1
      }
      {
        name: rng_fips
        struct: logic
        type: uni
        act: req
        width: 1
        inst_name: entropy_src
        default: ""
        package: ""
        external: true
        conn_type: false
        index: -1
        top_signame: es_rng_fips
      }
      {
        name: tl
        struct: tl
        package: tlul_pkg
        type: req_rsp
        act: rsp
        width: 1
        inst_name: entropy_src
        default: ""
        end_idx: -1
        top_type: one-to-one
        top_signame: entropy_src_tl
        index: -1
      }
      {
        name: csrng_cmd
        desc: EDN supports a single CSRNG application interface.
        struct: csrng
        package: csrng_pkg
        type: req_rsp
        act: req
        width: 1
        inst_name: edn0
        default: ""
        domain: Main
        top_signame: csrng_csrng_cmd
        index: 0
      }
      {
        name: edn
        desc: Every endpoint has its own peripheral port.
        struct: edn
        package: edn_pkg
        type: req_rsp
        act: rsp
        width:
        {
          name: NumEndPoints
          desc: Number of endpoints
          param_type: int unsigned
          unpacked_dimensions: null
          default: 8
          local: true
          expose: true
          name_top: Edn0NumEndPoints
        }
        default: "'0"
        inst_name: edn0
        end_idx: 7
        top_type: partial-one-to-N
        top_signame: edn0_edn
        index: -1
      }
      {
        name: tl
        struct: tl
        package: tlul_pkg
        type: req_rsp
        act: rsp
        width: 1
        inst_name: edn0
        default: ""
        end_idx: -1
        top_type: one-to-one
        top_signame: edn0_tl
        index: -1
      }
      {
        name: csrng_cmd
        desc: EDN supports a single CSRNG application interface.
        struct: csrng
        package: csrng_pkg
        type: req_rsp
        act: req
        width: 1
        inst_name: edn1
        default: ""
        domain: Main
        top_signame: csrng_csrng_cmd
        index: 1
      }
      {
        name: edn
        desc: Every endpoint has its own peripheral port.
        struct: edn
        package: edn_pkg
        type: req_rsp
        act: rsp
        width:
        {
          name: NumEndPoints
          desc: Number of endpoints
          param_type: int unsigned
          unpacked_dimensions: null
          default: 8
          local: true
          expose: true
          name_top: Edn1NumEndPoints
        }
        default: "'0"
        inst_name: edn1
        end_idx: -1
        top_type: one-to-one
        top_signame: edn1_edn
        index: -1
      }
      {
        name: tl
        struct: tl
        package: tlul_pkg
        type: req_rsp
        act: rsp
        width: 1
        inst_name: edn1
        default: ""
        end_idx: -1
        top_type: one-to-one
        top_signame: edn1_tl
        index: -1
      }
      {
        name: sram_otp_key
        struct: sram_otp_key
        package: otp_ctrl_pkg
        type: req_rsp
        act: req
        width: 1
        inst_name: sram_ctrl_main
        default: ""
        domain: Main
        top_signame: otp_ctrl_sram_otp_key
        index: 0
      }
      {
        name: ram_cfg
        struct: ram_1p_cfg
        package: prim_ram_1p_pkg
        type: req_rsp
        act: rsp
        width:
        {
          name: NumRamInst
          desc: Number of internal RAM instances. Must be the same as ceil(MemSizeRam / InstSize) .
          param_type: int
          unpacked_dimensions: null
          default: 1
          local: false
          expose: true
          name_top: SramCtrlMainNumRamInst
        }
        inst_name: sram_ctrl_main
        default: ""
        external: true
        conn_type: false
        index: -1
        top_signame: sram_ctrl_main_ram_cfg
      }
      {
        name: lc_escalate_en
        struct: lc_tx
        package: lc_ctrl_pkg
        type: uni
        act: rcv
        width: 1
        default: lc_ctrl_pkg::Off
        inst_name: sram_ctrl_main
        domain: Main
        top_signame: lc_ctrl_lc_escalate_en
        index: -1
      }
      {
        name: lc_hw_debug_en
        struct: lc_tx
        package: lc_ctrl_pkg
        type: uni
        act: rcv
        width: 1
        default: lc_ctrl_pkg::Off
        inst_name: sram_ctrl_main
        domain: Main
        top_signame: lc_ctrl_lc_hw_debug_en
        index: -1
      }
      {
        name: otp_en_sram_ifetch
        struct: mubi8
        package: prim_mubi_pkg
        type: uni
        act: rcv
        width: 1
        default: prim_mubi_pkg::MuBi8False
        inst_name: sram_ctrl_main
        top_signame: sram_ctrl_main_otp_en_sram_ifetch
        index: -1
      }
      {
        name: racl_policies
        desc:
          '''
          Incoming RACL policy vector from a racl_ctrl instance.
          The policy selection vector (parameter) selects the policy for each register.
          '''
        struct: racl_policy_vec
        package: top_racl_pkg
        type: uni
        act: rcv
        width: 1
        inst_name: sram_ctrl_main
        index: -1
      }
      {
        name: racl_error
        desc: RACL error log information of this module.
        struct: racl_error_log
        package: top_racl_pkg
        type: uni
        act: req
        width: 1
        inst_name: sram_ctrl_main
        index: -1
      }
      {
        name: sram_rerror
        desc: SRAM read error indicating correctable and uncorrectable ECC errors.
        struct: sram_error_t
        package: sram_ctrl_pkg
        type: uni
        act: req
        width: 1
        inst_name: sram_ctrl_main
        index: -1
      }
      {
        name: regs_tl
        struct: tl
        package: tlul_pkg
        type: req_rsp
        act: rsp
        width: 1
        inst_name: sram_ctrl_main
        default: ""
        end_idx: -1
        top_type: one-to-one
        top_signame: sram_ctrl_main_regs_tl
        index: -1
      }
      {
        name: ram_tl
        struct: tl
        package: tlul_pkg
        type: req_rsp
        act: rsp
        width: 1
        inst_name: sram_ctrl_main
        default: ""
        end_idx: -1
        top_type: one-to-one
        top_signame: sram_ctrl_main_ram_tl
        index: -1
      }
      {
        name: sram_otp_key
        struct: sram_otp_key
        package: otp_ctrl_pkg
        type: req_rsp
        act: req
        width: 1
        inst_name: sram_ctrl_mbox
        default: ""
        domain: Main
        top_signame: otp_ctrl_sram_otp_key
        index: 2
      }
      {
        name: ram_cfg
        struct: ram_1p_cfg
        package: prim_ram_1p_pkg
        type: req_rsp
        act: rsp
        width:
        {
          name: NumRamInst
          desc: Number of internal RAM instances. Must be the same as ceil(MemSizeRam / InstSize) .
          param_type: int
          unpacked_dimensions: null
          default: 1
          local: false
          expose: true
          name_top: SramCtrlMboxNumRamInst
        }
        inst_name: sram_ctrl_mbox
        default: ""
        external: true
        conn_type: false
        index: -1
        top_signame: sram_ctrl_mbox_ram_cfg
      }
      {
        name: lc_escalate_en
        struct: lc_tx
        package: lc_ctrl_pkg
        type: uni
        act: rcv
        width: 1
        default: lc_ctrl_pkg::Off
        inst_name: sram_ctrl_mbox
        domain: Main
        top_signame: lc_ctrl_lc_escalate_en
        index: -1
      }
      {
        name: lc_hw_debug_en
        struct: lc_tx
        package: lc_ctrl_pkg
        type: uni
        act: rcv
        width: 1
        default: lc_ctrl_pkg::Off
        inst_name: sram_ctrl_mbox
        index: -1
      }
      {
        name: otp_en_sram_ifetch
        struct: mubi8
        package: prim_mubi_pkg
        type: uni
        act: rcv
        width: 1
        default: prim_mubi_pkg::MuBi8False
        inst_name: sram_ctrl_mbox
        index: -1
      }
      {
        name: racl_policies
        desc:
          '''
          Incoming RACL policy vector from a racl_ctrl instance.
          The policy selection vector (parameter) selects the policy for each register.
          '''
        struct: racl_policy_vec
        package: top_racl_pkg
        type: uni
        act: rcv
        width: 1
        inst_name: sram_ctrl_mbox
        index: -1
      }
      {
        name: racl_error
        desc: RACL error log information of this module.
        struct: racl_error_log
        package: top_racl_pkg
        type: uni
        act: req
        width: 1
        inst_name: sram_ctrl_mbox
        index: -1
      }
      {
        name: sram_rerror
        desc: SRAM read error indicating correctable and uncorrectable ECC errors.
        struct: sram_error_t
        package: sram_ctrl_pkg
        type: uni
        act: req
        width: 1
        inst_name: sram_ctrl_mbox
        index: -1
      }
      {
        name: regs_tl
        struct: tl
        package: tlul_pkg
        type: req_rsp
        act: rsp
        width: 1
        inst_name: sram_ctrl_mbox
        default: ""
        end_idx: -1
        top_type: one-to-one
        top_signame: sram_ctrl_mbox_regs_tl
        index: -1
      }
      {
        name: ram_tl
        struct: tl
        package: tlul_pkg
        type: req_rsp
        act: rsp
        width: 1
        inst_name: sram_ctrl_mbox
        default: ""
        end_idx: -1
        top_type: one-to-one
        top_signame: sram_ctrl_mbox_ram_tl
        index: -1
      }
      {
        name: rom_cfg
        struct: rom_cfg
        package: prim_rom_pkg
        type: req_rsp
        act: rsp
        width: 1
        inst_name: rom_ctrl0
        default: ""
        external: true
        conn_type: false
        index: -1
        top_signame: rom_ctrl0_rom_cfg
      }
      {
        name: pwrmgr_data
        struct: pwrmgr_data
        package: rom_ctrl_pkg
        type: uni
        act: req
        width: 1
        inst_name: rom_ctrl0
        default: ""
        domain: Main
        top_signame: pwrmgr_rom_ctrl
        index: 0
        external: true
        conn_type: false
      }
      {
        name: keymgr_data
        struct: keymgr_data
        package: rom_ctrl_pkg
        type: uni
        act: req
        width: 1
        inst_name: rom_ctrl0
        default: ""
        domain: Main
        top_signame: keymgr_dpe_rom_digest
        index: 0
      }
      {
        name: kmac_data
        struct: app
        package: kmac_pkg
        type: req_rsp
        act: req
        width: 1
        inst_name: rom_ctrl0
        default: ""
        domain: Main
        top_signame: kmac_app
        index: 2
      }
      {
        name: regs_tl
        struct: tl
        package: tlul_pkg
        type: req_rsp
        act: rsp
        width: 1
        inst_name: rom_ctrl0
        default: ""
        end_idx: -1
        top_type: one-to-one
        top_signame: rom_ctrl0_regs_tl
        index: -1
      }
      {
        name: rom_tl
        struct: tl
        package: tlul_pkg
        type: req_rsp
        act: rsp
        width: 1
        inst_name: rom_ctrl0
        default: ""
        end_idx: -1
        top_type: one-to-one
        top_signame: rom_ctrl0_rom_tl
        index: -1
      }
      {
        name: rom_cfg
        struct: rom_cfg
        package: prim_rom_pkg
        type: req_rsp
        act: rsp
        width: 1
        inst_name: rom_ctrl1
        default: ""
        external: true
        conn_type: false
        index: -1
        top_signame: rom_ctrl1_rom_cfg
      }
      {
        name: pwrmgr_data
        struct: pwrmgr_data
        package: rom_ctrl_pkg
        type: uni
        act: req
        width: 1
        inst_name: rom_ctrl1
        default: ""
        domain: Main
        top_signame: pwrmgr_rom_ctrl
        index: 1
        external: true
        conn_type: false
      }
      {
        name: keymgr_data
        struct: keymgr_data
        package: rom_ctrl_pkg
        type: uni
        act: req
        width: 1
        inst_name: rom_ctrl1
        default: ""
        domain: Main
        top_signame: keymgr_dpe_rom_digest
        index: 1
      }
      {
        name: kmac_data
        struct: app
        package: kmac_pkg
        type: req_rsp
        act: req
        width: 1
        inst_name: rom_ctrl1
        default: ""
        domain: Main
        top_signame: kmac_app
        index: 3
      }
      {
        name: regs_tl
        struct: tl
        package: tlul_pkg
        type: req_rsp
        act: rsp
        width: 1
        inst_name: rom_ctrl1
        default: ""
        end_idx: -1
        top_type: one-to-one
        top_signame: rom_ctrl1_regs_tl
        index: -1
      }
      {
        name: rom_tl
        struct: tl
        package: tlul_pkg
        type: req_rsp
        act: rsp
        width: 1
        inst_name: rom_ctrl1
        default: ""
        end_idx: -1
        top_type: one-to-one
        top_signame: rom_ctrl1_rom_tl
        index: -1
      }
      {
        name: lsio_trigger
        struct: lsio_trigger
        package: dma_pkg
        type: uni
        act: rcv
        width: 1
        inst_name: dma
        default: ""
        end_idx: -1
        top_type: broadcast
        top_signame: dma_lsio_trigger
        index: -1
        external: true
        conn_type: false
      }
      {
        name: sys
        desc: SoC System Bus (requests and responses), synchronous
        struct: sys
        package: dma_pkg
        type: req_rsp
        act: req
        width: 1
        inst_name: dma
        default: ""
        external: true
        conn_type: false
        index: -1
        top_signame: dma_sys
      }
      {
        name: ctn_tl_h2d
        desc: TL-UL host port for egress into CTN (request part), synchronous
        struct: tl_h2d
        package: tlul_pkg
        type: uni
        act: req
        width: 1
        inst_name: dma
        default: ""
        domain: Main
        top_signame: soc_proxy_dma_tl_h2d
        index: -1
        external: true
        conn_type: false
      }
      {
        name: ctn_tl_d2h
        desc: TL-UL host port for egress into CTN (response part), synchronous
        struct: tl_d2h
        package: tlul_pkg
        type: uni
        act: rcv
        width: 1
        inst_name: dma
        default: ""
        domain: Main
        top_signame: soc_proxy_dma_tl_d2h
        index: -1
        external: true
        conn_type: false
      }
      {
        name: racl_policies
        desc:
          '''
          Incoming RACL policy vector from a racl_ctrl instance.
          The policy selection vector (parameter) selects the policy for each register.
          '''
        struct: racl_policy_vec
        package: top_racl_pkg
        type: uni
        act: rcv
        width: 1
        inst_name: dma
        index: -1
      }
      {
        name: racl_error
        desc: RACL error log information of this module.
        struct: racl_error_log
        package: top_racl_pkg
        type: uni
        act: req
        width: 1
        inst_name: dma
        index: -1
      }
      {
        name: host_tl_h
        struct: tl
        package: tlul_pkg
        type: req_rsp
        act: req
        width: 1
        inst_name: dma
        default: ""
        domain: Main
        top_signame: main_tl_dma__host
        index: -1
      }
      {
        name: tl_d
        struct: tl
        package: tlul_pkg
        type: req_rsp
        act: rsp
        width: 1
        inst_name: dma
        default: ""
        end_idx: -1
        top_type: one-to-one
        top_signame: dma_tl_d
        index: -1
      }
      {
        name: doe_intr_support
        struct: logic
        type: uni
        act: req
        width: 1
        default: 1'b0
        inst_name: mbx0
        package: ""
        external: true
        conn_type: false
        index: -1
        top_signame: mbx0_doe_intr_support
      }
      {
        name: doe_intr_en
        struct: logic
        type: uni
        act: req
        width: 1
        default: 1'b0
        inst_name: mbx0
        package: ""
        external: true
        conn_type: false
        index: -1
        top_signame: mbx0_doe_intr_en
      }
      {
        name: doe_intr
        struct: logic
        type: uni
        act: req
        width: 1
        default: 1'b0
        inst_name: mbx0
        package: ""
        external: true
        conn_type: false
        index: -1
        top_signame: mbx0_doe_intr
      }
      {
        name: doe_async_msg_support
        struct: logic
        type: uni
        act: req
        width: 1
        default: 1'b0
        inst_name: mbx0
        package: ""
        external: true
        conn_type: false
        index: -1
        top_signame: mbx0_doe_async_msg_support
      }
      {
        name: racl_policies
        desc:
          '''
          Incoming RACL policy vector from a racl_ctrl instance.
          The policy selection vector (parameter) selects the policy for each register.
          '''
        struct: racl_policy_vec
        package: top_racl_pkg
        type: uni
        act: rcv
        width: 1
        inst_name: mbx0
        default: ""
        domain: Main
        top_signame: racl_ctrl_racl_policies
        index: -1
      }
      {
        name: racl_error
        desc: RACL error log information of this module.
        struct: racl_error_log
        package: top_racl_pkg
        type: uni
        act: req
        width: 1
        inst_name: mbx0
        default: ""
        domain: Main
        top_signame: racl_ctrl_racl_error
        index: 0
      }
      {
        name: sram_tl_h
        struct: tl
        package: tlul_pkg
        type: req_rsp
        act: req
        width: 1
        inst_name: mbx0
        default: ""
        domain: Main
        top_signame: main_tl_mbx0__sram
        index: -1
      }
      {
        name: core_tl_d
        struct: tl
        package: tlul_pkg
        type: req_rsp
        act: rsp
        width: 1
        inst_name: mbx0
        default: ""
        end_idx: -1
        top_type: one-to-one
        top_signame: mbx0_core_tl_d
        index: -1
      }
      {
        name: soc_tl_d
        struct: tl
        package: tlul_pkg
        type: req_rsp
        act: rsp
        width: 1
        inst_name: mbx0
        default: ""
        end_idx: -1
        top_type: one-to-one
        top_signame: mbx0_soc_tl_d
        index: -1
      }
      {
        name: doe_intr_support
        struct: logic
        type: uni
        act: req
        width: 1
        default: 1'b0
        inst_name: mbx1
        package: ""
        external: true
        conn_type: false
        index: -1
        top_signame: mbx1_doe_intr_support
      }
      {
        name: doe_intr_en
        struct: logic
        type: uni
        act: req
        width: 1
        default: 1'b0
        inst_name: mbx1
        package: ""
        external: true
        conn_type: false
        index: -1
        top_signame: mbx1_doe_intr_en
      }
      {
        name: doe_intr
        struct: logic
        type: uni
        act: req
        width: 1
        default: 1'b0
        inst_name: mbx1
        package: ""
        external: true
        conn_type: false
        index: -1
        top_signame: mbx1_doe_intr
      }
      {
        name: doe_async_msg_support
        struct: logic
        type: uni
        act: req
        width: 1
        default: 1'b0
        inst_name: mbx1
        package: ""
        external: true
        conn_type: false
        index: -1
        top_signame: mbx1_doe_async_msg_support
      }
      {
        name: racl_policies
        desc:
          '''
          Incoming RACL policy vector from a racl_ctrl instance.
          The policy selection vector (parameter) selects the policy for each register.
          '''
        struct: racl_policy_vec
        package: top_racl_pkg
        type: uni
        act: rcv
        width: 1
        inst_name: mbx1
        default: ""
        domain: Main
        top_signame: racl_ctrl_racl_policies
        index: -1
      }
      {
        name: racl_error
        desc: RACL error log information of this module.
        struct: racl_error_log
        package: top_racl_pkg
        type: uni
        act: req
        width: 1
        inst_name: mbx1
        default: ""
        domain: Main
        top_signame: racl_ctrl_racl_error
        index: 1
      }
      {
        name: sram_tl_h
        struct: tl
        package: tlul_pkg
        type: req_rsp
        act: req
        width: 1
        inst_name: mbx1
        default: ""
        domain: Main
        top_signame: main_tl_mbx1__sram
        index: -1
      }
      {
        name: core_tl_d
        struct: tl
        package: tlul_pkg
        type: req_rsp
        act: rsp
        width: 1
        inst_name: mbx1
        default: ""
        end_idx: -1
        top_type: one-to-one
        top_signame: mbx1_core_tl_d
        index: -1
      }
      {
        name: soc_tl_d
        struct: tl
        package: tlul_pkg
        type: req_rsp
        act: rsp
        width: 1
        inst_name: mbx1
        default: ""
        end_idx: -1
        top_type: one-to-one
        top_signame: mbx1_soc_tl_d
        index: -1
      }
      {
        name: doe_intr_support
        struct: logic
        type: uni
        act: req
        width: 1
        default: 1'b0
        inst_name: mbx2
        package: ""
        external: true
        conn_type: false
        index: -1
        top_signame: mbx2_doe_intr_support
      }
      {
        name: doe_intr_en
        struct: logic
        type: uni
        act: req
        width: 1
        default: 1'b0
        inst_name: mbx2
        package: ""
        external: true
        conn_type: false
        index: -1
        top_signame: mbx2_doe_intr_en
      }
      {
        name: doe_intr
        struct: logic
        type: uni
        act: req
        width: 1
        default: 1'b0
        inst_name: mbx2
        package: ""
        external: true
        conn_type: false
        index: -1
        top_signame: mbx2_doe_intr
      }
      {
        name: doe_async_msg_support
        struct: logic
        type: uni
        act: req
        width: 1
        default: 1'b0
        inst_name: mbx2
        package: ""
        external: true
        conn_type: false
        index: -1
        top_signame: mbx2_doe_async_msg_support
      }
      {
        name: racl_policies
        desc:
          '''
          Incoming RACL policy vector from a racl_ctrl instance.
          The policy selection vector (parameter) selects the policy for each register.
          '''
        struct: racl_policy_vec
        package: top_racl_pkg
        type: uni
        act: rcv
        width: 1
        inst_name: mbx2
        default: ""
        domain: Main
        top_signame: racl_ctrl_racl_policies
        index: -1
      }
      {
        name: racl_error
        desc: RACL error log information of this module.
        struct: racl_error_log
        package: top_racl_pkg
        type: uni
        act: req
        width: 1
        inst_name: mbx2
        default: ""
        domain: Main
        top_signame: racl_ctrl_racl_error
        index: 2
      }
      {
        name: sram_tl_h
        struct: tl
        package: tlul_pkg
        type: req_rsp
        act: req
        width: 1
        inst_name: mbx2
        default: ""
        domain: Main
        top_signame: main_tl_mbx2__sram
        index: -1
      }
      {
        name: core_tl_d
        struct: tl
        package: tlul_pkg
        type: req_rsp
        act: rsp
        width: 1
        inst_name: mbx2
        default: ""
        end_idx: -1
        top_type: one-to-one
        top_signame: mbx2_core_tl_d
        index: -1
      }
      {
        name: soc_tl_d
        struct: tl
        package: tlul_pkg
        type: req_rsp
        act: rsp
        width: 1
        inst_name: mbx2
        default: ""
        end_idx: -1
        top_type: one-to-one
        top_signame: mbx2_soc_tl_d
        index: -1
      }
      {
        name: doe_intr_support
        struct: logic
        type: uni
        act: req
        width: 1
        default: 1'b0
        inst_name: mbx3
        package: ""
        external: true
        conn_type: false
        index: -1
        top_signame: mbx3_doe_intr_support
      }
      {
        name: doe_intr_en
        struct: logic
        type: uni
        act: req
        width: 1
        default: 1'b0
        inst_name: mbx3
        package: ""
        external: true
        conn_type: false
        index: -1
        top_signame: mbx3_doe_intr_en
      }
      {
        name: doe_intr
        struct: logic
        type: uni
        act: req
        width: 1
        default: 1'b0
        inst_name: mbx3
        package: ""
        external: true
        conn_type: false
        index: -1
        top_signame: mbx3_doe_intr
      }
      {
        name: doe_async_msg_support
        struct: logic
        type: uni
        act: req
        width: 1
        default: 1'b0
        inst_name: mbx3
        package: ""
        external: true
        conn_type: false
        index: -1
        top_signame: mbx3_doe_async_msg_support
      }
      {
        name: racl_policies
        desc:
          '''
          Incoming RACL policy vector from a racl_ctrl instance.
          The policy selection vector (parameter) selects the policy for each register.
          '''
        struct: racl_policy_vec
        package: top_racl_pkg
        type: uni
        act: rcv
        width: 1
        inst_name: mbx3
        default: ""
        domain: Main
        top_signame: racl_ctrl_racl_policies
        index: -1
      }
      {
        name: racl_error
        desc: RACL error log information of this module.
        struct: racl_error_log
        package: top_racl_pkg
        type: uni
        act: req
        width: 1
        inst_name: mbx3
        default: ""
        domain: Main
        top_signame: racl_ctrl_racl_error
        index: 3
      }
      {
        name: sram_tl_h
        struct: tl
        package: tlul_pkg
        type: req_rsp
        act: req
        width: 1
        inst_name: mbx3
        default: ""
        domain: Main
        top_signame: main_tl_mbx3__sram
        index: -1
      }
      {
        name: core_tl_d
        struct: tl
        package: tlul_pkg
        type: req_rsp
        act: rsp
        width: 1
        inst_name: mbx3
        default: ""
        end_idx: -1
        top_type: one-to-one
        top_signame: mbx3_core_tl_d
        index: -1
      }
      {
        name: soc_tl_d
        struct: tl
        package: tlul_pkg
        type: req_rsp
        act: rsp
        width: 1
        inst_name: mbx3
        default: ""
        end_idx: -1
        top_type: one-to-one
        top_signame: mbx3_soc_tl_d
        index: -1
      }
      {
        name: doe_intr_support
        struct: logic
        type: uni
        act: req
        width: 1
        default: 1'b0
        inst_name: mbx4
        package: ""
        external: true
        conn_type: false
        index: -1
        top_signame: mbx4_doe_intr_support
      }
      {
        name: doe_intr_en
        struct: logic
        type: uni
        act: req
        width: 1
        default: 1'b0
        inst_name: mbx4
        package: ""
        external: true
        conn_type: false
        index: -1
        top_signame: mbx4_doe_intr_en
      }
      {
        name: doe_intr
        struct: logic
        type: uni
        act: req
        width: 1
        default: 1'b0
        inst_name: mbx4
        package: ""
        external: true
        conn_type: false
        index: -1
        top_signame: mbx4_doe_intr
      }
      {
        name: doe_async_msg_support
        struct: logic
        type: uni
        act: req
        width: 1
        default: 1'b0
        inst_name: mbx4
        package: ""
        external: true
        conn_type: false
        index: -1
        top_signame: mbx4_doe_async_msg_support
      }
      {
        name: racl_policies
        desc:
          '''
          Incoming RACL policy vector from a racl_ctrl instance.
          The policy selection vector (parameter) selects the policy for each register.
          '''
        struct: racl_policy_vec
        package: top_racl_pkg
        type: uni
        act: rcv
        width: 1
        inst_name: mbx4
        default: ""
        domain: Main
        top_signame: racl_ctrl_racl_policies
        index: -1
      }
      {
        name: racl_error
        desc: RACL error log information of this module.
        struct: racl_error_log
        package: top_racl_pkg
        type: uni
        act: req
        width: 1
        inst_name: mbx4
        default: ""
        domain: Main
        top_signame: racl_ctrl_racl_error
        index: 4
      }
      {
        name: sram_tl_h
        struct: tl
        package: tlul_pkg
        type: req_rsp
        act: req
        width: 1
        inst_name: mbx4
        default: ""
        domain: Main
        top_signame: main_tl_mbx4__sram
        index: -1
      }
      {
        name: core_tl_d
        struct: tl
        package: tlul_pkg
        type: req_rsp
        act: rsp
        width: 1
        inst_name: mbx4
        default: ""
        end_idx: -1
        top_type: one-to-one
        top_signame: mbx4_core_tl_d
        index: -1
      }
      {
        name: soc_tl_d
        struct: tl
        package: tlul_pkg
        type: req_rsp
        act: rsp
        width: 1
        inst_name: mbx4
        default: ""
        end_idx: -1
        top_type: one-to-one
        top_signame: mbx4_soc_tl_d
        index: -1
      }
      {
        name: doe_intr_support
        struct: logic
        type: uni
        act: req
        width: 1
        default: 1'b0
        inst_name: mbx5
        package: ""
        external: true
        conn_type: false
        index: -1
        top_signame: mbx5_doe_intr_support
      }
      {
        name: doe_intr_en
        struct: logic
        type: uni
        act: req
        width: 1
        default: 1'b0
        inst_name: mbx5
        package: ""
        external: true
        conn_type: false
        index: -1
        top_signame: mbx5_doe_intr_en
      }
      {
        name: doe_intr
        struct: logic
        type: uni
        act: req
        width: 1
        default: 1'b0
        inst_name: mbx5
        package: ""
        external: true
        conn_type: false
        index: -1
        top_signame: mbx5_doe_intr
      }
      {
        name: doe_async_msg_support
        struct: logic
        type: uni
        act: req
        width: 1
        default: 1'b0
        inst_name: mbx5
        package: ""
        external: true
        conn_type: false
        index: -1
        top_signame: mbx5_doe_async_msg_support
      }
      {
        name: racl_policies
        desc:
          '''
          Incoming RACL policy vector from a racl_ctrl instance.
          The policy selection vector (parameter) selects the policy for each register.
          '''
        struct: racl_policy_vec
        package: top_racl_pkg
        type: uni
        act: rcv
        width: 1
        inst_name: mbx5
        default: ""
        domain: Main
        top_signame: racl_ctrl_racl_policies
        index: -1
      }
      {
        name: racl_error
        desc: RACL error log information of this module.
        struct: racl_error_log
        package: top_racl_pkg
        type: uni
        act: req
        width: 1
        inst_name: mbx5
        default: ""
        domain: Main
        top_signame: racl_ctrl_racl_error
        index: 5
      }
      {
        name: sram_tl_h
        struct: tl
        package: tlul_pkg
        type: req_rsp
        act: req
        width: 1
        inst_name: mbx5
        default: ""
        domain: Main
        top_signame: main_tl_mbx5__sram
        index: -1
      }
      {
        name: core_tl_d
        struct: tl
        package: tlul_pkg
        type: req_rsp
        act: rsp
        width: 1
        inst_name: mbx5
        default: ""
        end_idx: -1
        top_type: one-to-one
        top_signame: mbx5_core_tl_d
        index: -1
      }
      {
        name: soc_tl_d
        struct: tl
        package: tlul_pkg
        type: req_rsp
        act: rsp
        width: 1
        inst_name: mbx5
        default: ""
        end_idx: -1
        top_type: one-to-one
        top_signame: mbx5_soc_tl_d
        index: -1
      }
      {
        name: doe_intr_support
        struct: logic
        type: uni
        act: req
        width: 1
        default: 1'b0
        inst_name: mbx6
        package: ""
        external: true
        conn_type: false
        index: -1
        top_signame: mbx6_doe_intr_support
      }
      {
        name: doe_intr_en
        struct: logic
        type: uni
        act: req
        width: 1
        default: 1'b0
        inst_name: mbx6
        package: ""
        external: true
        conn_type: false
        index: -1
        top_signame: mbx6_doe_intr_en
      }
      {
        name: doe_intr
        struct: logic
        type: uni
        act: req
        width: 1
        default: 1'b0
        inst_name: mbx6
        package: ""
        external: true
        conn_type: false
        index: -1
        top_signame: mbx6_doe_intr
      }
      {
        name: doe_async_msg_support
        struct: logic
        type: uni
        act: req
        width: 1
        default: 1'b0
        inst_name: mbx6
        package: ""
        external: true
        conn_type: false
        index: -1
        top_signame: mbx6_doe_async_msg_support
      }
      {
        name: racl_policies
        desc:
          '''
          Incoming RACL policy vector from a racl_ctrl instance.
          The policy selection vector (parameter) selects the policy for each register.
          '''
        struct: racl_policy_vec
        package: top_racl_pkg
        type: uni
        act: rcv
        width: 1
        inst_name: mbx6
        default: ""
        domain: Main
        top_signame: racl_ctrl_racl_policies
        index: -1
      }
      {
        name: racl_error
        desc: RACL error log information of this module.
        struct: racl_error_log
        package: top_racl_pkg
        type: uni
        act: req
        width: 1
        inst_name: mbx6
        default: ""
        domain: Main
        top_signame: racl_ctrl_racl_error
        index: 6
      }
      {
        name: sram_tl_h
        struct: tl
        package: tlul_pkg
        type: req_rsp
        act: req
        width: 1
        inst_name: mbx6
        default: ""
        domain: Main
        top_signame: main_tl_mbx6__sram
        index: -1
      }
      {
        name: core_tl_d
        struct: tl
        package: tlul_pkg
        type: req_rsp
        act: rsp
        width: 1
        inst_name: mbx6
        default: ""
        end_idx: -1
        top_type: one-to-one
        top_signame: mbx6_core_tl_d
        index: -1
      }
      {
        name: soc_tl_d
        struct: tl
        package: tlul_pkg
        type: req_rsp
        act: rsp
        width: 1
        inst_name: mbx6
        default: ""
        end_idx: -1
        top_type: one-to-one
        top_signame: mbx6_soc_tl_d
        index: -1
      }
      {
        name: doe_intr_support
        struct: logic
        type: uni
        act: req
        width: 1
        default: 1'b0
        inst_name: mbx_jtag
        package: ""
        external: true
        conn_type: false
        index: -1
        top_signame: mbx_jtag_doe_intr_support
      }
      {
        name: doe_intr_en
        struct: logic
        type: uni
        act: req
        width: 1
        default: 1'b0
        inst_name: mbx_jtag
        package: ""
        external: true
        conn_type: false
        index: -1
        top_signame: mbx_jtag_doe_intr_en
      }
      {
        name: doe_intr
        struct: logic
        type: uni
        act: req
        width: 1
        default: 1'b0
        inst_name: mbx_jtag
        package: ""
        external: true
        conn_type: false
        index: -1
        top_signame: mbx_jtag_doe_intr
      }
      {
        name: doe_async_msg_support
        struct: logic
        type: uni
        act: req
        width: 1
        default: 1'b0
        inst_name: mbx_jtag
        package: ""
        external: true
        conn_type: false
        index: -1
        top_signame: mbx_jtag_doe_async_msg_support
      }
      {
        name: racl_policies
        desc:
          '''
          Incoming RACL policy vector from a racl_ctrl instance.
          The policy selection vector (parameter) selects the policy for each register.
          '''
        struct: racl_policy_vec
        package: top_racl_pkg
        type: uni
        act: rcv
        width: 1
        inst_name: mbx_jtag
        default: ""
        domain: Main
        top_signame: racl_ctrl_racl_policies
        index: -1
      }
      {
        name: racl_error
        desc: RACL error log information of this module.
        struct: racl_error_log
        package: top_racl_pkg
        type: uni
        act: req
        width: 1
        inst_name: mbx_jtag
        default: ""
        domain: Main
        top_signame: racl_ctrl_racl_error
        index: 7
      }
      {
        name: sram_tl_h
        struct: tl
        package: tlul_pkg
        type: req_rsp
        act: req
        width: 1
        inst_name: mbx_jtag
        default: ""
        domain: Main
        top_signame: main_tl_mbx_jtag__sram
        index: -1
      }
      {
        name: core_tl_d
        struct: tl
        package: tlul_pkg
        type: req_rsp
        act: rsp
        width: 1
        inst_name: mbx_jtag
        default: ""
        end_idx: -1
        top_type: one-to-one
        top_signame: mbx_jtag_core_tl_d
        index: -1
      }
      {
        name: soc_tl_d
        struct: tl
        package: tlul_pkg
        type: req_rsp
        act: rsp
        width: 1
        inst_name: mbx_jtag
        default: ""
        end_idx: -1
        top_type: one-to-one
        top_signame: mbx_jtag_soc_tl_d
        index: -1
      }
      {
        name: doe_intr_support
        struct: logic
        type: uni
        act: req
        width: 1
        default: 1'b0
        inst_name: mbx_pcie0
        package: ""
        external: true
        conn_type: false
        index: -1
        top_signame: mbx_pcie0_doe_intr_support
      }
      {
        name: doe_intr_en
        struct: logic
        type: uni
        act: req
        width: 1
        default: 1'b0
        inst_name: mbx_pcie0
        package: ""
        external: true
        conn_type: false
        index: -1
        top_signame: mbx_pcie0_doe_intr_en
      }
      {
        name: doe_intr
        struct: logic
        type: uni
        act: req
        width: 1
        default: 1'b0
        inst_name: mbx_pcie0
        package: ""
        external: true
        conn_type: false
        index: -1
        top_signame: mbx_pcie0_doe_intr
      }
      {
        name: doe_async_msg_support
        struct: logic
        type: uni
        act: req
        width: 1
        default: 1'b0
        inst_name: mbx_pcie0
        package: ""
        external: true
        conn_type: false
        index: -1
        top_signame: mbx_pcie0_doe_async_msg_support
      }
      {
        name: racl_policies
        desc:
          '''
          Incoming RACL policy vector from a racl_ctrl instance.
          The policy selection vector (parameter) selects the policy for each register.
          '''
        struct: racl_policy_vec
        package: top_racl_pkg
        type: uni
        act: rcv
        width: 1
        inst_name: mbx_pcie0
        default: ""
        domain: Main
        top_signame: racl_ctrl_racl_policies
        index: -1
      }
      {
        name: racl_error
        desc: RACL error log information of this module.
        struct: racl_error_log
        package: top_racl_pkg
        type: uni
        act: req
        width: 1
        inst_name: mbx_pcie0
        default: ""
        domain: Main
        top_signame: racl_ctrl_racl_error
        index: 8
      }
      {
        name: sram_tl_h
        struct: tl
        package: tlul_pkg
        type: req_rsp
        act: req
        width: 1
        inst_name: mbx_pcie0
        default: ""
        domain: Main
        top_signame: main_tl_mbx_pcie0__sram
        index: -1
      }
      {
        name: core_tl_d
        struct: tl
        package: tlul_pkg
        type: req_rsp
        act: rsp
        width: 1
        inst_name: mbx_pcie0
        default: ""
        end_idx: -1
        top_type: one-to-one
        top_signame: mbx_pcie0_core_tl_d
        index: -1
      }
      {
        name: soc_tl_d
        struct: tl
        package: tlul_pkg
        type: req_rsp
        act: rsp
        width: 1
        inst_name: mbx_pcie0
        default: ""
        end_idx: -1
        top_type: one-to-one
        top_signame: mbx_pcie0_soc_tl_d
        index: -1
      }
      {
        name: doe_intr_support
        struct: logic
        type: uni
        act: req
        width: 1
        default: 1'b0
        inst_name: mbx_pcie1
        package: ""
        external: true
        conn_type: false
        index: -1
        top_signame: mbx_pcie1_doe_intr_support
      }
      {
        name: doe_intr_en
        struct: logic
        type: uni
        act: req
        width: 1
        default: 1'b0
        inst_name: mbx_pcie1
        package: ""
        external: true
        conn_type: false
        index: -1
        top_signame: mbx_pcie1_doe_intr_en
      }
      {
        name: doe_intr
        struct: logic
        type: uni
        act: req
        width: 1
        default: 1'b0
        inst_name: mbx_pcie1
        package: ""
        external: true
        conn_type: false
        index: -1
        top_signame: mbx_pcie1_doe_intr
      }
      {
        name: doe_async_msg_support
        struct: logic
        type: uni
        act: req
        width: 1
        default: 1'b0
        inst_name: mbx_pcie1
        package: ""
        external: true
        conn_type: false
        index: -1
        top_signame: mbx_pcie1_doe_async_msg_support
      }
      {
        name: racl_policies
        desc:
          '''
          Incoming RACL policy vector from a racl_ctrl instance.
          The policy selection vector (parameter) selects the policy for each register.
          '''
        struct: racl_policy_vec
        package: top_racl_pkg
        type: uni
        act: rcv
        width: 1
        inst_name: mbx_pcie1
        default: ""
        domain: Main
        top_signame: racl_ctrl_racl_policies
        index: -1
      }
      {
        name: racl_error
        desc: RACL error log information of this module.
        struct: racl_error_log
        package: top_racl_pkg
        type: uni
        act: req
        width: 1
        inst_name: mbx_pcie1
        default: ""
        domain: Main
        top_signame: racl_ctrl_racl_error
        index: 9
      }
      {
        name: sram_tl_h
        struct: tl
        package: tlul_pkg
        type: req_rsp
        act: req
        width: 1
        inst_name: mbx_pcie1
        default: ""
        domain: Main
        top_signame: main_tl_mbx_pcie1__sram
        index: -1
      }
      {
        name: core_tl_d
        struct: tl
        package: tlul_pkg
        type: req_rsp
        act: rsp
        width: 1
        inst_name: mbx_pcie1
        default: ""
        end_idx: -1
        top_type: one-to-one
        top_signame: mbx_pcie1_core_tl_d
        index: -1
      }
      {
        name: soc_tl_d
        struct: tl
        package: tlul_pkg
        type: req_rsp
        act: rsp
        width: 1
        inst_name: mbx_pcie1
        default: ""
        end_idx: -1
        top_type: one-to-one
        top_signame: mbx_pcie1_soc_tl_d
        index: -1
      }
      {
        name: boot_status
        struct: pwr_boot_status
        package: pwrmgr_pkg
        type: uni
        act: rcv
        width: 1
        inst_name: soc_dbg_ctrl
        default: ""
        domain: Main
        top_signame: pwrmgr_boot_status
        index: -1
        external: true
        conn_type: false
      }
      {
        name: soc_dbg_state
        struct: soc_dbg_state
        package: lc_ctrl_state_pkg
        type: uni
        act: rcv
        width: 1
        inst_name: soc_dbg_ctrl
        default: ""
        top_signame: soc_dbg_ctrl_soc_dbg_state
        index: -1
      }
      {
        name: soc_dbg_policy_bus
        struct: soc_dbg_policy
        package: soc_dbg_ctrl_pkg
        type: uni
        act: req
        width: 1
        inst_name: soc_dbg_ctrl
        default: ""
        external: true
        conn_type: false
        index: -1
        top_signame: soc_dbg_policy_bus
      }
      {
        name: lc_hw_debug_en
        desc: Multibit life cycle hardware debug enable signal coming from life cycle controller, asserted when the hardware debug mechanisms are enabled in the system.
        struct: lc_tx
        package: lc_ctrl_pkg
        type: uni
        act: rcv
        width: 1
        default: lc_ctrl_pkg::Off
        inst_name: soc_dbg_ctrl
        domain: Main
        top_signame: lc_ctrl_lc_hw_debug_en
        index: -1
      }
      {
        name: lc_dft_en
        desc:
          '''
          Test enable qualifier coming from life cycle controller.
          This signals enables TEST & RMA mode accesses.
          '''
        struct: lc_tx
        package: lc_ctrl_pkg
        type: uni
        act: rcv
        width: 1
        default: lc_ctrl_pkg::Off
        inst_name: soc_dbg_ctrl
        domain: Main
        top_signame: lc_ctrl_lc_dft_en
        index: -1
      }
      {
        name: lc_raw_test_rma
        desc:
          '''
          Test enable qualifier coming from life cycle controller.
          This signals enables RAW, TEST and RMA mode accesses.
          '''
        struct: lc_tx
        package: lc_ctrl_pkg
        type: uni
        act: rcv
        width: 1
        default: lc_ctrl_pkg::Off
        inst_name: soc_dbg_ctrl
        domain: Main
        top_signame: lc_ctrl_lc_raw_test_rma
        index: -1
      }
      {
        name: lc_cpu_en
        desc:
          '''
          CPU enable qualifier coming from life cycle controller.
          Indication from life cycle controller that the CPU is running.
          '''
        struct: lc_tx
        package: lc_ctrl_pkg
        type: uni
        act: rcv
        width: 1
        default: lc_ctrl_pkg::Off
        inst_name: soc_dbg_ctrl
        domain: Main
        top_signame: lc_ctrl_lc_cpu_en
        index: -1
      }
      {
        name: lc_rma_state
        desc:
          '''
          RMA state qualifier coming from life cycle controller.
          Indication from life cycle controller that the RMA state is active.
          '''
        struct: lc_tx
        package: lc_ctrl_pkg
        type: uni
        act: rcv
        width: 1
        default: lc_ctrl_pkg::Off
        inst_name: soc_dbg_ctrl
        domain: Main
        top_signame: lc_ctrl_lc_rma_state
        index: -1
      }
      {
        name: halt_cpu_boot
        desc: External request to halt the CPU until a JTAG command allows the boot process to continue.
        struct: logic
        type: uni
        act: rcv
        width: 1
        inst_name: soc_dbg_ctrl
        default: ""
        package: ""
        external: true
        conn_type: false
        index: -1
        top_signame: debug_halt_cpu_boot
      }
      {
        name: continue_cpu_boot
        desc: Artificial ROM control input to the pwrmgr to halt the boot process.
        struct: pwrmgr_data
        package: rom_ctrl_pkg
        type: uni
        act: req
        width: 1
        inst_name: soc_dbg_ctrl
        default: ""
        domain: Main
        top_signame: pwrmgr_rom_ctrl
        index: 2
        external: true
        conn_type: false
      }
      {
        name: core_tl
        struct: tl
        package: tlul_pkg
        type: req_rsp
        act: rsp
        width: 1
        inst_name: soc_dbg_ctrl
        default: ""
        end_idx: -1
        top_type: one-to-one
        top_signame: soc_dbg_ctrl_core_tl
        index: -1
      }
      {
        name: jtag_tl
        struct: tl
        package: tlul_pkg
        type: req_rsp
        act: rsp
        width: 1
        inst_name: soc_dbg_ctrl
        default: ""
        end_idx: -1
        top_type: one-to-one
        top_signame: soc_dbg_ctrl_jtag_tl
        index: -1
      }
      {
        name: racl_policies
        desc: Policy vector distributed to the subscribing RACL IPs.
        struct: racl_policy_vec
        package: top_racl_pkg
        type: uni
        act: req
        width: 1
        inst_name: racl_ctrl
        default: ""
        end_idx: -1
        top_type: broadcast
        top_signame: racl_ctrl_racl_policies
        index: -1
        external: true
        conn_type: true
      }
      {
        name: racl_error
        desc:
          '''
          Error log information from all IPs.
          Only one IP can raise an error at a time.
          '''
        struct: racl_error_log
        package: top_racl_pkg
        type: uni
        act: rcv
        width:
        {
          name: NumSubscribingIps
          desc: Number of subscribing RACL IPs
          param_type: int
          unpacked_dimensions: null
          default: 11
          local: true
          expose: true
          name_top: RaclCtrlNumSubscribingIps
        }
        inst_name: racl_ctrl
        default: ""
        end_idx: -1
        top_type: one-to-N
        top_signame: racl_ctrl_racl_error
        index: -1
      }
      {
        name: racl_error_external
        desc:
          '''
          Error log information from all external IPs.
          Only one IP can raise an error at a time.
          '''
        struct: racl_error_log
        package: top_racl_pkg
        type: uni
        act: rcv
        width:
        {
          name: NumExternalSubscribingIps
          desc: Number of external subscribing RACL IPs
          param_type: int
          unpacked_dimensions: null
          default: 1
          local: false
          expose: true
          name_top: RaclCtrlNumExternalSubscribingIps
        }
        inst_name: racl_ctrl
        default: ""
        external: true
        conn_type: false
        index: -1
        top_signame: racl_error
      }
      {
        name: tl
        struct: tl
        package: tlul_pkg
        type: req_rsp
        act: rsp
        width: 1
        inst_name: racl_ctrl
        default: ""
        end_idx: -1
        top_type: one-to-one
        top_signame: racl_ctrl_tl
        index: -1
      }
      {
        name: range_check_overwrite
        desc: Overwrites all ranges and let all requests pass through.
        struct: mubi8
        package: prim_mubi_pkg
        type: uni
        act: rcv
        width: 1
        inst_name: ac_range_check
        default: ""
        external: true
        conn_type: false
        index: -1
        top_signame: ac_range_check_overwrite
      }
      {
        name: ctn_tl_h2d
        desc: TL-UL input port (request part), synchronous
        struct: tl_h2d
        package: tlul_pkg
        type: uni
        act: rcv
        width: 1
        inst_name: ac_range_check
        default: ""
        domain: Main
        top_signame: soc_proxy_ctn_tl_h2d
        index: -1
        external: true
        conn_type: false
      }
      {
        name: ctn_tl_d2h
        desc: TL-UL input port (response part), synchronous
        struct: tl_d2h
        package: tlul_pkg
        type: uni
        act: req
        width: 1
        inst_name: ac_range_check
        default: ""
        domain: Main
        top_signame: soc_proxy_ctn_tl_d2h
        index: -1
        external: true
        conn_type: false
      }
      {
        name: ctn_filtered_tl_h2d
        desc: Filtered TL-UL output port (request part), synchronous
        struct: tl_h2d
        package: tlul_pkg
        type: uni
        act: req
        width: 1
        inst_name: ac_range_check
        default: ""
        external: true
        conn_type: false
        index: -1
        top_signame: ctn_tl_h2d
      }
      {
        name: ctn_filtered_tl_d2h
        desc: Filtered TL-UL output port (response part), synchronous
        struct: tl_d2h
        package: tlul_pkg
        type: uni
        act: rcv
        width: 1
        inst_name: ac_range_check
        default: ""
        external: true
        conn_type: false
        index: -1
        top_signame: ctn_tl_d2h
      }
      {
        name: racl_policies
        desc:
          '''
          Incoming RACL policy vector from a racl_ctrl instance.
          The policy selection vector (parameter) selects the policy for each register.
          '''
        struct: racl_policy_vec
        package: top_racl_pkg
        type: uni
        act: rcv
        width: 1
        inst_name: ac_range_check
        default: ""
        domain: Main
        top_signame: racl_ctrl_racl_policies
        index: -1
      }
      {
        name: racl_error
        desc: RACL error log information of this module.
        struct: racl_error_log
        package: top_racl_pkg
        type: uni
        act: req
        width: 1
        inst_name: ac_range_check
        default: ""
        domain: Main
        top_signame: racl_ctrl_racl_error
        index: 10
      }
      {
        name: tl
        struct: tl
        package: tlul_pkg
        type: req_rsp
        act: rsp
        width: 1
        inst_name: ac_range_check
        default: ""
        end_idx: -1
        top_type: one-to-one
        top_signame: ac_range_check_tl
        index: -1
      }
      {
        name: rst_cpu_n
        struct: logic
        type: uni
        act: req
        width: 1
        inst_name: rv_core_ibex
        index: -1
      }
      {
        name: ram_cfg_icache_tag
        struct: ram_1p_cfg
        package: prim_ram_1p_pkg
        type: req_rsp
        act: rsp
        width:
        {
          name: ICacheNWays
          desc: Number of instruction cache ways
          param_type: int unsigned
          unpacked_dimensions: null
          default: 2
          local: false
          expose: true
          name_top: RvCoreIbexICacheNWays
        }
        inst_name: rv_core_ibex
        default: ""
        external: true
        conn_type: false
        index: -1
        top_signame: rv_core_ibex_icache_tag_ram_cfg
      }
      {
        name: ram_cfg_icache_data
        struct: ram_1p_cfg
        package: prim_ram_1p_pkg
        type: req_rsp
        act: rsp
        width:
        {
          name: ICacheNWays
          desc: Number of instruction cache ways
          param_type: int unsigned
          unpacked_dimensions: null
          default: 2
          local: false
          expose: true
          name_top: RvCoreIbexICacheNWays
        }
        inst_name: rv_core_ibex
        default: ""
        external: true
        conn_type: false
        index: -1
        top_signame: rv_core_ibex_icache_data_ram_cfg
      }
      {
        name: hart_id
        struct: logic
        type: uni
        act: rcv
        width: 32
        inst_name: rv_core_ibex
        default: ""
        package: ""
        top_signame: rv_core_ibex_hart_id
        index: -1
      }
      {
        name: boot_addr
        struct: logic
        type: uni
        act: rcv
        width: 32
        inst_name: rv_core_ibex
        default: ""
        package: ""
        top_signame: rv_core_ibex_boot_addr
        index: -1
      }
      {
        name: irq_software
        struct: logic
        type: uni
        act: rcv
        width: 1
        inst_name: rv_core_ibex
        default: ""
        package: ""
        domain: Main
        top_signame: rv_plic_msip
        index: -1
      }
      {
        name: irq_timer
        struct: logic
        type: uni
        act: rcv
        width: 1
        inst_name: rv_core_ibex
        default: ""
        package: ""
        top_signame: rv_core_ibex_irq_timer
        index: -1
      }
      {
        name: irq_external
        struct: logic
        type: uni
        act: rcv
        width: 1
        inst_name: rv_core_ibex
        default: ""
        package: ""
        domain: Main
        top_signame: rv_plic_irq
        index: -1
      }
      {
        name: esc_tx
        struct: esc_tx
        package: prim_esc_pkg
        type: uni
        act: rcv
        width: 1
        inst_name: rv_core_ibex
        default: ""
        domain: Main
        top_signame: alert_handler_esc_tx
        index: 0
      }
      {
        name: esc_rx
        struct: esc_rx
        package: prim_esc_pkg
        type: uni
        act: req
        width: 1
        inst_name: rv_core_ibex
        default: ""
        domain: Main
        top_signame: alert_handler_esc_rx
        index: 0
      }
      {
        name: debug_req
        struct: logic
        type: uni
        act: rcv
        width: 1
        inst_name: rv_core_ibex
        default: ""
        package: ""
        domain: Main
        top_signame: rv_dm_debug_req
        index: -1
      }
      {
        name: crash_dump
        struct: cpu_crash_dump
        package: rv_core_ibex_pkg
        type: uni
        act: req
        width: 1
        inst_name: rv_core_ibex
        default: ""
        end_idx: -1
        top_type: broadcast
        top_signame: rv_core_ibex_crash_dump
        index: -1
        external: true
        conn_type: false
      }
      {
        name: lc_cpu_en
        struct: lc_tx
        package: lc_ctrl_pkg
        type: uni
        act: rcv
        width: 1
        default: lc_ctrl_pkg::On
        inst_name: rv_core_ibex
        domain: Main
        top_signame: lc_ctrl_lc_cpu_en
        index: -1
      }
      {
        name: pwrmgr_cpu_en
        struct: lc_tx
        package: lc_ctrl_pkg
        type: uni
        act: rcv
        width: 1
        inst_name: rv_core_ibex
        default: ""
        domain: Main
        top_signame: pwrmgr_fetch_en
        index: -1
        external: true
        conn_type: false
      }
      {
        name: pwrmgr
        struct: cpu_pwrmgr
        package: rv_core_ibex_pkg
        type: uni
        act: req
        width: 1
        inst_name: rv_core_ibex
        default: ""
        end_idx: -1
        top_type: broadcast
        top_signame: rv_core_ibex_pwrmgr
        index: -1
        external: true
        conn_type: false
      }
      {
        name: nmi_wdog
        struct: logic
        type: uni
        act: rcv
        width: 1
        inst_name: rv_core_ibex
        default: ""
        package: ""
        domain: Main
        top_signame: aon_timer_nmi_wdog_timer_bark
        index: -1
        external: true
        conn_type: false
      }
      {
        name: edn
        struct: edn
        package: edn_pkg
        type: req_rsp
        act: req
        width: 1
        inst_name: rv_core_ibex
        default: ""
        domain: Main
        top_signame: edn0_edn
        index: 6
      }
      {
        name: icache_otp_key
        struct: sram_otp_key
        package: otp_ctrl_pkg
        type: req_rsp
        act: req
        width: 1
        inst_name: rv_core_ibex
        default: ""
        domain: Main
        top_signame: otp_ctrl_sram_otp_key
        index: 3
      }
      {
        name: corei_tl_h
        struct: tl
        package: tlul_pkg
        type: req_rsp
        act: req
        width: 1
        inst_name: rv_core_ibex
        default: ""
        domain: Main
        top_signame: main_tl_rv_core_ibex__corei
        index: -1
      }
      {
        name: cored_tl_h
        struct: tl
        package: tlul_pkg
        type: req_rsp
        act: req
        width: 1
        inst_name: rv_core_ibex
        default: ""
        domain: Main
        top_signame: main_tl_rv_core_ibex__cored
        index: -1
      }
      {
        name: cfg_tl_d
        struct: tl
        package: tlul_pkg
        type: req_rsp
        act: rsp
        width: 1
        inst_name: rv_core_ibex
        default: ""
        end_idx: -1
        top_type: one-to-one
        top_signame: rv_core_ibex_cfg_tl_d
        index: -1
      }
      {
        name: tl_rv_core_ibex__corei
        struct: tl
        package: tlul_pkg
        type: req_rsp
        act: rsp
        inst_name: main
        width: 1
        default: ""
        end_idx: -1
        top_type: one-to-one
        top_signame: main_tl_rv_core_ibex__corei
        index: -1
      }
      {
        name: tl_rv_core_ibex__cored
        struct: tl
        package: tlul_pkg
        type: req_rsp
        act: rsp
        inst_name: main
        width: 1
        default: ""
        end_idx: -1
        top_type: one-to-one
        top_signame: main_tl_rv_core_ibex__cored
        index: -1
      }
      {
        name: tl_rv_dm__sba
        struct: tl
        package: tlul_pkg
        type: req_rsp
        act: rsp
        inst_name: main
        width: 1
        default: ""
        end_idx: -1
        top_type: one-to-one
        top_signame: main_tl_rv_dm__sba
        index: -1
      }
      {
        name: tl_dma__host
        struct: tl
        package: tlul_pkg
        type: req_rsp
        act: rsp
        inst_name: main
        width: 1
        default: ""
        end_idx: -1
        top_type: one-to-one
        top_signame: main_tl_dma__host
        index: -1
      }
      {
        name: tl_mbx0__sram
        struct: tl
        package: tlul_pkg
        type: req_rsp
        act: rsp
        inst_name: main
        width: 1
        default: ""
        end_idx: -1
        top_type: one-to-one
        top_signame: main_tl_mbx0__sram
        index: -1
      }
      {
        name: tl_mbx1__sram
        struct: tl
        package: tlul_pkg
        type: req_rsp
        act: rsp
        inst_name: main
        width: 1
        default: ""
        end_idx: -1
        top_type: one-to-one
        top_signame: main_tl_mbx1__sram
        index: -1
      }
      {
        name: tl_mbx2__sram
        struct: tl
        package: tlul_pkg
        type: req_rsp
        act: rsp
        inst_name: main
        width: 1
        default: ""
        end_idx: -1
        top_type: one-to-one
        top_signame: main_tl_mbx2__sram
        index: -1
      }
      {
        name: tl_mbx3__sram
        struct: tl
        package: tlul_pkg
        type: req_rsp
        act: rsp
        inst_name: main
        width: 1
        default: ""
        end_idx: -1
        top_type: one-to-one
        top_signame: main_tl_mbx3__sram
        index: -1
      }
      {
        name: tl_mbx4__sram
        struct: tl
        package: tlul_pkg
        type: req_rsp
        act: rsp
        inst_name: main
        width: 1
        default: ""
        end_idx: -1
        top_type: one-to-one
        top_signame: main_tl_mbx4__sram
        index: -1
      }
      {
        name: tl_mbx5__sram
        struct: tl
        package: tlul_pkg
        type: req_rsp
        act: rsp
        inst_name: main
        width: 1
        default: ""
        end_idx: -1
        top_type: one-to-one
        top_signame: main_tl_mbx5__sram
        index: -1
      }
      {
        name: tl_mbx6__sram
        struct: tl
        package: tlul_pkg
        type: req_rsp
        act: rsp
        inst_name: main
        width: 1
        default: ""
        end_idx: -1
        top_type: one-to-one
        top_signame: main_tl_mbx6__sram
        index: -1
      }
      {
        name: tl_mbx_jtag__sram
        struct: tl
        package: tlul_pkg
        type: req_rsp
        act: rsp
        inst_name: main
        width: 1
        default: ""
        end_idx: -1
        top_type: one-to-one
        top_signame: main_tl_mbx_jtag__sram
        index: -1
      }
      {
        name: tl_mbx_pcie0__sram
        struct: tl
        package: tlul_pkg
        type: req_rsp
        act: rsp
        inst_name: main
        width: 1
        default: ""
        end_idx: -1
        top_type: one-to-one
        top_signame: main_tl_mbx_pcie0__sram
        index: -1
      }
      {
        name: tl_mbx_pcie1__sram
        struct: tl
        package: tlul_pkg
        type: req_rsp
        act: rsp
        inst_name: main
        width: 1
        default: ""
        end_idx: -1
        top_type: one-to-one
        top_signame: main_tl_mbx_pcie1__sram
        index: -1
      }
      {
        name: tl_rv_dm__regs
        struct: tl
        package: tlul_pkg
        type: req_rsp
        act: req
        inst_name: main
        width: 1
        default: ""
        domain: Main
        top_signame: rv_dm_regs_tl_d
        index: -1
      }
      {
        name: tl_rv_dm__mem
        struct: tl
        package: tlul_pkg
        type: req_rsp
        act: req
        inst_name: main
        width: 1
        default: ""
        domain: Main
        top_signame: rv_dm_mem_tl_d
        index: -1
      }
      {
        name: tl_rom_ctrl0__rom
        struct: tl
        package: tlul_pkg
        type: req_rsp
        act: req
        inst_name: main
        width: 1
        default: ""
        domain: Main
        top_signame: rom_ctrl0_rom_tl
        index: -1
      }
      {
        name: tl_rom_ctrl0__regs
        struct: tl
        package: tlul_pkg
        type: req_rsp
        act: req
        inst_name: main
        width: 1
        default: ""
        domain: Main
        top_signame: rom_ctrl0_regs_tl
        index: -1
      }
      {
        name: tl_rom_ctrl1__rom
        struct: tl
        package: tlul_pkg
        type: req_rsp
        act: req
        inst_name: main
        width: 1
        default: ""
        domain: Main
        top_signame: rom_ctrl1_rom_tl
        index: -1
      }
      {
        name: tl_rom_ctrl1__regs
        struct: tl
        package: tlul_pkg
        type: req_rsp
        act: req
        inst_name: main
        width: 1
        default: ""
        domain: Main
        top_signame: rom_ctrl1_regs_tl
        index: -1
      }
      {
        name: tl_peri
        struct: tl
        package: tlul_pkg
        type: req_rsp
        act: req
        inst_name: main
        width: 1
        default: ""
        end_idx: -1
        top_type: one-to-one
        top_signame: main_tl_peri
        index: -1
      }
      {
        name: tl_soc_proxy__core
        struct: tl
        package: tlul_pkg
        type: req_rsp
        act: req
        inst_name: main
        width: 1
        default: ""
        domain: Main
        top_signame: soc_proxy_core_tl
        index: -1
        external: true
        conn_type: false
      }
      {
        name: tl_soc_proxy__ctn
        struct: tl
        package: tlul_pkg
        type: req_rsp
        act: req
        inst_name: main
        width: 1
        default: ""
        domain: Main
        top_signame: soc_proxy_ctn_tl
        index: -1
        external: true
        conn_type: false
      }
      {
        name: tl_hmac
        struct: tl
        package: tlul_pkg
        type: req_rsp
        act: req
        inst_name: main
        width: 1
        default: ""
        domain: Main
        top_signame: hmac_tl
        index: -1
      }
      {
        name: tl_kmac
        struct: tl
        package: tlul_pkg
        type: req_rsp
        act: req
        inst_name: main
        width: 1
        default: ""
        domain: Main
        top_signame: kmac_tl
        index: -1
      }
      {
        name: tl_aes
        struct: tl
        package: tlul_pkg
        type: req_rsp
        act: req
        inst_name: main
        width: 1
        default: ""
        domain: Main
        top_signame: aes_tl
        index: -1
      }
      {
        name: tl_entropy_src
        struct: tl
        package: tlul_pkg
        type: req_rsp
        act: req
        inst_name: main
        width: 1
        default: ""
        domain: Main
        top_signame: entropy_src_tl
        index: -1
      }
      {
        name: tl_csrng
        struct: tl
        package: tlul_pkg
        type: req_rsp
        act: req
        inst_name: main
        width: 1
        default: ""
        domain: Main
        top_signame: csrng_tl
        index: -1
      }
      {
        name: tl_edn0
        struct: tl
        package: tlul_pkg
        type: req_rsp
        act: req
        inst_name: main
        width: 1
        default: ""
        domain: Main
        top_signame: edn0_tl
        index: -1
      }
      {
        name: tl_edn1
        struct: tl
        package: tlul_pkg
        type: req_rsp
        act: req
        inst_name: main
        width: 1
        default: ""
        domain: Main
        top_signame: edn1_tl
        index: -1
      }
      {
        name: tl_rv_plic
        struct: tl
        package: tlul_pkg
        type: req_rsp
        act: req
        inst_name: main
        width: 1
        default: ""
        domain: Main
        top_signame: rv_plic_tl
        index: -1
      }
      {
        name: tl_otbn
        struct: tl
        package: tlul_pkg
        type: req_rsp
        act: req
        inst_name: main
        width: 1
        default: ""
        domain: Main
        top_signame: otbn_tl
        index: -1
      }
      {
        name: tl_keymgr_dpe
        struct: tl
        package: tlul_pkg
        type: req_rsp
        act: req
        inst_name: main
        width: 1
        default: ""
        domain: Main
        top_signame: keymgr_dpe_tl
        index: -1
      }
      {
        name: tl_rv_core_ibex__cfg
        struct: tl
        package: tlul_pkg
        type: req_rsp
        act: req
        inst_name: main
        width: 1
        default: ""
        domain: Main
        top_signame: rv_core_ibex_cfg_tl_d
        index: -1
      }
      {
        name: tl_sram_ctrl_main__regs
        struct: tl
        package: tlul_pkg
        type: req_rsp
        act: req
        inst_name: main
        width: 1
        default: ""
        domain: Main
        top_signame: sram_ctrl_main_regs_tl
        index: -1
      }
      {
        name: tl_sram_ctrl_main__ram
        struct: tl
        package: tlul_pkg
        type: req_rsp
        act: req
        inst_name: main
        width: 1
        default: ""
        domain: Main
        top_signame: sram_ctrl_main_ram_tl
        index: -1
      }
      {
        name: tl_sram_ctrl_mbox__regs
        struct: tl
        package: tlul_pkg
        type: req_rsp
        act: req
        inst_name: main
        width: 1
        default: ""
        domain: Main
        top_signame: sram_ctrl_mbox_regs_tl
        index: -1
      }
      {
        name: tl_sram_ctrl_mbox__ram
        struct: tl
        package: tlul_pkg
        type: req_rsp
        act: req
        inst_name: main
        width: 1
        default: ""
        domain: Main
        top_signame: sram_ctrl_mbox_ram_tl
        index: -1
      }
      {
        name: tl_dma
        struct: tl
        package: tlul_pkg
        type: req_rsp
        act: req
        inst_name: main
        width: 1
        default: ""
        domain: Main
        top_signame: dma_tl_d
        index: -1
      }
      {
        name: tl_mbx0__core
        struct: tl
        package: tlul_pkg
        type: req_rsp
        act: req
        inst_name: main
        width: 1
        default: ""
        domain: Main
        top_signame: mbx0_core_tl_d
        index: -1
      }
      {
        name: tl_mbx1__core
        struct: tl
        package: tlul_pkg
        type: req_rsp
        act: req
        inst_name: main
        width: 1
        default: ""
        domain: Main
        top_signame: mbx1_core_tl_d
        index: -1
      }
      {
        name: tl_mbx2__core
        struct: tl
        package: tlul_pkg
        type: req_rsp
        act: req
        inst_name: main
        width: 1
        default: ""
        domain: Main
        top_signame: mbx2_core_tl_d
        index: -1
      }
      {
        name: tl_mbx3__core
        struct: tl
        package: tlul_pkg
        type: req_rsp
        act: req
        inst_name: main
        width: 1
        default: ""
        domain: Main
        top_signame: mbx3_core_tl_d
        index: -1
      }
      {
        name: tl_mbx4__core
        struct: tl
        package: tlul_pkg
        type: req_rsp
        act: req
        inst_name: main
        width: 1
        default: ""
        domain: Main
        top_signame: mbx4_core_tl_d
        index: -1
      }
      {
        name: tl_mbx5__core
        struct: tl
        package: tlul_pkg
        type: req_rsp
        act: req
        inst_name: main
        width: 1
        default: ""
        domain: Main
        top_signame: mbx5_core_tl_d
        index: -1
      }
      {
        name: tl_mbx6__core
        struct: tl
        package: tlul_pkg
        type: req_rsp
        act: req
        inst_name: main
        width: 1
        default: ""
        domain: Main
        top_signame: mbx6_core_tl_d
        index: -1
      }
      {
        name: tl_mbx_jtag__core
        struct: tl
        package: tlul_pkg
        type: req_rsp
        act: req
        inst_name: main
        width: 1
        default: ""
        domain: Main
        top_signame: mbx_jtag_core_tl_d
        index: -1
      }
      {
        name: tl_mbx_pcie0__core
        struct: tl
        package: tlul_pkg
        type: req_rsp
        act: req
        inst_name: main
        width: 1
        default: ""
        domain: Main
        top_signame: mbx_pcie0_core_tl_d
        index: -1
      }
      {
        name: tl_mbx_pcie1__core
        struct: tl
        package: tlul_pkg
        type: req_rsp
        act: req
        inst_name: main
        width: 1
        default: ""
        domain: Main
        top_signame: mbx_pcie1_core_tl_d
        index: -1
      }
      {
        name: tl_main
        struct: tl
        package: tlul_pkg
        type: req_rsp
        act: rsp
        inst_name: peri
        width: 1
        default: ""
        domain: Main
        top_signame: main_tl_peri
        index: -1
      }
      {
        name: tl_uart0
        struct: tl
        package: tlul_pkg
        type: req_rsp
        act: req
        inst_name: peri
        width: 1
        default: ""
        domain: Main
        top_signame: uart0_tl
        index: -1
      }
      {
        name: tl_i2c0
        struct: tl
        package: tlul_pkg
        type: req_rsp
        act: req
        inst_name: peri
        width: 1
        default: ""
        domain: Main
        top_signame: i2c0_tl
        index: -1
      }
      {
        name: tl_gpio0
        struct: tl
        package: tlul_pkg
        type: req_rsp
        act: req
        inst_name: peri
        width: 1
        default: ""
        domain: Main
        top_signame: gpio0_tl
        index: -1
      }
      {
        name: tl_spi_host0
        struct: tl
        package: tlul_pkg
        type: req_rsp
        act: req
        inst_name: peri
        width: 1
        default: ""
        domain: Main
        top_signame: spi_host0_tl
        index: -1
      }
      {
        name: tl_spi_device
        struct: tl
        package: tlul_pkg
        type: req_rsp
        act: req
        inst_name: peri
        width: 1
        default: ""
        domain: Main
        top_signame: spi_device_tl
        index: -1
      }
      {
        name: tl_rv_timer
        struct: tl
        package: tlul_pkg
        type: req_rsp
        act: req
        inst_name: peri
        width: 1
        default: ""
        domain: Main
        top_signame: rv_timer_tl
        index: -1
      }
      {
        name: tl_pwrmgr
        struct: tl
        package: tlul_pkg
        type: req_rsp
        act: req
        inst_name: peri
        width: 1
        default: ""
        domain: Main
        top_signame: pwrmgr_tl
        index: -1
        external: true
        conn_type: false
      }
      {
        name: tl_rstmgr
        struct: tl
        package: tlul_pkg
        type: req_rsp
        act: req
        inst_name: peri
        width: 1
        default: ""
        domain: Main
        top_signame: rstmgr_tl
        index: -1
        external: true
        conn_type: false
      }
      {
        name: tl_clkmgr
        struct: tl
        package: tlul_pkg
        type: req_rsp
        act: req
        inst_name: peri
        width: 1
        default: ""
        domain: Main
        top_signame: clkmgr_tl
        index: -1
        external: true
        conn_type: false
      }
      {
        name: tl_pinmux
        struct: tl
        package: tlul_pkg
        type: req_rsp
        act: req
        inst_name: peri
        width: 1
        default: ""
        domain: Main
        top_signame: pinmux_tl
        index: -1
      }
      {
        name: tl_otp_ctrl__core
        struct: tl
        package: tlul_pkg
        type: req_rsp
        act: req
        inst_name: peri
        width: 1
        default: ""
        domain: Main
        top_signame: otp_ctrl_core_tl
        index: -1
      }
      {
        name: tl_otp_macro__prim
        struct: tl
        package: tlul_pkg
        type: req_rsp
        act: req
        inst_name: peri
        width: 1
        default: ""
        domain: Main
        top_signame: otp_macro_prim_tl
        index: -1
      }
      {
        name: tl_lc_ctrl__regs
        struct: tl
        package: tlul_pkg
        type: req_rsp
        act: req
        inst_name: peri
        width: 1
        default: ""
        domain: Main
        top_signame: lc_ctrl_regs_tl
        index: -1
      }
      {
        name: tl_alert_handler
        struct: tl
        package: tlul_pkg
        type: req_rsp
        act: req
        inst_name: peri
        width: 1
        default: ""
        domain: Main
        top_signame: alert_handler_tl
        index: -1
      }
      {
        name: tl_sram_ctrl_ret__regs
        struct: tl
        package: tlul_pkg
        type: req_rsp
        act: req
        inst_name: peri
        width: 1
        default: ""
        domain: Main
        top_signame: sram_ctrl_ret_regs_tl
        index: -1
        external: true
        conn_type: false
      }
      {
        name: tl_sram_ctrl_ret__ram
        struct: tl
        package: tlul_pkg
        type: req_rsp
        act: req
        inst_name: peri
        width: 1
        default: ""
        domain: Main
        top_signame: sram_ctrl_ret_ram_tl
        index: -1
        external: true
        conn_type: false
      }
      {
        name: tl_aon_timer
        struct: tl
        package: tlul_pkg
        type: req_rsp
        act: req
        inst_name: peri
        width: 1
        default: ""
        domain: Main
        top_signame: aon_timer_tl
        index: -1
        external: true
        conn_type: false
      }
      {
        name: tl_ast
        struct: tl
        package: tlul_pkg
        type: req_rsp
        act: req
        inst_name: peri
        width: 1
        default: ""
        external: true
        conn_type: false
        index: -1
        top_signame: ast_tl
      }
      {
        name: tl_soc_dbg_ctrl__core
        struct: tl
        package: tlul_pkg
        type: req_rsp
        act: req
        inst_name: peri
        width: 1
        default: ""
        domain: Main
        top_signame: soc_dbg_ctrl_core_tl
        index: -1
      }
      {
        name: tl_mbx
        struct: tl
        package: tlul_pkg
        type: req_rsp
        act: rsp
        inst_name: mbx
        width: 1
        default: ""
        external: true
        conn_type: false
        index: -1
        top_signame: mbx_tl
      }
      {
        name: tl_mbx0__soc
        struct: tl
        package: tlul_pkg
        type: req_rsp
        act: req
        inst_name: mbx
        width: 1
        default: ""
        domain: Main
        top_signame: mbx0_soc_tl_d
        index: -1
      }
      {
        name: tl_mbx1__soc
        struct: tl
        package: tlul_pkg
        type: req_rsp
        act: req
        inst_name: mbx
        width: 1
        default: ""
        domain: Main
        top_signame: mbx1_soc_tl_d
        index: -1
      }
      {
        name: tl_mbx2__soc
        struct: tl
        package: tlul_pkg
        type: req_rsp
        act: req
        inst_name: mbx
        width: 1
        default: ""
        domain: Main
        top_signame: mbx2_soc_tl_d
        index: -1
      }
      {
        name: tl_mbx3__soc
        struct: tl
        package: tlul_pkg
        type: req_rsp
        act: req
        inst_name: mbx
        width: 1
        default: ""
        domain: Main
        top_signame: mbx3_soc_tl_d
        index: -1
      }
      {
        name: tl_mbx4__soc
        struct: tl
        package: tlul_pkg
        type: req_rsp
        act: req
        inst_name: mbx
        width: 1
        default: ""
        domain: Main
        top_signame: mbx4_soc_tl_d
        index: -1
      }
      {
        name: tl_mbx5__soc
        struct: tl
        package: tlul_pkg
        type: req_rsp
        act: req
        inst_name: mbx
        width: 1
        default: ""
        domain: Main
        top_signame: mbx5_soc_tl_d
        index: -1
      }
      {
        name: tl_mbx6__soc
        struct: tl
        package: tlul_pkg
        type: req_rsp
        act: req
        inst_name: mbx
        width: 1
        default: ""
        domain: Main
        top_signame: mbx6_soc_tl_d
        index: -1
      }
      {
        name: tl_mbx_pcie0__soc
        struct: tl
        package: tlul_pkg
        type: req_rsp
        act: req
        inst_name: mbx
        width: 1
        default: ""
        domain: Main
        top_signame: mbx_pcie0_soc_tl_d
        index: -1
      }
      {
        name: tl_mbx_pcie1__soc
        struct: tl
        package: tlul_pkg
        type: req_rsp
        act: req
        inst_name: mbx
        width: 1
        default: ""
        domain: Main
        top_signame: mbx_pcie1_soc_tl_d
        index: -1
      }
      {
        name: tl_racl_ctrl
        struct: tl
        package: tlul_pkg
        type: req_rsp
        act: req
        inst_name: mbx
        width: 1
        default: ""
        domain: Main
        top_signame: racl_ctrl_tl
        index: -1
      }
      {
        name: tl_ac_range_check
        struct: tl
        package: tlul_pkg
        type: req_rsp
        act: req
        inst_name: mbx
        width: 1
        default: ""
        domain: Main
        top_signame: ac_range_check_tl
        index: -1
      }
      {
        name: tl_dbg
        struct: tl
        package: tlul_pkg
        type: req_rsp
        act: rsp
        inst_name: dbg
        width: 1
        default: ""
        external: true
        conn_type: false
        index: -1
        top_signame: dbg_tl
      }
      {
        name: tl_rv_dm__dbg
        struct: tl
        package: tlul_pkg
        type: req_rsp
        act: req
        inst_name: dbg
        width: 1
        default: ""
        domain: Main
        top_signame: rv_dm_dbg_tl_d
        index: -1
      }
      {
        name: tl_mbx_jtag__soc
        struct: tl
        package: tlul_pkg
        type: req_rsp
        act: req
        inst_name: dbg
        width: 1
        default: ""
        domain: Main
        top_signame: mbx_jtag_soc_tl_d
        index: -1
      }
      {
        name: tl_lc_ctrl__dmi
        struct: tl
        package: tlul_pkg
        type: req_rsp
        act: req
        inst_name: dbg
        width: 1
        default: ""
        domain: Main
        top_signame: lc_ctrl_dmi_tl
        index: -1
      }
      {
        name: tl_soc_dbg_ctrl__jtag
        struct: tl
        package: tlul_pkg
        type: req_rsp
        act: req
        inst_name: dbg
        width: 1
        default: ""
        domain: Main
        top_signame: soc_dbg_ctrl_jtag_tl
        index: -1
      }
      {
        struct: lc_tx
        type: uni
        name: lc_dft_en
        act: req
        package: lc_ctrl_pkg
        inst_name: ast
        width: 1
        default: ""
        domain: Main
        top_signame: lc_ctrl_lc_dft_en
        index: -1
        external: true
        conn_type: true
      }
      {
        struct: lc_tx
        type: uni
        name: lc_hw_debug_en
        act: req
        package: lc_ctrl_pkg
        inst_name: ast
        width: 1
        default: ""
        domain: Main
        top_signame: lc_ctrl_lc_hw_debug_en
        index: -1
        external: true
        conn_type: true
      }
      {
        struct: ast_obs_ctrl
        type: uni
        name: obs_ctrl
        act: rcv
        package: ast_pkg
        inst_name: ast
        width: 1
        default: ""
        end_idx: -1
        top_type: broadcast
        top_signame: ast_obs_ctrl
        index: -1
        external: true
        conn_type: true
      }
    ]
    external:
    [
      {
        package: alert_handler_pkg
        struct: alert_crashdump
        domain: Main
        inter_pd: true
        signame: alert_handler_crashdump_o
        signame_chip:
        {
          asic: alert_handler_crashdump
          verilator: alert_handler_crashdump
        }
        width: 1
        type: uni
        default: ""
        direction: out
        conn_type: false
        index: -1
        netname: alert_handler_crashdump
      }
      {
        package: alert_handler_pkg
        struct: alert_crashdump
        domain: Aon
        inter_pd: true
        signame: alert_handler_crashdump_i
        signame_chip:
        {
          asic: alert_handler_crashdump
          verilator: alert_handler_crashdump
        }
        width: 1
        type: uni
        default: ""
        direction: in
        conn_type: false
        index: -1
        netname: alert_handler_crashdump
      }
      {
        package: prim_esc_pkg
        struct: esc_rx
        domain: Main
        inter_pd: true
        signame: alert_handler_esc_rx_i
        signame_chip:
        {
          asic: alert_handler_esc_rx
          verilator: alert_handler_esc_rx
        }
        width: 1
        type: uni
        default: ""
        direction: in
        conn_type: true
        index: 3
        netname: alert_handler_esc_rx
      }
      {
        package: prim_esc_pkg
        struct: esc_rx
        domain: Aon
        inter_pd: true
        signame: alert_handler_esc_rx_o
        signame_chip:
        {
          asic: alert_handler_esc_rx
          verilator: alert_handler_esc_rx
        }
        width: 1
        type: uni
        default: ""
        direction: out
        conn_type: false
        index: 3
        netname: alert_handler_esc_rx
      }
      {
        package: prim_esc_pkg
        struct: esc_tx
        domain: Main
        inter_pd: true
        signame: alert_handler_esc_tx_o
        signame_chip:
        {
          asic: alert_handler_esc_tx
          verilator: alert_handler_esc_tx
        }
        width: 1
        type: uni
        default: ""
        direction: out
        conn_type: true
        index: 3
        netname: alert_handler_esc_tx
      }
      {
        package: prim_esc_pkg
        struct: esc_tx
        domain: Aon
        inter_pd: true
        signame: alert_handler_esc_tx_i
        signame_chip:
        {
          asic: alert_handler_esc_tx
          verilator: alert_handler_esc_tx
        }
        width: 1
        type: uni
        default: ""
        direction: in
        conn_type: false
        index: 3
        netname: alert_handler_esc_tx
      }
      {
        package: ""
        struct: logic
        domain: Aon
        inter_pd: true
        signame: aon_timer_nmi_wdog_timer_bark_o
        signame_chip:
        {
          asic: aon_timer_nmi_wdog_timer_bark
          verilator: aon_timer_nmi_wdog_timer_bark
        }
        width: 1
        type: uni
        default: 1'b0
        direction: out
        conn_type: false
        index: -1
        netname: aon_timer_nmi_wdog_timer_bark
      }
      {
        package: ""
        struct: logic
        domain: Main
        inter_pd: true
        signame: aon_timer_nmi_wdog_timer_bark_i
        signame_chip:
        {
          asic: aon_timer_nmi_wdog_timer_bark
          verilator: aon_timer_nmi_wdog_timer_bark
        }
        width: 1
        type: uni
        default: 1'b0
        direction: in
        conn_type: false
        index: -1
        netname: aon_timer_nmi_wdog_timer_bark
      }
      {
        package: otp_ctrl_pkg
        struct: sram_otp_key_req
        domain: Main
        inter_pd: true
        signame: otp_ctrl_sram_otp_key_req_i
        signame_chip:
        {
          asic: otp_ctrl_sram_otp_key_req
          verilator: otp_ctrl_sram_otp_key_req
        }
        width: 1
        type: req_rsp
        default: "'0"
        direction: in
        conn_type: true
        index: 1
        netname: otp_ctrl_sram_otp_key_req
      }
      {
        package: otp_ctrl_pkg
        struct: sram_otp_key_rsp
        domain: Main
        inter_pd: true
        signame: otp_ctrl_sram_otp_key_rsp_o
        signame_chip:
        {
          asic: otp_ctrl_sram_otp_key_rsp
          verilator: otp_ctrl_sram_otp_key_rsp
        }
        width: 1
        type: req_rsp
        default: "'0"
        direction: out
        conn_type: true
        index: 1
        netname: otp_ctrl_sram_otp_key_rsp
      }
      {
        package: otp_ctrl_pkg
        struct: sram_otp_key_req
        domain: Aon
        inter_pd: true
        signame: otp_ctrl_sram_otp_key_req_o
        signame_chip:
        {
          asic: otp_ctrl_sram_otp_key_req
          verilator: otp_ctrl_sram_otp_key_req
        }
        width: 1
        type: req_rsp
        default: "'0"
        direction: out
        conn_type: false
        index: 1
        netname: otp_ctrl_sram_otp_key_req
      }
      {
        package: otp_ctrl_pkg
        struct: sram_otp_key_rsp
        domain: Aon
        inter_pd: true
        signame: otp_ctrl_sram_otp_key_rsp_i
        signame_chip:
        {
          asic: otp_ctrl_sram_otp_key_rsp
          verilator: otp_ctrl_sram_otp_key_rsp
        }
        width: 1
        type: req_rsp
        default: "'0"
        direction: in
        conn_type: false
        index: 1
        netname: otp_ctrl_sram_otp_key_rsp
      }
      {
        package: pwrmgr_pkg
        struct: pwr_otp_req
        domain: Aon
        inter_pd: true
        signame: pwrmgr_pwr_otp_req_o
        signame_chip:
        {
          asic: pwrmgr_pwr_otp_req
          verilator: pwrmgr_pwr_otp_req
        }
        width: 1
        type: req_rsp
        default: ""
        direction: out
        conn_type: false
        index: -1
        netname: pwrmgr_pwr_otp_req
      }
      {
        package: pwrmgr_pkg
        struct: pwr_otp_rsp
        domain: Aon
        inter_pd: true
        signame: pwrmgr_pwr_otp_rsp_i
        signame_chip:
        {
          asic: pwrmgr_pwr_otp_rsp
          verilator: pwrmgr_pwr_otp_rsp
        }
        width: 1
        type: req_rsp
        default: ""
        direction: in
        conn_type: false
        index: -1
        netname: pwrmgr_pwr_otp_rsp
      }
      {
        package: pwrmgr_pkg
        struct: pwr_otp_req
        domain: Main
        inter_pd: true
        signame: pwrmgr_pwr_otp_req_i
        signame_chip:
        {
          asic: pwrmgr_pwr_otp_req
          verilator: pwrmgr_pwr_otp_req
        }
        width: 1
        type: req_rsp
        default: ""
        direction: in
        conn_type: false
        index: -1
        netname: pwrmgr_pwr_otp_req
      }
      {
        package: pwrmgr_pkg
        struct: pwr_otp_rsp
        domain: Main
        inter_pd: true
        signame: pwrmgr_pwr_otp_rsp_o
        signame_chip:
        {
          asic: pwrmgr_pwr_otp_rsp
          verilator: pwrmgr_pwr_otp_rsp
        }
        width: 1
        type: req_rsp
        default: ""
        direction: out
        conn_type: false
        index: -1
        netname: pwrmgr_pwr_otp_rsp
      }
      {
        package: lc_ctrl_pkg
        struct: pwr_lc_req
        domain: Aon
        inter_pd: true
        signame: pwrmgr_pwr_lc_req_o
        signame_chip:
        {
          asic: pwrmgr_pwr_lc_req
          verilator: pwrmgr_pwr_lc_req
        }
        width: 1
        type: req_rsp
        default: ""
        direction: out
        conn_type: false
        index: -1
        netname: pwrmgr_pwr_lc_req
      }
      {
        package: lc_ctrl_pkg
        struct: pwr_lc_rsp
        domain: Aon
        inter_pd: true
        signame: pwrmgr_pwr_lc_rsp_i
        signame_chip:
        {
          asic: pwrmgr_pwr_lc_rsp
          verilator: pwrmgr_pwr_lc_rsp
        }
        width: 1
        type: req_rsp
        default: ""
        direction: in
        conn_type: false
        index: -1
        netname: pwrmgr_pwr_lc_rsp
      }
      {
        package: lc_ctrl_pkg
        struct: pwr_lc_req
        domain: Main
        inter_pd: true
        signame: pwrmgr_pwr_lc_req_i
        signame_chip:
        {
          asic: pwrmgr_pwr_lc_req
          verilator: pwrmgr_pwr_lc_req
        }
        width: 1
        type: req_rsp
        default: ""
        direction: in
        conn_type: false
        index: -1
        netname: pwrmgr_pwr_lc_req
      }
      {
        package: lc_ctrl_pkg
        struct: pwr_lc_rsp
        domain: Main
        inter_pd: true
        signame: pwrmgr_pwr_lc_rsp_o
        signame_chip:
        {
          asic: pwrmgr_pwr_lc_rsp
          verilator: pwrmgr_pwr_lc_rsp
        }
        width: 1
        type: req_rsp
        default: ""
        direction: out
        conn_type: false
        index: -1
        netname: pwrmgr_pwr_lc_rsp
      }
      {
        package: ""
        struct: logic
        domain: Aon
        inter_pd: true
        signame: pwrmgr_strap_o
        signame_chip:
        {
          asic: pwrmgr_strap
          verilator: pwrmgr_strap
        }
        width: 1
        type: uni
        default: ""
        direction: out
        conn_type: false
        index: -1
        netname: pwrmgr_strap
      }
      {
        package: ""
        struct: logic
        domain: Main
        inter_pd: true
        signame: pwrmgr_strap_i
        signame_chip:
        {
          asic: pwrmgr_strap
          verilator: pwrmgr_strap
        }
        width: 1
        type: uni
        default: ""
        direction: in
        conn_type: false
        index: -1
        netname: pwrmgr_strap
      }
      {
        package: ""
        struct: logic
        domain: Aon
        inter_pd: true
        signame: pwrmgr_low_power_o
        signame_chip:
        {
          asic: pwrmgr_low_power
          verilator: pwrmgr_low_power
        }
        width: 1
        type: uni
        default: ""
        direction: out
        conn_type: true
        index: -1
        netname: pwrmgr_low_power
      }
      {
        package: ""
        struct: logic
        domain: Main
        inter_pd: true
        signame: pwrmgr_low_power_i
        signame_chip:
        {
          asic: pwrmgr_low_power
          verilator: pwrmgr_low_power
        }
        width: 1
        type: uni
        default: ""
        direction: in
        conn_type: false
        index: -1
        netname: pwrmgr_low_power
      }
      {
        package: lc_ctrl_pkg
        struct: lc_tx
        domain: Aon
        inter_pd: true
        signame: pwrmgr_fetch_en_o
        signame_chip:
        {
          asic: pwrmgr_fetch_en
          verilator: pwrmgr_fetch_en
        }
        width: 1
        type: uni
        default: ""
        direction: out
        conn_type: false
        index: -1
        netname: pwrmgr_fetch_en
      }
      {
        package: lc_ctrl_pkg
        struct: lc_tx
        domain: Main
        inter_pd: true
        signame: pwrmgr_fetch_en_i
        signame_chip:
        {
          asic: pwrmgr_fetch_en
          verilator: pwrmgr_fetch_en
        }
        width: 1
        type: uni
        default: ""
        direction: in
        conn_type: false
        index: -1
        netname: pwrmgr_fetch_en
      }
      {
        package: rom_ctrl_pkg
        struct: pwrmgr_data
        domain: Aon
        inter_pd: true
        signame: pwrmgr_rom_ctrl_i
        signame_chip:
        {
          asic: pwrmgr_rom_ctrl
          verilator: pwrmgr_rom_ctrl
        }
        width: 3
        type: uni
        default: rom_ctrl_pkg::PWRMGR_DATA_DEFAULT
        direction: in
        conn_type: false
        index: -1
        netname: pwrmgr_rom_ctrl
      }
      {
        package: rom_ctrl_pkg
        struct: pwrmgr_data
        domain: Main
        inter_pd: true
        signame: pwrmgr_rom_ctrl_o
        signame_chip:
        {
          asic: pwrmgr_rom_ctrl
          verilator: pwrmgr_rom_ctrl
        }
        width: 3
        type: uni
        default: rom_ctrl_pkg::PWRMGR_DATA_DEFAULT
        direction: out
        conn_type: false
        index: -1
        netname: pwrmgr_rom_ctrl
      }
      {
        package: pwrmgr_pkg
        struct: pwr_boot_status
        domain: Aon
        inter_pd: true
        signame: pwrmgr_boot_status_o
        signame_chip:
        {
          asic: pwrmgr_boot_status
          verilator: pwrmgr_boot_status
        }
        width: 1
        type: uni
        default: ""
        direction: out
        conn_type: true
        index: -1
        netname: pwrmgr_boot_status
      }
      {
        package: pwrmgr_pkg
        struct: pwr_boot_status
        domain: Main
        inter_pd: true
        signame: pwrmgr_boot_status_i
        signame_chip:
        {
          asic: pwrmgr_boot_status
          verilator: pwrmgr_boot_status
        }
        width: 1
        type: uni
        default: ""
        direction: in
        conn_type: false
        index: -1
        netname: pwrmgr_boot_status
      }
      {
        package: dma_pkg
        struct: lsio_trigger
        domain: Main
        inter_pd: true
        signame: dma_lsio_trigger_i
        signame_chip:
        {
          asic: dma_lsio_trigger
          verilator: dma_lsio_trigger
        }
        width: 1
        type: uni
        default: ""
        direction: in
        conn_type: false
        index: -1
        netname: dma_lsio_trigger
      }
      {
        package: dma_pkg
        struct: lsio_trigger
        domain: Aon
        inter_pd: true
        signame: dma_lsio_trigger_o
        signame_chip:
        {
          asic: dma_lsio_trigger
          verilator: dma_lsio_trigger
        }
        width: 1
        type: uni
        default: ""
        direction: out
        conn_type: false
        index: -1
        netname: dma_lsio_trigger
      }
      {
        package: ""
        struct: logic
        domain: Main
        inter_pd: true
        signame: i2c0_lsio_trigger_o
        signame_chip:
        {
          asic: i2c0_lsio_trigger
          verilator: i2c0_lsio_trigger
        }
        width: 1
        type: uni
        default: ""
        direction: out
        conn_type: false
        index: -1
        netname: i2c0_lsio_trigger
      }
      {
        package: ""
        struct: logic
        domain: Aon
        inter_pd: true
        signame: i2c0_lsio_trigger_i
        signame_chip:
        {
          asic: i2c0_lsio_trigger
          verilator: i2c0_lsio_trigger
        }
        width: 1
        type: uni
        default: ""
        direction: in
        conn_type: false
        index: -1
        netname: i2c0_lsio_trigger
      }
      {
        package: ""
        struct: logic
        domain: Main
        inter_pd: true
        signame: spi_host0_lsio_trigger_o
        signame_chip:
        {
          asic: spi_host0_lsio_trigger
          verilator: spi_host0_lsio_trigger
        }
        width: 1
        type: uni
        default: ""
        direction: out
        conn_type: false
        index: -1
        netname: spi_host0_lsio_trigger
      }
      {
        package: ""
        struct: logic
        domain: Aon
        inter_pd: true
        signame: spi_host0_lsio_trigger_i
        signame_chip:
        {
          asic: spi_host0_lsio_trigger
          verilator: spi_host0_lsio_trigger
        }
        width: 1
        type: uni
        default: ""
        direction: in
        conn_type: false
        index: -1
        netname: spi_host0_lsio_trigger
      }
      {
        package: ""
        struct: logic
        domain: Main
        inter_pd: true
        signame: uart0_lsio_trigger_o
        signame_chip:
        {
          asic: uart0_lsio_trigger
          verilator: uart0_lsio_trigger
        }
        width: 1
        type: uni
        default: ""
        direction: out
        conn_type: false
        index: -1
        netname: uart0_lsio_trigger
      }
      {
        package: ""
        struct: logic
        domain: Aon
        inter_pd: true
        signame: uart0_lsio_trigger_i
        signame_chip:
        {
          asic: uart0_lsio_trigger
          verilator: uart0_lsio_trigger
        }
        width: 1
        type: uni
        default: ""
        direction: in
        conn_type: false
        index: -1
        netname: uart0_lsio_trigger
      }
      {
        package: prim_mubi_pkg
        struct: mubi4
        domain: Aon
        inter_pd: true
        signame: clkmgr_idle_i
        signame_chip:
        {
          asic: clkmgr_idle
          verilator: clkmgr_idle
        }
        width: 4
        type: uni
        default: ""
        direction: in
        conn_type: false
        index: -1
        netname: clkmgr_idle
      }
      {
        package: prim_mubi_pkg
        struct: mubi4
        domain: Main
        inter_pd: true
        signame: clkmgr_idle_o
        signame_chip:
        {
          asic: clkmgr_idle
          verilator: clkmgr_idle
        }
        width: 4
        type: uni
        default: ""
        direction: out
        conn_type: false
        index: -1
        netname: clkmgr_idle
      }
      {
        package: lc_ctrl_pkg
        struct: lc_tx
        domain: Main
        inter_pd: true
        signame: lc_ctrl_lc_dft_en_o
        signame_chip:
        {
          asic: lc_ctrl_lc_dft_en
          verilator: lc_ctrl_lc_dft_en
        }
        width: 1
        type: uni
        default: lc_ctrl_pkg::Off
        direction: out
        conn_type: true
        index: -1
        netname: lc_ctrl_lc_dft_en
      }
      {
        package: lc_ctrl_pkg
        struct: lc_tx
        domain: Aon
        inter_pd: true
        signame: lc_ctrl_lc_dft_en_i
        signame_chip:
        {
          asic: lc_ctrl_lc_dft_en
          verilator: lc_ctrl_lc_dft_en
        }
        width: 1
        type: uni
        default: lc_ctrl_pkg::Off
        direction: in
        conn_type: false
        index: -1
        netname: lc_ctrl_lc_dft_en
      }
      {
        package: lc_ctrl_pkg
        struct: lc_tx
        domain: Main
        inter_pd: true
        signame: lc_ctrl_lc_hw_debug_en_o
        signame_chip:
        {
          asic: lc_ctrl_lc_hw_debug_en
          verilator: lc_ctrl_lc_hw_debug_en
        }
        width: 1
        type: uni
        default: lc_ctrl_pkg::Off
        direction: out
        conn_type: true
        index: -1
        netname: lc_ctrl_lc_hw_debug_en
      }
      {
        package: lc_ctrl_pkg
        struct: lc_tx
        domain: Aon
        inter_pd: true
        signame: lc_ctrl_lc_hw_debug_en_i
        signame_chip:
        {
          asic: lc_ctrl_lc_hw_debug_en
          verilator: lc_ctrl_lc_hw_debug_en
        }
        width: 1
        type: uni
        default: lc_ctrl_pkg::Off
        direction: in
        conn_type: false
        index: -1
        netname: lc_ctrl_lc_hw_debug_en
      }
      {
        package: lc_ctrl_pkg
        struct: lc_tx
        domain: Main
        inter_pd: true
        signame: lc_ctrl_lc_escalate_en_o
        signame_chip:
        {
          asic: lc_ctrl_lc_escalate_en
          verilator: lc_ctrl_lc_escalate_en
        }
        width: 1
        type: uni
        default: lc_ctrl_pkg::Off
        direction: out
        conn_type: true
        index: -1
        netname: lc_ctrl_lc_escalate_en
      }
      {
        package: lc_ctrl_pkg
        struct: lc_tx
        domain: Aon
        inter_pd: true
        signame: lc_ctrl_lc_escalate_en_i
        signame_chip:
        {
          asic: lc_ctrl_lc_escalate_en
          verilator: lc_ctrl_lc_escalate_en
        }
        width: 1
        type: uni
        default: lc_ctrl_pkg::Off
        direction: in
        conn_type: false
        index: -1
        netname: lc_ctrl_lc_escalate_en
      }
      {
        package: rv_core_ibex_pkg
        struct: cpu_crash_dump
        domain: Main
        inter_pd: true
        signame: rv_core_ibex_crash_dump_o
        signame_chip:
        {
          asic: rv_core_ibex_crash_dump
          verilator: rv_core_ibex_crash_dump
        }
        width: 1
        type: uni
        default: ""
        direction: out
        conn_type: false
        index: -1
        netname: rv_core_ibex_crash_dump
      }
      {
        package: rv_core_ibex_pkg
        struct: cpu_crash_dump
        domain: Aon
        inter_pd: true
        signame: rv_core_ibex_crash_dump_i
        signame_chip:
        {
          asic: rv_core_ibex_crash_dump
          verilator: rv_core_ibex_crash_dump
        }
        width: 1
        type: uni
        default: ""
        direction: in
        conn_type: false
        index: -1
        netname: rv_core_ibex_crash_dump
      }
      {
        package: rv_core_ibex_pkg
        struct: cpu_pwrmgr
        domain: Main
        inter_pd: true
        signame: rv_core_ibex_pwrmgr_o
        signame_chip:
        {
          asic: rv_core_ibex_pwrmgr
          verilator: rv_core_ibex_pwrmgr
        }
        width: 1
        type: uni
        default: ""
        direction: out
        conn_type: false
        index: -1
        netname: rv_core_ibex_pwrmgr
      }
      {
        package: rv_core_ibex_pkg
        struct: cpu_pwrmgr
        domain: Aon
        inter_pd: true
        signame: rv_core_ibex_pwrmgr_i
        signame_chip:
        {
          asic: rv_core_ibex_pwrmgr
          verilator: rv_core_ibex_pwrmgr
        }
        width: 1
        type: uni
        default: ""
        direction: in
        conn_type: false
        index: -1
        netname: rv_core_ibex_pwrmgr
      }
      {
        package: ""
        struct: logic
        domain: Main
        inter_pd: true
        signame: rv_dm_ndmreset_req_o
        signame_chip:
        {
          asic: rv_dm_ndmreset_req
          verilator: rv_dm_ndmreset_req
        }
        width: 1
        type: uni
        default: ""
        direction: out
        conn_type: false
        index: -1
        netname: rv_dm_ndmreset_req
      }
      {
        package: ""
        struct: logic
        domain: Aon
        inter_pd: true
        signame: rv_dm_ndmreset_req_i
        signame_chip:
        {
          asic: rv_dm_ndmreset_req
          verilator: rv_dm_ndmreset_req
        }
        width: 1
        type: uni
        default: ""
        direction: in
        conn_type: false
        index: -1
        netname: rv_dm_ndmreset_req
      }
      {
        package: tlul_pkg
        struct: tl_h2d
        domain: Aon
        inter_pd: true
        signame: soc_proxy_dma_tl_h2d_i
        signame_chip:
        {
          asic: soc_proxy_dma_tl_h2d
          verilator: soc_proxy_dma_tl_h2d
        }
        width: 1
        type: uni
        default: ""
        direction: in
        conn_type: false
        index: -1
        netname: soc_proxy_dma_tl_h2d
      }
      {
        package: tlul_pkg
        struct: tl_h2d
        domain: Main
        inter_pd: true
        signame: soc_proxy_dma_tl_h2d_o
        signame_chip:
        {
          asic: soc_proxy_dma_tl_h2d
          verilator: soc_proxy_dma_tl_h2d
        }
        width: 1
        type: uni
        default: ""
        direction: out
        conn_type: false
        index: -1
        netname: soc_proxy_dma_tl_h2d
      }
      {
        package: tlul_pkg
        struct: tl_d2h
        domain: Aon
        inter_pd: true
        signame: soc_proxy_dma_tl_d2h_o
        signame_chip:
        {
          asic: soc_proxy_dma_tl_d2h
          verilator: soc_proxy_dma_tl_d2h
        }
        width: 1
        type: uni
        default: ""
        direction: out
        conn_type: false
        index: -1
        netname: soc_proxy_dma_tl_d2h
      }
      {
        package: tlul_pkg
        struct: tl_d2h
        domain: Main
        inter_pd: true
        signame: soc_proxy_dma_tl_d2h_i
        signame_chip:
        {
          asic: soc_proxy_dma_tl_d2h
          verilator: soc_proxy_dma_tl_d2h
        }
        width: 1
        type: uni
        default: ""
        direction: in
        conn_type: false
        index: -1
        netname: soc_proxy_dma_tl_d2h
      }
      {
        package: tlul_pkg
        struct: tl_h2d
        domain: Aon
        inter_pd: true
        signame: soc_proxy_ctn_tl_h2d_o
        signame_chip:
        {
          asic: soc_proxy_ctn_tl_h2d
          verilator: soc_proxy_ctn_tl_h2d
        }
        width: 1
        type: uni
        default: ""
        direction: out
        conn_type: false
        index: -1
        netname: soc_proxy_ctn_tl_h2d
      }
      {
        package: tlul_pkg
        struct: tl_h2d
        domain: Main
        inter_pd: true
        signame: soc_proxy_ctn_tl_h2d_i
        signame_chip:
        {
          asic: soc_proxy_ctn_tl_h2d
          verilator: soc_proxy_ctn_tl_h2d
        }
        width: 1
        type: uni
        default: ""
        direction: in
        conn_type: false
        index: -1
        netname: soc_proxy_ctn_tl_h2d
      }
      {
        package: tlul_pkg
        struct: tl_d2h
        domain: Aon
        inter_pd: true
        signame: soc_proxy_ctn_tl_d2h_i
        signame_chip:
        {
          asic: soc_proxy_ctn_tl_d2h
          verilator: soc_proxy_ctn_tl_d2h
        }
        width: 1
        type: uni
        default: ""
        direction: in
        conn_type: false
        index: -1
        netname: soc_proxy_ctn_tl_d2h
      }
      {
        package: tlul_pkg
        struct: tl_d2h
        domain: Main
        inter_pd: true
        signame: soc_proxy_ctn_tl_d2h_o
        signame_chip:
        {
          asic: soc_proxy_ctn_tl_d2h
          verilator: soc_proxy_ctn_tl_d2h
        }
        width: 1
        type: uni
        default: ""
        direction: out
        conn_type: false
        index: -1
        netname: soc_proxy_ctn_tl_d2h
      }
      {
        package: ""
        struct: logic
        domain: Aon
        inter_pd: true
        signame: pwrmgr_wakeups_i
        signame_chip:
        {
          asic: pwrmgr_wakeups
          verilator: pwrmgr_wakeups
        }
        width: 1
        type: uni
        default: ""
        direction: in
        conn_type: true
        index: 0
        netname: pwrmgr_wakeups
      }
      {
        package: ""
        struct: logic
        domain: Main
        inter_pd: true
        signame: pwrmgr_wakeups_o
        signame_chip:
        {
          asic: pwrmgr_wakeups
          verilator: pwrmgr_wakeups
        }
        width: 1
        type: uni
        default: ""
        direction: out
        conn_type: false
        index: 0
        netname: pwrmgr_wakeups
      }
      {
        package: tlul_pkg
        struct: tl_h2d
        domain: Aon
        inter_pd: true
        signame: soc_proxy_core_tl_req_i
        signame_chip:
        {
          asic: soc_proxy_core_tl_req
          verilator: soc_proxy_core_tl_req
        }
        width: 1
        type: req_rsp
        default: ""
        direction: in
        conn_type: false
        index: -1
        netname: soc_proxy_core_tl_h2d
      }
      {
        package: tlul_pkg
        struct: tl_d2h
        domain: Aon
        inter_pd: true
        signame: soc_proxy_core_tl_rsp_o
        signame_chip:
        {
          asic: soc_proxy_core_tl_rsp
          verilator: soc_proxy_core_tl_rsp
        }
        width: 1
        type: req_rsp
        default: ""
        direction: out
        conn_type: false
        index: -1
        netname: soc_proxy_core_tl_d2h
      }
      {
        package: tlul_pkg
        struct: tl_h2d
        domain: Main
        inter_pd: true
        signame: soc_proxy_core_tl_req_o
        signame_chip:
        {
          asic: soc_proxy_core_tl_req
          verilator: soc_proxy_core_tl_req
        }
        width: 1
        type: req_rsp
        default: ""
        direction: out
        conn_type: false
        index: -1
        netname: soc_proxy_core_tl_h2d
      }
      {
        package: tlul_pkg
        struct: tl_d2h
        domain: Main
        inter_pd: true
        signame: soc_proxy_core_tl_rsp_i
        signame_chip:
        {
          asic: soc_proxy_core_tl_rsp
          verilator: soc_proxy_core_tl_rsp
        }
        width: 1
        type: req_rsp
        default: ""
        direction: in
        conn_type: false
        index: -1
        netname: soc_proxy_core_tl_d2h
      }
      {
        package: tlul_pkg
        struct: tl_h2d
        domain: Aon
        inter_pd: true
        signame: soc_proxy_ctn_tl_req_i
        signame_chip:
        {
          asic: soc_proxy_ctn_tl_req
          verilator: soc_proxy_ctn_tl_req
        }
        width: 1
        type: req_rsp
        default: ""
        direction: in
        conn_type: false
        index: -1
        netname: soc_proxy_ctn_tl_h2d
      }
      {
        package: tlul_pkg
        struct: tl_d2h
        domain: Aon
        inter_pd: true
        signame: soc_proxy_ctn_tl_rsp_o
        signame_chip:
        {
          asic: soc_proxy_ctn_tl_rsp
          verilator: soc_proxy_ctn_tl_rsp
        }
        width: 1
        type: req_rsp
        default: ""
        direction: out
        conn_type: false
        index: -1
        netname: soc_proxy_ctn_tl_d2h
      }
      {
        package: tlul_pkg
        struct: tl_h2d
        domain: Main
        inter_pd: true
        signame: soc_proxy_ctn_tl_req_o
        signame_chip:
        {
          asic: soc_proxy_ctn_tl_req
          verilator: soc_proxy_ctn_tl_req
        }
        width: 1
        type: req_rsp
        default: ""
        direction: out
        conn_type: false
        index: -1
        netname: soc_proxy_ctn_tl_h2d
      }
      {
        package: tlul_pkg
        struct: tl_d2h
        domain: Main
        inter_pd: true
        signame: soc_proxy_ctn_tl_rsp_i
        signame_chip:
        {
          asic: soc_proxy_ctn_tl_rsp
          verilator: soc_proxy_ctn_tl_rsp
        }
        width: 1
        type: req_rsp
        default: ""
        direction: in
        conn_type: false
        index: -1
        netname: soc_proxy_ctn_tl_d2h
      }
      {
        package: tlul_pkg
        struct: tl_h2d
        domain: Aon
        inter_pd: true
        signame: pwrmgr_tl_req_i
        signame_chip:
        {
          asic: pwrmgr_tl_req
          verilator: pwrmgr_tl_req
        }
        width: 1
        type: req_rsp
        default: ""
        direction: in
        conn_type: false
        index: -1
        netname: pwrmgr_tl_h2d
      }
      {
        package: tlul_pkg
        struct: tl_d2h
        domain: Aon
        inter_pd: true
        signame: pwrmgr_tl_rsp_o
        signame_chip:
        {
          asic: pwrmgr_tl_rsp
          verilator: pwrmgr_tl_rsp
        }
        width: 1
        type: req_rsp
        default: ""
        direction: out
        conn_type: false
        index: -1
        netname: pwrmgr_tl_d2h
      }
      {
        package: tlul_pkg
        struct: tl_h2d
        domain: Main
        inter_pd: true
        signame: pwrmgr_tl_req_o
        signame_chip:
        {
          asic: pwrmgr_tl_req
          verilator: pwrmgr_tl_req
        }
        width: 1
        type: req_rsp
        default: ""
        direction: out
        conn_type: false
        index: -1
        netname: pwrmgr_tl_h2d
      }
      {
        package: tlul_pkg
        struct: tl_d2h
        domain: Main
        inter_pd: true
        signame: pwrmgr_tl_rsp_i
        signame_chip:
        {
          asic: pwrmgr_tl_rsp
          verilator: pwrmgr_tl_rsp
        }
        width: 1
        type: req_rsp
        default: ""
        direction: in
        conn_type: false
        index: -1
        netname: pwrmgr_tl_d2h
      }
      {
        package: tlul_pkg
        struct: tl_h2d
        domain: Aon
        inter_pd: true
        signame: rstmgr_tl_req_i
        signame_chip:
        {
          asic: rstmgr_tl_req
          verilator: rstmgr_tl_req
        }
        width: 1
        type: req_rsp
        default: ""
        direction: in
        conn_type: false
        index: -1
        netname: rstmgr_tl_h2d
      }
      {
        package: tlul_pkg
        struct: tl_d2h
        domain: Aon
        inter_pd: true
        signame: rstmgr_tl_rsp_o
        signame_chip:
        {
          asic: rstmgr_tl_rsp
          verilator: rstmgr_tl_rsp
        }
        width: 1
        type: req_rsp
        default: ""
        direction: out
        conn_type: false
        index: -1
        netname: rstmgr_tl_d2h
      }
      {
        package: tlul_pkg
        struct: tl_h2d
        domain: Main
        inter_pd: true
        signame: rstmgr_tl_req_o
        signame_chip:
        {
          asic: rstmgr_tl_req
          verilator: rstmgr_tl_req
        }
        width: 1
        type: req_rsp
        default: ""
        direction: out
        conn_type: false
        index: -1
        netname: rstmgr_tl_h2d
      }
      {
        package: tlul_pkg
        struct: tl_d2h
        domain: Main
        inter_pd: true
        signame: rstmgr_tl_rsp_i
        signame_chip:
        {
          asic: rstmgr_tl_rsp
          verilator: rstmgr_tl_rsp
        }
        width: 1
        type: req_rsp
        default: ""
        direction: in
        conn_type: false
        index: -1
        netname: rstmgr_tl_d2h
      }
      {
        package: tlul_pkg
        struct: tl_h2d
        domain: Aon
        inter_pd: true
        signame: clkmgr_tl_req_i
        signame_chip:
        {
          asic: clkmgr_tl_req
          verilator: clkmgr_tl_req
        }
        width: 1
        type: req_rsp
        default: ""
        direction: in
        conn_type: false
        index: -1
        netname: clkmgr_tl_h2d
      }
      {
        package: tlul_pkg
        struct: tl_d2h
        domain: Aon
        inter_pd: true
        signame: clkmgr_tl_rsp_o
        signame_chip:
        {
          asic: clkmgr_tl_rsp
          verilator: clkmgr_tl_rsp
        }
        width: 1
        type: req_rsp
        default: ""
        direction: out
        conn_type: false
        index: -1
        netname: clkmgr_tl_d2h
      }
      {
        package: tlul_pkg
        struct: tl_h2d
        domain: Main
        inter_pd: true
        signame: clkmgr_tl_req_o
        signame_chip:
        {
          asic: clkmgr_tl_req
          verilator: clkmgr_tl_req
        }
        width: 1
        type: req_rsp
        default: ""
        direction: out
        conn_type: false
        index: -1
        netname: clkmgr_tl_h2d
      }
      {
        package: tlul_pkg
        struct: tl_d2h
        domain: Main
        inter_pd: true
        signame: clkmgr_tl_rsp_i
        signame_chip:
        {
          asic: clkmgr_tl_rsp
          verilator: clkmgr_tl_rsp
        }
        width: 1
        type: req_rsp
        default: ""
        direction: in
        conn_type: false
        index: -1
        netname: clkmgr_tl_d2h
      }
      {
        package: tlul_pkg
        struct: tl_h2d
        domain: Aon
        inter_pd: true
        signame: sram_ctrl_ret_regs_tl_req_i
        signame_chip:
        {
          asic: sram_ctrl_ret_regs_tl_req
          verilator: sram_ctrl_ret_regs_tl_req
        }
        width: 1
        type: req_rsp
        default: ""
        direction: in
        conn_type: false
        index: -1
        netname: sram_ctrl_ret_regs_tl_h2d
      }
      {
        package: tlul_pkg
        struct: tl_d2h
        domain: Aon
        inter_pd: true
        signame: sram_ctrl_ret_regs_tl_rsp_o
        signame_chip:
        {
          asic: sram_ctrl_ret_regs_tl_rsp
          verilator: sram_ctrl_ret_regs_tl_rsp
        }
        width: 1
        type: req_rsp
        default: ""
        direction: out
        conn_type: false
        index: -1
        netname: sram_ctrl_ret_regs_tl_d2h
      }
      {
        package: tlul_pkg
        struct: tl_h2d
        domain: Main
        inter_pd: true
        signame: sram_ctrl_ret_regs_tl_req_o
        signame_chip:
        {
          asic: sram_ctrl_ret_regs_tl_req
          verilator: sram_ctrl_ret_regs_tl_req
        }
        width: 1
        type: req_rsp
        default: ""
        direction: out
        conn_type: false
        index: -1
        netname: sram_ctrl_ret_regs_tl_h2d
      }
      {
        package: tlul_pkg
        struct: tl_d2h
        domain: Main
        inter_pd: true
        signame: sram_ctrl_ret_regs_tl_rsp_i
        signame_chip:
        {
          asic: sram_ctrl_ret_regs_tl_rsp
          verilator: sram_ctrl_ret_regs_tl_rsp
        }
        width: 1
        type: req_rsp
        default: ""
        direction: in
        conn_type: false
        index: -1
        netname: sram_ctrl_ret_regs_tl_d2h
      }
      {
        package: tlul_pkg
        struct: tl_h2d
        domain: Aon
        inter_pd: true
        signame: sram_ctrl_ret_ram_tl_req_i
        signame_chip:
        {
          asic: sram_ctrl_ret_ram_tl_req
          verilator: sram_ctrl_ret_ram_tl_req
        }
        width: 1
        type: req_rsp
        default: ""
        direction: in
        conn_type: false
        index: -1
        netname: sram_ctrl_ret_ram_tl_h2d
      }
      {
        package: tlul_pkg
        struct: tl_d2h
        domain: Aon
        inter_pd: true
        signame: sram_ctrl_ret_ram_tl_rsp_o
        signame_chip:
        {
          asic: sram_ctrl_ret_ram_tl_rsp
          verilator: sram_ctrl_ret_ram_tl_rsp
        }
        width: 1
        type: req_rsp
        default: ""
        direction: out
        conn_type: false
        index: -1
        netname: sram_ctrl_ret_ram_tl_d2h
      }
      {
        package: tlul_pkg
        struct: tl_h2d
        domain: Main
        inter_pd: true
        signame: sram_ctrl_ret_ram_tl_req_o
        signame_chip:
        {
          asic: sram_ctrl_ret_ram_tl_req
          verilator: sram_ctrl_ret_ram_tl_req
        }
        width: 1
        type: req_rsp
        default: ""
        direction: out
        conn_type: false
        index: -1
        netname: sram_ctrl_ret_ram_tl_h2d
      }
      {
        package: tlul_pkg
        struct: tl_d2h
        domain: Main
        inter_pd: true
        signame: sram_ctrl_ret_ram_tl_rsp_i
        signame_chip:
        {
          asic: sram_ctrl_ret_ram_tl_rsp
          verilator: sram_ctrl_ret_ram_tl_rsp
        }
        width: 1
        type: req_rsp
        default: ""
        direction: in
        conn_type: false
        index: -1
        netname: sram_ctrl_ret_ram_tl_d2h
      }
      {
        package: tlul_pkg
        struct: tl_h2d
        domain: Aon
        inter_pd: true
        signame: aon_timer_tl_req_i
        signame_chip:
        {
          asic: aon_timer_tl_req
          verilator: aon_timer_tl_req
        }
        width: 1
        type: req_rsp
        default: ""
        direction: in
        conn_type: false
        index: -1
        netname: aon_timer_tl_h2d
      }
      {
        package: tlul_pkg
        struct: tl_d2h
        domain: Aon
        inter_pd: true
        signame: aon_timer_tl_rsp_o
        signame_chip:
        {
          asic: aon_timer_tl_rsp
          verilator: aon_timer_tl_rsp
        }
        width: 1
        type: req_rsp
        default: ""
        direction: out
        conn_type: false
        index: -1
        netname: aon_timer_tl_d2h
      }
      {
        package: tlul_pkg
        struct: tl_h2d
        domain: Main
        inter_pd: true
        signame: aon_timer_tl_req_o
        signame_chip:
        {
          asic: aon_timer_tl_req
          verilator: aon_timer_tl_req
        }
        width: 1
        type: req_rsp
        default: ""
        direction: out
        conn_type: false
        index: -1
        netname: aon_timer_tl_h2d
      }
      {
        package: tlul_pkg
        struct: tl_d2h
        domain: Main
        inter_pd: true
        signame: aon_timer_tl_rsp_i
        signame_chip:
        {
          asic: aon_timer_tl_rsp
          verilator: aon_timer_tl_rsp
        }
        width: 1
        type: req_rsp
        default: ""
        direction: in
        conn_type: false
        index: -1
        netname: aon_timer_tl_d2h
      }
      {
        package: lc_ctrl_pkg
        struct: lc_tx
        domain: Main
        inter_pd: false
        signame: ast_lc_dft_en_o
        signame_chip:
        {
          asic: lc_dft_en
          verilator: lc_dft_en
        }
        width: 1
        type: uni
        default: ""
        direction: out
        conn_type: true
        index: -1
        netname: lc_ctrl_lc_dft_en
      }
      {
        package: lc_ctrl_pkg
        struct: lc_tx
        domain: Main
        inter_pd: false
        signame: ast_lc_hw_debug_en_o
        signame_chip:
        {
          asic: ""
          verilator: ""
        }
        width: 1
        type: uni
        default: ""
        direction: out
        conn_type: true
        index: -1
        netname: lc_ctrl_lc_hw_debug_en
      }
      {
        package: ast_pkg
        struct: ast_obs_ctrl
        domain: Main
        inter_pd: false
        signame: obs_ctrl_i
        signame_chip:
        {
          asic: obs_ctrl
          verilator: obs_ctrl
        }
        width: 1
        type: uni
        default: ""
        direction: in
        conn_type: true
        index: -1
        netname: ast_obs_ctrl
      }
      {
        package: prim_ram_1p_pkg
        struct: ram_1p_cfg_req
        domain: Main
        inter_pd: false
        signame: otbn_imem_ram_cfg_req_i
        signame_chip:
        {
          asic: otbn_imem_ram_cfg_req
          verilator: otbn_imem_ram_cfg_req
        }
        width: 1
        type: req_rsp
        default: ""
        direction: in
        conn_type: false
        index: -1
        netname: otbn_imem_ram_cfg_req
      }
      {
        package: prim_ram_1p_pkg
        struct: ram_1p_cfg_rsp
        domain: Main
        inter_pd: false
        signame: otbn_imem_ram_cfg_rsp_o
        signame_chip:
        {
          asic: otbn_imem_ram_cfg_rsp
          verilator: otbn_imem_ram_cfg_rsp
        }
        width: 1
        type: req_rsp
        default: ""
        direction: out
        conn_type: false
        index: -1
        netname: otbn_imem_ram_cfg_rsp
      }
      {
        package: prim_ram_1p_pkg
        struct: ram_1p_cfg_req
        domain: Main
        inter_pd: false
        signame: otbn_dmem_ram_cfg_req_i
        signame_chip:
        {
          asic: otbn_dmem_ram_cfg_req
          verilator: otbn_dmem_ram_cfg_req
        }
        width: 1
        type: req_rsp
        default: ""
        direction: in
        conn_type: false
        index: -1
        netname: otbn_dmem_ram_cfg_req
      }
      {
        package: prim_ram_1p_pkg
        struct: ram_1p_cfg_rsp
        domain: Main
        inter_pd: false
        signame: otbn_dmem_ram_cfg_rsp_o
        signame_chip:
        {
          asic: otbn_dmem_ram_cfg_rsp
          verilator: otbn_dmem_ram_cfg_rsp
        }
        width: 1
        type: req_rsp
        default: ""
        direction: out
        conn_type: false
        index: -1
        netname: otbn_dmem_ram_cfg_rsp
      }
      {
        package: prim_ram_1p_pkg
        struct: ram_1p_cfg_req
        domain: Main
        inter_pd: false
        signame: i2c0_ram_cfg_req_i
        signame_chip:
        {
          asic: i2c0_ram_cfg_req
          verilator: i2c0_ram_cfg_req
        }
        width: 1
        type: req_rsp
        default: ""
        direction: in
        conn_type: false
        index: -1
        netname: i2c0_ram_cfg_req
      }
      {
        package: prim_ram_1p_pkg
        struct: ram_1p_cfg_rsp
        domain: Main
        inter_pd: false
        signame: i2c0_ram_cfg_rsp_o
        signame_chip:
        {
          asic: i2c0_ram_cfg_rsp
          verilator: i2c0_ram_cfg_rsp
        }
        width: 1
        type: req_rsp
        default: ""
        direction: out
        conn_type: false
        index: -1
        netname: i2c0_ram_cfg_rsp
      }
      {
        package: prim_ram_1p_pkg
        struct: ram_1p_cfg_req
        domain: Main
        inter_pd: false
        signame: rv_core_ibex_icache_tag_ram_cfg_req_i
        signame_chip:
        {
          asic: rv_core_ibex_icache_tag_ram_cfg_req
          verilator: rv_core_ibex_icache_tag_ram_cfg_req
        }
        width:
        {
          name: ICacheNWays
          desc: Number of instruction cache ways
          param_type: int unsigned
          unpacked_dimensions: null
          default: 2
          local: false
          expose: true
          name_top: RvCoreIbexICacheNWays
        }
        type: req_rsp
        default: ""
        direction: in
        conn_type: false
        index: -1
        netname: rv_core_ibex_icache_tag_ram_cfg_req
      }
      {
        package: prim_ram_1p_pkg
        struct: ram_1p_cfg_rsp
        domain: Main
        inter_pd: false
        signame: rv_core_ibex_icache_tag_ram_cfg_rsp_o
        signame_chip:
        {
          asic: rv_core_ibex_icache_tag_ram_cfg_rsp
          verilator: rv_core_ibex_icache_tag_ram_cfg_rsp
        }
        width:
        {
          name: ICacheNWays
          desc: Number of instruction cache ways
          param_type: int unsigned
          unpacked_dimensions: null
          default: 2
          local: false
          expose: true
          name_top: RvCoreIbexICacheNWays
        }
        type: req_rsp
        default: ""
        direction: out
        conn_type: false
        index: -1
        netname: rv_core_ibex_icache_tag_ram_cfg_rsp
      }
      {
        package: prim_ram_1p_pkg
        struct: ram_1p_cfg_req
        domain: Main
        inter_pd: false
        signame: rv_core_ibex_icache_data_ram_cfg_req_i
        signame_chip:
        {
          asic: rv_core_ibex_icache_data_ram_cfg_req
          verilator: rv_core_ibex_icache_data_ram_cfg_req
        }
        width:
        {
          name: ICacheNWays
          desc: Number of instruction cache ways
          param_type: int unsigned
          unpacked_dimensions: null
          default: 2
          local: false
          expose: true
          name_top: RvCoreIbexICacheNWays
        }
        type: req_rsp
        default: ""
        direction: in
        conn_type: false
        index: -1
        netname: rv_core_ibex_icache_data_ram_cfg_req
      }
      {
        package: prim_ram_1p_pkg
        struct: ram_1p_cfg_rsp
        domain: Main
        inter_pd: false
        signame: rv_core_ibex_icache_data_ram_cfg_rsp_o
        signame_chip:
        {
          asic: rv_core_ibex_icache_data_ram_cfg_rsp
          verilator: rv_core_ibex_icache_data_ram_cfg_rsp
        }
        width:
        {
          name: ICacheNWays
          desc: Number of instruction cache ways
          param_type: int unsigned
          unpacked_dimensions: null
          default: 2
          local: false
          expose: true
          name_top: RvCoreIbexICacheNWays
        }
        type: req_rsp
        default: ""
        direction: out
        conn_type: false
        index: -1
        netname: rv_core_ibex_icache_data_ram_cfg_rsp
      }
      {
        package: prim_ram_1r1w_pkg
        struct: ram_1r1w_cfg_req
        domain: Main
        inter_pd: false
        signame: spi_device_sys2spi_ram_cfg_req_i
        signame_chip:
        {
          asic: spi_device_sys2spi_ram_cfg_req
          verilator: spi_device_sys2spi_ram_cfg_req
        }
        width: 1
        type: req_rsp
        default: ""
        direction: in
        conn_type: false
        index: -1
        netname: spi_device_sys2spi_ram_cfg_req
      }
      {
        package: prim_ram_1r1w_pkg
        struct: ram_1r1w_cfg_rsp
        domain: Main
        inter_pd: false
        signame: spi_device_sys2spi_ram_cfg_rsp_o
        signame_chip:
        {
          asic: spi_device_sys2spi_ram_cfg_rsp
          verilator: spi_device_sys2spi_ram_cfg_rsp
        }
        width: 1
        type: req_rsp
        default: ""
        direction: out
        conn_type: false
        index: -1
        netname: spi_device_sys2spi_ram_cfg_rsp
      }
      {
        package: prim_ram_1r1w_pkg
        struct: ram_1r1w_cfg_req
        domain: Main
        inter_pd: false
        signame: spi_device_spi2sys_ram_cfg_req_i
        signame_chip:
        {
          asic: spi_device_spi2sys_ram_cfg_req
          verilator: spi_device_spi2sys_ram_cfg_req
        }
        width: 1
        type: req_rsp
        default: ""
        direction: in
        conn_type: false
        index: -1
        netname: spi_device_spi2sys_ram_cfg_req
      }
      {
        package: prim_ram_1r1w_pkg
        struct: ram_1r1w_cfg_rsp
        domain: Main
        inter_pd: false
        signame: spi_device_spi2sys_ram_cfg_rsp_o
        signame_chip:
        {
          asic: spi_device_spi2sys_ram_cfg_rsp
          verilator: spi_device_spi2sys_ram_cfg_rsp
        }
        width: 1
        type: req_rsp
        default: ""
        direction: out
        conn_type: false
        index: -1
        netname: spi_device_spi2sys_ram_cfg_rsp
      }
      {
        package: prim_rom_pkg
        struct: rom_cfg_req
        domain: Main
        inter_pd: false
        signame: rom_ctrl0_rom_cfg_req_i
        signame_chip:
        {
          asic: rom_ctrl0_rom_cfg_req
          verilator: rom_ctrl0_rom_cfg_req
        }
        width: 1
        type: req_rsp
        default: ""
        direction: in
        conn_type: false
        index: -1
        netname: rom_ctrl0_rom_cfg_req
      }
      {
        package: prim_rom_pkg
        struct: rom_cfg_rsp
        domain: Main
        inter_pd: false
        signame: rom_ctrl0_rom_cfg_rsp_o
        signame_chip:
        {
          asic: rom_ctrl0_rom_cfg_rsp
          verilator: rom_ctrl0_rom_cfg_rsp
        }
        width: 1
        type: req_rsp
        default: ""
        direction: out
        conn_type: false
        index: -1
        netname: rom_ctrl0_rom_cfg_rsp
      }
      {
        package: prim_rom_pkg
        struct: rom_cfg_req
        domain: Main
        inter_pd: false
        signame: rom_ctrl1_rom_cfg_req_i
        signame_chip:
        {
          asic: rom_ctrl1_rom_cfg_req
          verilator: rom_ctrl1_rom_cfg_req
        }
        width: 1
        type: req_rsp
        default: ""
        direction: in
        conn_type: false
        index: -1
        netname: rom_ctrl1_rom_cfg_req
      }
      {
        package: prim_rom_pkg
        struct: rom_cfg_rsp
        domain: Main
        inter_pd: false
        signame: rom_ctrl1_rom_cfg_rsp_o
        signame_chip:
        {
          asic: rom_ctrl1_rom_cfg_rsp
          verilator: rom_ctrl1_rom_cfg_rsp
        }
        width: 1
        type: req_rsp
        default: ""
        direction: out
        conn_type: false
        index: -1
        netname: rom_ctrl1_rom_cfg_rsp
      }
      {
        package: prim_ram_1p_pkg
        struct: ram_1p_cfg_req
        domain: Main
        inter_pd: false
        signame: sram_ctrl_main_ram_cfg_req_i
        signame_chip:
        {
          asic: sram_ctrl_main_ram_cfg_req
          verilator: sram_ctrl_main_ram_cfg_req
        }
        width:
        {
          name: NumRamInst
          desc: Number of internal RAM instances. Must be the same as ceil(MemSizeRam / InstSize) .
          param_type: int
          unpacked_dimensions: null
          default: 1
          local: false
          expose: true
          name_top: SramCtrlMainNumRamInst
        }
        type: req_rsp
        default: ""
        direction: in
        conn_type: false
        index: -1
        netname: sram_ctrl_main_ram_cfg_req
      }
      {
        package: prim_ram_1p_pkg
        struct: ram_1p_cfg_rsp
        domain: Main
        inter_pd: false
        signame: sram_ctrl_main_ram_cfg_rsp_o
        signame_chip:
        {
          asic: sram_ctrl_main_ram_cfg_rsp
          verilator: sram_ctrl_main_ram_cfg_rsp
        }
        width:
        {
          name: NumRamInst
          desc: Number of internal RAM instances. Must be the same as ceil(MemSizeRam / InstSize) .
          param_type: int
          unpacked_dimensions: null
          default: 1
          local: false
          expose: true
          name_top: SramCtrlMainNumRamInst
        }
        type: req_rsp
        default: ""
        direction: out
        conn_type: false
        index: -1
        netname: sram_ctrl_main_ram_cfg_rsp
      }
      {
        package: prim_ram_1p_pkg
        struct: ram_1p_cfg_req
        domain: Aon
        inter_pd: false
        signame: sram_ctrl_ret_ram_cfg_req_i
        signame_chip:
        {
          asic: sram_ctrl_ret_ram_cfg_req
          verilator: sram_ctrl_ret_ram_cfg_req
        }
        width:
        {
          name: NumRamInst
          desc: Number of internal RAM instances. Must be the same as ceil(MemSizeRam / InstSize) .
          param_type: int
          unpacked_dimensions: null
          default: 1
          local: false
          expose: true
          name_top: SramCtrlRetNumRamInst
        }
        type: req_rsp
        default: ""
        direction: in
        conn_type: false
        index: -1
        netname: sram_ctrl_ret_ram_cfg_req
      }
      {
        package: prim_ram_1p_pkg
        struct: ram_1p_cfg_rsp
        domain: Aon
        inter_pd: false
        signame: sram_ctrl_ret_ram_cfg_rsp_o
        signame_chip:
        {
          asic: sram_ctrl_ret_ram_cfg_rsp
          verilator: sram_ctrl_ret_ram_cfg_rsp
        }
        width:
        {
          name: NumRamInst
          desc: Number of internal RAM instances. Must be the same as ceil(MemSizeRam / InstSize) .
          param_type: int
          unpacked_dimensions: null
          default: 1
          local: false
          expose: true
          name_top: SramCtrlRetNumRamInst
        }
        type: req_rsp
        default: ""
        direction: out
        conn_type: false
        index: -1
        netname: sram_ctrl_ret_ram_cfg_rsp
      }
      {
        package: prim_ram_1p_pkg
        struct: ram_1p_cfg_req
        domain: Main
        inter_pd: false
        signame: sram_ctrl_mbox_ram_cfg_req_i
        signame_chip:
        {
          asic: sram_ctrl_mbox_ram_cfg_req
          verilator: sram_ctrl_mbox_ram_cfg_req
        }
        width:
        {
          name: NumRamInst
          desc: Number of internal RAM instances. Must be the same as ceil(MemSizeRam / InstSize) .
          param_type: int
          unpacked_dimensions: null
          default: 1
          local: false
          expose: true
          name_top: SramCtrlMboxNumRamInst
        }
        type: req_rsp
        default: ""
        direction: in
        conn_type: false
        index: -1
        netname: sram_ctrl_mbox_ram_cfg_req
      }
      {
        package: prim_ram_1p_pkg
        struct: ram_1p_cfg_rsp
        domain: Main
        inter_pd: false
        signame: sram_ctrl_mbox_ram_cfg_rsp_o
        signame_chip:
        {
          asic: sram_ctrl_mbox_ram_cfg_rsp
          verilator: sram_ctrl_mbox_ram_cfg_rsp
        }
        width:
        {
          name: NumRamInst
          desc: Number of internal RAM instances. Must be the same as ceil(MemSizeRam / InstSize) .
          param_type: int
          unpacked_dimensions: null
          default: 1
          local: false
          expose: true
          name_top: SramCtrlMboxNumRamInst
        }
        type: req_rsp
        default: ""
        direction: out
        conn_type: false
        index: -1
        netname: sram_ctrl_mbox_ram_cfg_rsp
      }
      {
        package: pwrmgr_pkg
        struct: pwr_boot_status
        domain: Aon
        inter_pd: false
        signame: pwrmgr_boot_status_obs_o
        signame_chip:
        {
          asic: pwrmgr_boot_status
          verilator: pwrmgr_boot_status
        }
        width: 1
        type: uni
        default: ""
        direction: out
        conn_type: true
        index: -1
        netname: pwrmgr_boot_status
      }
      {
        package: ""
        struct: logic
        domain: Aon
        inter_pd: false
        signame: pwrmgr_ext_rst_ack_i
        signame_chip:
        {
          asic: 1'b0
          verilator: 1'b0
        }
        width: 1
        type: uni
        default: ""
        direction: in
        conn_type: false
        index: -1
        netname: pwrmgr_ext_rst_ack
      }
      {
        package: clkmgr_pkg
        struct: clkmgr_out
        domain: Aon
        inter_pd: false
        signame: clkmgr_clocks_o
        signame_chip:
        {
          asic: clkmgr_clocks
          verilator: clkmgr_clocks
        }
        width: 1
        type: uni
        default: ""
        direction: out
        conn_type: true
        index: -1
        netname: clkmgr_clocks
      }
      {
        package: clkmgr_pkg
        struct: clkmgr_cg_en
        domain: Aon
        inter_pd: false
        signame: clkmgr_cg_en_o
        signame_chip:
        {
          asic: ""
          verilator: ""
        }
        width: 1
        type: uni
        default: ""
        direction: out
        conn_type: true
        index: -1
        netname: clkmgr_cg_en
      }
      {
        package: prim_mubi_pkg
        struct: mubi4
        domain: Aon
        inter_pd: false
        signame: clk_main_jitter_en_o
        signame_chip:
        {
          asic: clk_main_jitter_en
          verilator: clk_main_jitter_en
        }
        width: 1
        type: uni
        default: ""
        direction: out
        conn_type: false
        index: -1
        netname: clk_main_jitter_en
      }
      {
        package: dma_pkg
        struct: sys_req
        domain: Main
        inter_pd: false
        signame: dma_sys_req_o
        signame_chip:
        {
          asic: ""
          verilator: ""
        }
        width: 1
        type: req_rsp
        default: ""
        direction: out
        conn_type: false
        index: -1
        netname: dma_sys_req
      }
      {
        package: dma_pkg
        struct: sys_rsp
        domain: Main
        inter_pd: false
        signame: dma_sys_rsp_i
        signame_chip:
        {
          asic: dma_pkg::SYS_RSP_DEFAULT
          verilator: dma_pkg::SYS_RSP_DEFAULT
        }
        width: 1
        type: req_rsp
        default: ""
        direction: in
        conn_type: false
        index: -1
        netname: dma_sys_rsp
      }
      {
        package: ""
        struct: logic
        domain: Main
        inter_pd: false
        signame: es_rng_enable_o
        signame_chip:
        {
          asic: es_rng_enable
          verilator: es_rng_enable
        }
        width: 1
        type: uni
        default: ""
        direction: out
        conn_type: false
        index: -1
        netname: es_rng_enable
      }
      {
        package: ""
        struct: logic
        domain: Main
        inter_pd: false
        signame: es_rng_valid_i
        signame_chip:
        {
          asic: es_rng_valid
          verilator: es_rng_valid
        }
        width: 1
        type: uni
        default: ""
        direction: in
        conn_type: false
        index: -1
        netname: es_rng_valid
      }
      {
        package: ""
        struct: logic
        domain: Main
        inter_pd: false
        signame: es_rng_bit_i
        signame_chip:
        {
          asic: es_rng_bit
          verilator: es_rng_bit
        }
        width:
        {
          name: RngBusWidth
          desc:
            '''
            Defines the bit-width of the noise source data.
            Must be between 4 and 256 (inclusive) and divisible by 4.
            The divisibility by 4 is a prerequisite for the bucket health test.
            '''
          param_type: int
          unpacked_dimensions: null
          default: 4
          local: false
          expose: true
          name_top: EntropySrcRngBusWidth
        }
        type: uni
        default: ""
        direction: in
        conn_type: false
        index: -1
        netname: es_rng_bit
      }
      {
        package: ""
        struct: logic
        domain: Main
        inter_pd: false
        signame: es_rng_fips_o
        signame_chip:
        {
          asic: es_rng_fips
          verilator: es_rng_fips
        }
        width: 1
        type: uni
        default: ""
        direction: out
        conn_type: false
        index: -1
        netname: es_rng_fips
      }
      {
        package: tlul_pkg
        struct: tl_h2d
        domain: Main
        inter_pd: false
        signame: mbx_tl_req_i
        signame_chip:
        {
          asic: tlul_pkg::TL_H2D_DEFAULT
          verilator: tlul_pkg::TL_H2D_DEFAULT
        }
        width: 1
        type: req_rsp
        default: ""
        direction: in
        conn_type: false
        index: -1
        netname: mbx_tl_h2d
      }
      {
        package: tlul_pkg
        struct: tl_d2h
        domain: Main
        inter_pd: false
        signame: mbx_tl_rsp_o
        signame_chip:
        {
          asic: ""
          verilator: ""
        }
        width: 1
        type: req_rsp
        default: ""
        direction: out
        conn_type: false
        index: -1
        netname: mbx_tl_d2h
      }
      {
        package: ""
        struct: logic
        domain: Main
        inter_pd: false
        signame: mbx0_doe_intr_o
        signame_chip:
        {
          asic: ""
          verilator: ""
        }
        width: 1
        type: uni
        default: 1'b0
        direction: out
        conn_type: false
        index: -1
        netname: mbx0_doe_intr
      }
      {
        package: ""
        struct: logic
        domain: Main
        inter_pd: false
        signame: mbx0_doe_intr_en_o
        signame_chip:
        {
          asic: ""
          verilator: ""
        }
        width: 1
        type: uni
        default: 1'b0
        direction: out
        conn_type: false
        index: -1
        netname: mbx0_doe_intr_en
      }
      {
        package: ""
        struct: logic
        domain: Main
        inter_pd: false
        signame: mbx0_doe_intr_support_o
        signame_chip:
        {
          asic: ""
          verilator: ""
        }
        width: 1
        type: uni
        default: 1'b0
        direction: out
        conn_type: false
        index: -1
        netname: mbx0_doe_intr_support
      }
      {
        package: ""
        struct: logic
        domain: Main
        inter_pd: false
        signame: mbx0_doe_async_msg_support_o
        signame_chip:
        {
          asic: ""
          verilator: ""
        }
        width: 1
        type: uni
        default: 1'b0
        direction: out
        conn_type: false
        index: -1
        netname: mbx0_doe_async_msg_support
      }
      {
        package: ""
        struct: logic
        domain: Main
        inter_pd: false
        signame: mbx1_doe_intr_o
        signame_chip:
        {
          asic: ""
          verilator: ""
        }
        width: 1
        type: uni
        default: 1'b0
        direction: out
        conn_type: false
        index: -1
        netname: mbx1_doe_intr
      }
      {
        package: ""
        struct: logic
        domain: Main
        inter_pd: false
        signame: mbx1_doe_intr_en_o
        signame_chip:
        {
          asic: ""
          verilator: ""
        }
        width: 1
        type: uni
        default: 1'b0
        direction: out
        conn_type: false
        index: -1
        netname: mbx1_doe_intr_en
      }
      {
        package: ""
        struct: logic
        domain: Main
        inter_pd: false
        signame: mbx1_doe_intr_support_o
        signame_chip:
        {
          asic: ""
          verilator: ""
        }
        width: 1
        type: uni
        default: 1'b0
        direction: out
        conn_type: false
        index: -1
        netname: mbx1_doe_intr_support
      }
      {
        package: ""
        struct: logic
        domain: Main
        inter_pd: false
        signame: mbx1_doe_async_msg_support_o
        signame_chip:
        {
          asic: ""
          verilator: ""
        }
        width: 1
        type: uni
        default: 1'b0
        direction: out
        conn_type: false
        index: -1
        netname: mbx1_doe_async_msg_support
      }
      {
        package: ""
        struct: logic
        domain: Main
        inter_pd: false
        signame: mbx2_doe_intr_o
        signame_chip:
        {
          asic: ""
          verilator: ""
        }
        width: 1
        type: uni
        default: 1'b0
        direction: out
        conn_type: false
        index: -1
        netname: mbx2_doe_intr
      }
      {
        package: ""
        struct: logic
        domain: Main
        inter_pd: false
        signame: mbx2_doe_intr_en_o
        signame_chip:
        {
          asic: ""
          verilator: ""
        }
        width: 1
        type: uni
        default: 1'b0
        direction: out
        conn_type: false
        index: -1
        netname: mbx2_doe_intr_en
      }
      {
        package: ""
        struct: logic
        domain: Main
        inter_pd: false
        signame: mbx2_doe_intr_support_o
        signame_chip:
        {
          asic: ""
          verilator: ""
        }
        width: 1
        type: uni
        default: 1'b0
        direction: out
        conn_type: false
        index: -1
        netname: mbx2_doe_intr_support
      }
      {
        package: ""
        struct: logic
        domain: Main
        inter_pd: false
        signame: mbx2_doe_async_msg_support_o
        signame_chip:
        {
          asic: ""
          verilator: ""
        }
        width: 1
        type: uni
        default: 1'b0
        direction: out
        conn_type: false
        index: -1
        netname: mbx2_doe_async_msg_support
      }
      {
        package: ""
        struct: logic
        domain: Main
        inter_pd: false
        signame: mbx3_doe_intr_o
        signame_chip:
        {
          asic: ""
          verilator: ""
        }
        width: 1
        type: uni
        default: 1'b0
        direction: out
        conn_type: false
        index: -1
        netname: mbx3_doe_intr
      }
      {
        package: ""
        struct: logic
        domain: Main
        inter_pd: false
        signame: mbx3_doe_intr_en_o
        signame_chip:
        {
          asic: ""
          verilator: ""
        }
        width: 1
        type: uni
        default: 1'b0
        direction: out
        conn_type: false
        index: -1
        netname: mbx3_doe_intr_en
      }
      {
        package: ""
        struct: logic
        domain: Main
        inter_pd: false
        signame: mbx3_doe_intr_support_o
        signame_chip:
        {
          asic: ""
          verilator: ""
        }
        width: 1
        type: uni
        default: 1'b0
        direction: out
        conn_type: false
        index: -1
        netname: mbx3_doe_intr_support
      }
      {
        package: ""
        struct: logic
        domain: Main
        inter_pd: false
        signame: mbx3_doe_async_msg_support_o
        signame_chip:
        {
          asic: ""
          verilator: ""
        }
        width: 1
        type: uni
        default: 1'b0
        direction: out
        conn_type: false
        index: -1
        netname: mbx3_doe_async_msg_support
      }
      {
        package: ""
        struct: logic
        domain: Main
        inter_pd: false
        signame: mbx4_doe_intr_o
        signame_chip:
        {
          asic: ""
          verilator: ""
        }
        width: 1
        type: uni
        default: 1'b0
        direction: out
        conn_type: false
        index: -1
        netname: mbx4_doe_intr
      }
      {
        package: ""
        struct: logic
        domain: Main
        inter_pd: false
        signame: mbx4_doe_intr_en_o
        signame_chip:
        {
          asic: ""
          verilator: ""
        }
        width: 1
        type: uni
        default: 1'b0
        direction: out
        conn_type: false
        index: -1
        netname: mbx4_doe_intr_en
      }
      {
        package: ""
        struct: logic
        domain: Main
        inter_pd: false
        signame: mbx4_doe_intr_support_o
        signame_chip:
        {
          asic: ""
          verilator: ""
        }
        width: 1
        type: uni
        default: 1'b0
        direction: out
        conn_type: false
        index: -1
        netname: mbx4_doe_intr_support
      }
      {
        package: ""
        struct: logic
        domain: Main
        inter_pd: false
        signame: mbx4_doe_async_msg_support_o
        signame_chip:
        {
          asic: ""
          verilator: ""
        }
        width: 1
        type: uni
        default: 1'b0
        direction: out
        conn_type: false
        index: -1
        netname: mbx4_doe_async_msg_support
      }
      {
        package: ""
        struct: logic
        domain: Main
        inter_pd: false
        signame: mbx5_doe_intr_o
        signame_chip:
        {
          asic: ""
          verilator: ""
        }
        width: 1
        type: uni
        default: 1'b0
        direction: out
        conn_type: false
        index: -1
        netname: mbx5_doe_intr
      }
      {
        package: ""
        struct: logic
        domain: Main
        inter_pd: false
        signame: mbx5_doe_intr_en_o
        signame_chip:
        {
          asic: ""
          verilator: ""
        }
        width: 1
        type: uni
        default: 1'b0
        direction: out
        conn_type: false
        index: -1
        netname: mbx5_doe_intr_en
      }
      {
        package: ""
        struct: logic
        domain: Main
        inter_pd: false
        signame: mbx5_doe_intr_support_o
        signame_chip:
        {
          asic: ""
          verilator: ""
        }
        width: 1
        type: uni
        default: 1'b0
        direction: out
        conn_type: false
        index: -1
        netname: mbx5_doe_intr_support
      }
      {
        package: ""
        struct: logic
        domain: Main
        inter_pd: false
        signame: mbx5_doe_async_msg_support_o
        signame_chip:
        {
          asic: ""
          verilator: ""
        }
        width: 1
        type: uni
        default: 1'b0
        direction: out
        conn_type: false
        index: -1
        netname: mbx5_doe_async_msg_support
      }
      {
        package: ""
        struct: logic
        domain: Main
        inter_pd: false
        signame: mbx6_doe_intr_o
        signame_chip:
        {
          asic: ""
          verilator: ""
        }
        width: 1
        type: uni
        default: 1'b0
        direction: out
        conn_type: false
        index: -1
        netname: mbx6_doe_intr
      }
      {
        package: ""
        struct: logic
        domain: Main
        inter_pd: false
        signame: mbx6_doe_intr_en_o
        signame_chip:
        {
          asic: ""
          verilator: ""
        }
        width: 1
        type: uni
        default: 1'b0
        direction: out
        conn_type: false
        index: -1
        netname: mbx6_doe_intr_en
      }
      {
        package: ""
        struct: logic
        domain: Main
        inter_pd: false
        signame: mbx6_doe_intr_support_o
        signame_chip:
        {
          asic: ""
          verilator: ""
        }
        width: 1
        type: uni
        default: 1'b0
        direction: out
        conn_type: false
        index: -1
        netname: mbx6_doe_intr_support
      }
      {
        package: ""
        struct: logic
        domain: Main
        inter_pd: false
        signame: mbx6_doe_async_msg_support_o
        signame_chip:
        {
          asic: ""
          verilator: ""
        }
        width: 1
        type: uni
        default: 1'b0
        direction: out
        conn_type: false
        index: -1
        netname: mbx6_doe_async_msg_support
      }
      {
        package: ""
        struct: logic
        domain: Main
        inter_pd: false
        signame: mbx_jtag_doe_intr_o
        signame_chip:
        {
          asic: ""
          verilator: ""
        }
        width: 1
        type: uni
        default: 1'b0
        direction: out
        conn_type: false
        index: -1
        netname: mbx_jtag_doe_intr
      }
      {
        package: ""
        struct: logic
        domain: Main
        inter_pd: false
        signame: mbx_jtag_doe_intr_en_o
        signame_chip:
        {
          asic: ""
          verilator: ""
        }
        width: 1
        type: uni
        default: 1'b0
        direction: out
        conn_type: false
        index: -1
        netname: mbx_jtag_doe_intr_en
      }
      {
        package: ""
        struct: logic
        domain: Main
        inter_pd: false
        signame: mbx_jtag_doe_intr_support_o
        signame_chip:
        {
          asic: ""
          verilator: ""
        }
        width: 1
        type: uni
        default: 1'b0
        direction: out
        conn_type: false
        index: -1
        netname: mbx_jtag_doe_intr_support
      }
      {
        package: ""
        struct: logic
        domain: Main
        inter_pd: false
        signame: mbx_jtag_doe_async_msg_support_o
        signame_chip:
        {
          asic: ""
          verilator: ""
        }
        width: 1
        type: uni
        default: 1'b0
        direction: out
        conn_type: false
        index: -1
        netname: mbx_jtag_doe_async_msg_support
      }
      {
        package: ""
        struct: logic
        domain: Main
        inter_pd: false
        signame: mbx_pcie0_doe_intr_o
        signame_chip:
        {
          asic: ""
          verilator: ""
        }
        width: 1
        type: uni
        default: 1'b0
        direction: out
        conn_type: false
        index: -1
        netname: mbx_pcie0_doe_intr
      }
      {
        package: ""
        struct: logic
        domain: Main
        inter_pd: false
        signame: mbx_pcie0_doe_intr_en_o
        signame_chip:
        {
          asic: ""
          verilator: ""
        }
        width: 1
        type: uni
        default: 1'b0
        direction: out
        conn_type: false
        index: -1
        netname: mbx_pcie0_doe_intr_en
      }
      {
        package: ""
        struct: logic
        domain: Main
        inter_pd: false
        signame: mbx_pcie0_doe_intr_support_o
        signame_chip:
        {
          asic: ""
          verilator: ""
        }
        width: 1
        type: uni
        default: 1'b0
        direction: out
        conn_type: false
        index: -1
        netname: mbx_pcie0_doe_intr_support
      }
      {
        package: ""
        struct: logic
        domain: Main
        inter_pd: false
        signame: mbx_pcie0_doe_async_msg_support_o
        signame_chip:
        {
          asic: ""
          verilator: ""
        }
        width: 1
        type: uni
        default: 1'b0
        direction: out
        conn_type: false
        index: -1
        netname: mbx_pcie0_doe_async_msg_support
      }
      {
        package: ""
        struct: logic
        domain: Main
        inter_pd: false
        signame: mbx_pcie1_doe_intr_o
        signame_chip:
        {
          asic: ""
          verilator: ""
        }
        width: 1
        type: uni
        default: 1'b0
        direction: out
        conn_type: false
        index: -1
        netname: mbx_pcie1_doe_intr
      }
      {
        package: ""
        struct: logic
        domain: Main
        inter_pd: false
        signame: mbx_pcie1_doe_intr_en_o
        signame_chip:
        {
          asic: ""
          verilator: ""
        }
        width: 1
        type: uni
        default: 1'b0
        direction: out
        conn_type: false
        index: -1
        netname: mbx_pcie1_doe_intr_en
      }
      {
        package: ""
        struct: logic
        domain: Main
        inter_pd: false
        signame: mbx_pcie1_doe_intr_support_o
        signame_chip:
        {
          asic: ""
          verilator: ""
        }
        width: 1
        type: uni
        default: 1'b0
        direction: out
        conn_type: false
        index: -1
        netname: mbx_pcie1_doe_intr_support
      }
      {
        package: ""
        struct: logic
        domain: Main
        inter_pd: false
        signame: mbx_pcie1_doe_async_msg_support_o
        signame_chip:
        {
          asic: ""
          verilator: ""
        }
        width: 1
        type: uni
        default: 1'b0
        direction: out
        conn_type: false
        index: -1
        netname: mbx_pcie1_doe_async_msg_support
      }
      {
        package: tlul_pkg
        struct: tl_h2d
        domain: Main
        inter_pd: false
        signame: dbg_tl_req_i
        signame_chip:
        {
          asic: dmi_req
          verilator: dmi_req
        }
        width: 1
        type: req_rsp
        default: ""
        direction: in
        conn_type: false
        index: -1
        netname: dbg_tl_h2d
      }
      {
        package: tlul_pkg
        struct: tl_d2h
        domain: Main
        inter_pd: false
        signame: dbg_tl_rsp_o
        signame_chip:
        {
          asic: dmi_rsp
          verilator: dmi_rsp
        }
        width: 1
        type: req_rsp
        default: ""
        direction: out
        conn_type: false
        index: -1
        netname: dbg_tl_d2h
      }
      {
        package: rv_dm_pkg
        struct: next_dm_addr
        domain: Main
        inter_pd: false
        signame: rv_dm_next_dm_addr_i
        signame_chip:
        {
          asic: "'0"
          verilator: "'0"
        }
        width: 1
        type: uni
        default: "'0"
        direction: in
        conn_type: false
        index: -1
        netname: rv_dm_next_dm_addr
      }
      {
        package: tlul_pkg
        struct: tl_h2d
        domain: Main
        inter_pd: false
        signame: ast_tl_req_o
        signame_chip:
        {
          asic: ast_tl_req
          verilator: ast_tl_req
        }
        width: 1
        type: req_rsp
        default: ""
        direction: out
        conn_type: false
        index: -1
        netname: ast_tl_h2d
      }
      {
        package: tlul_pkg
        struct: tl_d2h
        domain: Main
        inter_pd: false
        signame: ast_tl_rsp_i
        signame_chip:
        {
          asic: ast_tl_rsp
          verilator: ast_tl_rsp
        }
        width: 1
        type: req_rsp
        default: ""
        direction: in
        conn_type: false
        index: -1
        netname: ast_tl_d2h
      }
      {
        package: pwrmgr_pkg
        struct: pwr_ast_req
        domain: Aon
        inter_pd: false
        signame: pwrmgr_ast_req_o
        signame_chip:
        {
          asic: pwrmgr_ast_req
          verilator: pwrmgr_ast_req
        }
        width: 1
        type: req_rsp
        default: ""
        direction: out
        conn_type: false
        index: -1
        netname: pwrmgr_ast_req
      }
      {
        package: pwrmgr_pkg
        struct: pwr_ast_rsp
        domain: Aon
        inter_pd: false
        signame: pwrmgr_ast_rsp_i
        signame_chip:
        {
          asic: pwrmgr_ast_rsp
          verilator: pwrmgr_ast_rsp
        }
        width: 1
        type: req_rsp
        default: ""
        direction: in
        conn_type: false
        index: -1
        netname: pwrmgr_ast_rsp
      }
      {
        package: otp_macro_pkg
        struct: pwr_seq
        domain: Main
        inter_pd: false
        signame: otp_macro_pwr_seq_o
        signame_chip:
        {
          asic: otp_macro_pwr_seq
          verilator: otp_macro_pwr_seq
        }
        width: 1
        type: uni
        default: "'0"
        direction: out
        conn_type: false
        index: -1
        netname: otp_macro_pwr_seq
      }
      {
        package: otp_macro_pkg
        struct: pwr_seq
        domain: Main
        inter_pd: false
        signame: otp_macro_pwr_seq_h_i
        signame_chip:
        {
          asic: otp_macro_pwr_seq_h
          verilator: otp_macro_pwr_seq_h
        }
        width: 1
        type: uni
        default: "'0"
        direction: in
        conn_type: false
        index: -1
        netname: otp_macro_pwr_seq_h
      }
      {
        package: ""
        struct: ""
        domain: Main
        inter_pd: false
        signame: otp_ext_voltage_h_io
        signame_chip:
        {
          asic: OTP_EXT_VOLT
          verilator: ""
        }
        width: 1
        type: io
        default: "'0"
        direction: inout
        conn_type: false
        index: -1
        netname: otp_ext_voltage_h
      }
      {
        package: ""
        struct: logic
        domain: Main
        inter_pd: false
        signame: otp_obs_o
        signame_chip:
        {
          asic: otp_obs
          verilator: otp_obs
        }
        width: 8
        type: uni
        default: ""
        direction: out
        conn_type: false
        index: -1
        netname: otp_obs
      }
      {
        package: otp_macro_pkg
        struct: otp_cfg
        domain: Main
        inter_pd: false
        signame: otp_cfg_i
        signame_chip:
        {
          asic: otp_cfg
          verilator: otp_cfg
        }
        width: 1
        type: uni
        default: "'0"
        direction: in
        conn_type: false
        index: -1
        netname: otp_cfg
      }
      {
        package: ""
        struct: logic
        domain: Aon
        inter_pd: false
        signame: por_n_i
        signame_chip:
        {
          asic: por_n
          verilator: por_n
        }
        width: 2
        type: uni
        default: ""
        direction: in
        conn_type: false
        index: -1
        netname: por_n
      }
      {
        package: rstmgr_pkg
        struct: rstmgr_out
        domain: Aon
        inter_pd: false
        signame: rstmgr_resets_o
        signame_chip:
        {
          asic: rstmgr_resets
          verilator: rstmgr_resets
        }
        width: 1
        type: uni
        default: ""
        direction: out
        conn_type: true
        index: -1
        netname: rstmgr_resets
      }
      {
        package: rstmgr_pkg
        struct: rstmgr_rst_en
        domain: Aon
        inter_pd: false
        signame: rstmgr_rst_en_o
        signame_chip:
        {
          asic: ""
          verilator: ""
        }
        width: 1
        type: uni
        default: ""
        direction: out
        conn_type: true
        index: -1
        netname: rstmgr_rst_en
      }
      {
        package: tlul_pkg
        struct: tl_h2d
        domain: Aon
        inter_pd: false
        signame: ctn_misc_tl_h2d_i
        signame_chip:
        {
          asic: ctn_misc_tl_h2d_i
          verilator: ctn_misc_tl_h2d_i
        }
        width: 1
        type: uni
        default: ""
        direction: in
        conn_type: false
        index: -1
        netname: ctn_misc_tl_h2d
      }
      {
        package: tlul_pkg
        struct: tl_d2h
        domain: Aon
        inter_pd: false
        signame: ctn_misc_tl_d2h_o
        signame_chip:
        {
          asic: ctn_misc_tl_d2h_o
          verilator: ctn_misc_tl_d2h_o
        }
        width: 1
        type: uni
        default: ""
        direction: out
        conn_type: false
        index: -1
        netname: ctn_misc_tl_d2h
      }
      {
        package: ""
        struct: logic
        domain: Aon
        inter_pd: false
        signame: soc_wkup_async_i
        signame_chip:
        {
          asic: 1'b0
          verilator: 1'b0
        }
        width: 1
        type: uni
        default: ""
        direction: in
        conn_type: false
        index: -1
        netname: soc_wkup_async
      }
      {
        package: ""
        struct: logic
        domain: Aon
        inter_pd: false
        signame: soc_rst_req_async_i
        signame_chip:
        {
          asic: soc_rst_req_async
          verilator: soc_rst_req_async
        }
        width: 1
        type: uni
        default: ""
        direction: in
        conn_type: false
        index: -1
        netname: soc_rst_req_async
      }
      {
        package: ""
        struct: logic
        domain: Aon
        inter_pd: false
        signame: soc_lsio_trigger_i
        signame_chip:
        {
          asic: "'0"
          verilator: "'0"
        }
        width: 8
        type: uni
        default: ""
        direction: in
        conn_type: false
        index: -1
        netname: soc_lsio_trigger
      }
      {
        package: ""
        struct: logic
        domain: Aon
        inter_pd: false
        signame: soc_gpi_async_o
        signame_chip:
        {
          asic: ""
          verilator: ""
        }
        width: 16
        type: uni
        default: ""
        direction: out
        conn_type: false
        index: -1
        netname: soc_gpi_async
      }
      {
        package: ""
        struct: logic
        domain: Aon
        inter_pd: false
        signame: soc_gpo_async_i
        signame_chip:
        {
          asic: "'0"
          verilator: "'0"
        }
        width: 16
        type: uni
        default: ""
        direction: in
        conn_type: false
        index: -1
        netname: soc_gpo_async
      }
      {
        package: ""
        struct: logic
        domain: Aon
        inter_pd: false
        signame: integrator_id_i
        signame_chip:
        {
          asic: "'0"
          verilator: "'0"
        }
        width: 4
        type: uni
        default: ""
        direction: in
        conn_type: false
        index: -1
        netname: integrator_id
      }
      {
        package: ""
        struct: logic
        domain: Main
        inter_pd: false
        signame: sck_monitor_o
        signame_chip:
        {
          asic: sck_monitor
          verilator: sck_monitor
        }
        width: 1
        type: uni
        default: ""
        direction: out
        conn_type: false
        index: -1
        netname: sck_monitor
      }
      {
        package: soc_dbg_ctrl_pkg
        struct: soc_dbg_policy
        domain: Main
        inter_pd: false
        signame: soc_dbg_policy_bus_o
        signame_chip:
        {
          asic: ""
          verilator: ""
        }
        width: 1
        type: uni
        default: ""
        direction: out
        conn_type: false
        index: -1
        netname: soc_dbg_policy_bus
      }
      {
        package: ""
        struct: logic
        domain: Main
        inter_pd: false
        signame: debug_halt_cpu_boot_i
        signame_chip:
        {
          asic: 1'b0
          verilator: 1'b0
        }
        width: 1
        type: uni
        default: ""
        direction: in
        conn_type: false
        index: -1
        netname: debug_halt_cpu_boot
      }
      {
        package: top_racl_pkg
        struct: racl_policy_vec
        domain: Main
        inter_pd: false
        signame: racl_policies_o
        signame_chip:
        {
          asic: ""
          verilator: ""
        }
        width: 1
        type: uni
        default: ""
        direction: out
        conn_type: true
        index: -1
        netname: racl_ctrl_racl_policies
      }
      {
        package: top_racl_pkg
        struct: racl_error_log
        domain: Main
        inter_pd: false
        signame: racl_error_i
        signame_chip:
        {
          asic: ext_racl_error
          verilator: ext_racl_error
        }
        width:
        {
          name: NumExternalSubscribingIps
          desc: Number of external subscribing RACL IPs
          param_type: int
          unpacked_dimensions: null
          default: 1
          local: false
          expose: true
          name_top: RaclCtrlNumExternalSubscribingIps
        }
        type: uni
        default: ""
        direction: in
        conn_type: false
        index: -1
        netname: racl_error
      }
      {
        package: prim_mubi_pkg
        struct: mubi8
        domain: Main
        inter_pd: false
        signame: ac_range_check_overwrite_i
        signame_chip:
        {
          asic: ac_range_check_overwrite_i
          verilator: ac_range_check_overwrite_i
        }
        width: 1
        type: uni
        default: ""
        direction: in
        conn_type: false
        index: -1
        netname: ac_range_check_overwrite
      }
      {
        package: tlul_pkg
        struct: tl_h2d
        domain: Main
        inter_pd: false
        signame: ctn_tl_h2d_o
        signame_chip:
        {
          asic: ctn_tl_h2d[0]
          verilator: ctn_tl_h2d[0]
        }
        width: 1
        type: uni
        default: ""
        direction: out
        conn_type: false
        index: -1
        netname: ctn_tl_h2d
      }
      {
        package: tlul_pkg
        struct: tl_d2h
        domain: Main
        inter_pd: false
        signame: ctn_tl_d2h_i
        signame_chip:
        {
          asic: ctn_tl_d2h[0]
          verilator: ctn_tl_d2h[0]
        }
        width: 1
        type: uni
        default: ""
        direction: in
        conn_type: false
        index: -1
        netname: ctn_tl_d2h
      }
      {
        package: ""
        struct: logic
        domain: Aon
        inter_pd: true
        signame: cio_soc_proxy_soc_gpi_p2d_i
        signame_chip:
        {
          asic: cio_soc_proxy_soc_gpi_p2d
          verilator: cio_soc_proxy_soc_gpi_p2d
        }
        width: 16
        type: uni
        default: "'0"
        direction: in
        conn_type: false
        index: -1
        netname: cio_soc_proxy_soc_gpi_p2d
      }
      {
        package: ""
        struct: logic
        domain: Main
        inter_pd: true
        signame: cio_soc_proxy_soc_gpi_p2d_o
        signame_chip:
        {
          asic: cio_soc_proxy_soc_gpi_p2d
          verilator: cio_soc_proxy_soc_gpi_p2d
        }
        width: 16
        type: uni
        default: "'0"
        direction: out
        conn_type: false
        index: -1
        netname: cio_soc_proxy_soc_gpi_p2d
      }
      {
        package: ""
        struct: logic
        domain: Aon
        inter_pd: true
        signame: cio_soc_proxy_soc_gpo_d2p_o
        signame_chip:
        {
          asic: cio_soc_proxy_soc_gpo_d2p
          verilator: cio_soc_proxy_soc_gpo_d2p
        }
        width: 16
        type: uni
        default: "'0"
        direction: out
        conn_type: false
        index: -1
        netname: cio_soc_proxy_soc_gpo_d2p
      }
      {
        package: ""
        struct: logic
        domain: Main
        inter_pd: true
        signame: cio_soc_proxy_soc_gpo_d2p_i
        signame_chip:
        {
          asic: cio_soc_proxy_soc_gpo_d2p
          verilator: cio_soc_proxy_soc_gpo_d2p
        }
        width: 16
        type: uni
        default: "'0"
        direction: in
        conn_type: false
        index: -1
        netname: cio_soc_proxy_soc_gpo_d2p
      }
      {
        package: ""
        struct: logic
        domain: Aon
        inter_pd: true
        signame: cio_soc_proxy_soc_gpo_en_d2p_o
        signame_chip:
        {
          asic: cio_soc_proxy_soc_gpo_en_d2p
          verilator: cio_soc_proxy_soc_gpo_en_d2p
        }
        width: 16
        type: uni
        default: "'0"
        direction: out
        conn_type: false
        index: -1
        netname: cio_soc_proxy_soc_gpo_en_d2p
      }
      {
        package: ""
        struct: logic
        domain: Main
        inter_pd: true
        signame: cio_soc_proxy_soc_gpo_en_d2p_i
        signame_chip:
        {
          asic: cio_soc_proxy_soc_gpo_en_d2p
          verilator: cio_soc_proxy_soc_gpo_en_d2p
        }
        width: 16
        type: uni
        default: "'0"
        direction: in
        conn_type: false
        index: -1
        netname: cio_soc_proxy_soc_gpo_en_d2p
      }
    ]
    definitions:
    [
      {
        package: ast_pkg
        struct: ast_obs_ctrl
        domain: Main
        signame: ast_obs_ctrl
        width: 1
        type: uni
        end_idx: -1
        act: rcv
        suffix: ""
        default: ast_pkg::AST_OBS_CTRL_DEFAULT
      }
      {
        package: prim_esc_pkg
        struct: esc_rx
        domain: Main
        signame: alert_handler_esc_rx
        width: 4
        type: uni
        end_idx: -1
        act: rcv
        suffix: ""
        default: "{4{prim_esc_pkg::ESC_RX_DEFAULT}}"
      }
      {
        package: prim_esc_pkg
        struct: esc_tx
        domain: Main
        signame: alert_handler_esc_tx
        width: 4
        type: uni
        end_idx: -1
        act: req
        suffix: ""
        default: "{4{prim_esc_pkg::ESC_TX_DEFAULT}}"
      }
      {
        package: csrng_pkg
        struct: csrng_req
        domain: Main
        signame: csrng_csrng_cmd_req
        width: 2
        type: req_rsp
        end_idx: -1
        act: rsp
        suffix: req
        default: "{2{csrng_pkg::CSRNG_REQ_DEFAULT}}"
      }
      {
        package: csrng_pkg
        struct: csrng_rsp
        domain: Main
        signame: csrng_csrng_cmd_rsp
        width: 2
        type: req_rsp
        end_idx: -1
        act: rsp
        suffix: rsp
        default: ""
      }
      {
        package: entropy_src_pkg
        struct: entropy_src_hw_if_req
        domain: Main
        signame: csrng_entropy_src_hw_if_req
        width: 1
        type: req_rsp
        end_idx: -1
        act: req
        suffix: req
        default: ""
      }
      {
        package: entropy_src_pkg
        struct: entropy_src_hw_if_rsp
        domain: Main
        signame: csrng_entropy_src_hw_if_rsp
        width: 1
        type: req_rsp
        end_idx: -1
        act: req
        suffix: rsp
        default: entropy_src_pkg::ENTROPY_SRC_HW_IF_RSP_DEFAULT
      }
      {
        package: otp_ctrl_pkg
        struct: sram_otp_key_req
        domain: Main
        signame: otp_ctrl_sram_otp_key_req
        width: 4
        type: req_rsp
        end_idx: -1
        act: rsp
        suffix: req
        default: "'0"
      }
      {
        package: otp_ctrl_pkg
        struct: sram_otp_key_rsp
        domain: Main
        signame: otp_ctrl_sram_otp_key_rsp
        width: 4
        type: req_rsp
        end_idx: -1
        act: rsp
        suffix: rsp
        default: "'0"
      }
      {
        package: pwrmgr_pkg
        struct: pwr_rst_req
        domain: Aon
        signame: pwrmgr_pwr_rst_req
        width: 1
        type: req_rsp
        end_idx: -1
        act: req
        suffix: req
        default: ""
      }
      {
        package: pwrmgr_pkg
        struct: pwr_rst_rsp
        domain: Aon
        signame: pwrmgr_pwr_rst_rsp
        width: 1
        type: req_rsp
        end_idx: -1
        act: req
        suffix: rsp
        default: pwrmgr_pkg::PWR_RST_RSP_DEFAULT
      }
      {
        package: pwrmgr_pkg
        struct: pwr_clk_req
        domain: Aon
        signame: pwrmgr_pwr_clk_req
        width: 1
        type: req_rsp
        end_idx: -1
        act: req
        suffix: req
        default: ""
      }
      {
        package: pwrmgr_pkg
        struct: pwr_clk_rsp
        domain: Aon
        signame: pwrmgr_pwr_clk_rsp
        width: 1
        type: req_rsp
        end_idx: -1
        act: req
        suffix: rsp
        default: pwrmgr_pkg::PWR_CLK_RSP_DEFAULT
      }
      {
        package: ""
        struct: logic
        domain: Aon
        signame: pwrmgr_low_power
        width: 1
        type: uni
        end_idx: -1
        act: req
        suffix: ""
        default: 1'b0
      }
      {
        package: pwrmgr_pkg
        struct: pwr_boot_status
        domain: Aon
        signame: pwrmgr_boot_status
        width: 1
        type: uni
        end_idx: -1
        act: req
        suffix: ""
        default: pwrmgr_pkg::PWR_BOOT_STATUS_DEFAULT
      }
      {
        package: rom_ctrl_pkg
        struct: keymgr_data
        domain: Main
        signame: keymgr_dpe_rom_digest
        width:
        {
          name: NumRomDigestInputs
          desc: Number of digest inputs from ROM_CTRL
          param_type: int
          unpacked_dimensions: null
          default: 1
          local: true
          expose: true
          name_top: KeymgrDpeNumRomDigestInputs
        }
        type: uni
        end_idx: -1
        act: rcv
        suffix: ""
        default: rom_ctrl_pkg::KEYMGR_DATA_DEFAULT
      }
      {
        package: lc_ctrl_pkg
        struct: lc_tx
        domain: Main
        signame: lc_ctrl_lc_nvm_rma_req
        width: 1
        type: uni
        end_idx: -1
        act: req
        suffix: ""
        default: lc_ctrl_pkg::Off
      }
      {
        package: lc_ctrl_pkg
        struct: lc_tx
        domain: Main
        signame: otbn_lc_rma_ack
        width: 1
        type: uni
        end_idx: -1
        act: req
        suffix: ""
        default: lc_ctrl_pkg::Off
      }
      {
        package: edn_pkg
        struct: edn_req
        domain: Main
        signame: edn0_edn_req
        width:
        {
          name: NumEndPoints
          desc: Number of endpoints
          param_type: int unsigned
          unpacked_dimensions: null
          default: 8
          local: true
          expose: true
          name_top: Edn0NumEndPoints
        }
        type: req_rsp
        end_idx: 7
        act: rsp
        suffix: req
        default: "'0"
      }
      {
        package: edn_pkg
        struct: edn_rsp
        domain: Main
        signame: edn0_edn_rsp
        width:
        {
          name: NumEndPoints
          desc: Number of endpoints
          param_type: int unsigned
          unpacked_dimensions: null
          default: 8
          local: true
          expose: true
          name_top: Edn0NumEndPoints
        }
        type: req_rsp
        end_idx: 7
        act: rsp
        suffix: rsp
        default: ""
      }
      {
        package: edn_pkg
        struct: edn_req
        domain: Main
        signame: edn1_edn_req
        width:
        {
          name: NumEndPoints
          desc: Number of endpoints
          param_type: int unsigned
          unpacked_dimensions: null
          default: 8
          local: true
          expose: true
          name_top: Edn1NumEndPoints
        }
        type: req_rsp
        end_idx: -1
        act: rsp
        suffix: req
        default: "'0"
      }
      {
        package: edn_pkg
        struct: edn_rsp
        domain: Main
        signame: edn1_edn_rsp
        width:
        {
          name: NumEndPoints
          desc: Number of endpoints
          param_type: int unsigned
          unpacked_dimensions: null
          default: 8
          local: true
          expose: true
          name_top: Edn1NumEndPoints
        }
        type: req_rsp
        end_idx: -1
        act: rsp
        suffix: rsp
        default: ""
      }
      {
        package: otp_ctrl_pkg
        struct: otbn_otp_key_req
        domain: Main
        signame: otp_ctrl_otbn_otp_key_req
        width: 1
        type: req_rsp
        end_idx: -1
        act: rsp
        suffix: req
        default: "'0"
      }
      {
        package: otp_ctrl_pkg
        struct: otbn_otp_key_rsp
        domain: Main
        signame: otp_ctrl_otbn_otp_key_rsp
        width: 1
        type: req_rsp
        end_idx: -1
        act: rsp
        suffix: rsp
        default: ""
      }
      {
        package: keymgr_dpe_pkg
        struct: keymgr_dpe_creator_root_key
        domain: Main
        signame: otp_ctrl_keymgr_creator_root_key
        width: 1
        type: uni
        end_idx: -1
        act: req
        suffix: ""
        default: "'0"
      }
      {
        package: keymgr_dpe_pkg
        struct: keymgr_dpe_creator_seed
        domain: Main
        signame: otp_ctrl_keymgr_creator_seed
        width: 1
        type: uni
        end_idx: -1
        act: req
        suffix: ""
        default: "'0"
      }
      {
        package: keymgr_dpe_pkg
        struct: keymgr_dpe_owner_seed
        domain: Main
        signame: otp_ctrl_keymgr_owner_seed
        width: 1
        type: uni
        end_idx: -1
        act: req
        suffix: ""
        default: "'0"
      }
      {
        package: keymgr_dpe_pkg
        struct: hw_key_req
        domain: Main
        signame: keymgr_dpe_aes_key
        width: 1
        type: uni
        end_idx: -1
        act: req
        suffix: ""
        default: keymgr_dpe_pkg::HW_KEY_REQ_DEFAULT
      }
      {
        package: keymgr_dpe_pkg
        struct: hw_key_req
        domain: Main
        signame: keymgr_dpe_kmac_key
        width: 1
        type: uni
        end_idx: -1
        act: req
        suffix: ""
        default: keymgr_dpe_pkg::HW_KEY_REQ_DEFAULT
      }
      {
        package: keymgr_dpe_pkg
        struct: wide_hw_key_req
        domain: Main
        signame: keymgr_dpe_hmac_key
        width: 1
        type: uni
        end_idx: -1
        act: req
        suffix: ""
        default: keymgr_dpe_pkg::WIDE_HW_KEY_REQ_DEFAULT
      }
      {
        package: keymgr_dpe_pkg
        struct: wide_hw_key_req
        domain: Main
        signame: keymgr_dpe_otbn_key
        width: 1
        type: uni
        end_idx: -1
        act: req
        suffix: ""
        default: keymgr_dpe_pkg::WIDE_HW_KEY_REQ_DEFAULT
      }
      {
        package: kmac_pkg
        struct: app_req
        domain: Main
        signame: kmac_app_req
        width:
        {
          name: NumAppIntf
          desc: Number of application interfaces
          param_type: int
          unpacked_dimensions: null
          default: 4
          local: false
          expose: true
          name_top: KmacNumAppIntf
        }
        type: req_rsp
        end_idx: -1
        act: rsp
        suffix: req
        default: kmac_pkg::APP_REQ_DEFAULT
      }
      {
        package: kmac_pkg
        struct: app_rsp
        domain: Main
        signame: kmac_app_rsp
        width:
        {
          name: NumAppIntf
          desc: Number of application interfaces
          param_type: int
          unpacked_dimensions: null
          default: 4
          local: false
          expose: true
          name_top: KmacNumAppIntf
        }
        type: req_rsp
        end_idx: -1
        act: rsp
        suffix: rsp
        default: ""
      }
      {
        package: ""
        struct: logic
        domain: Main
        signame: kmac_en_masking
        width: 1
        type: uni
        end_idx: -1
        act: req
        suffix: ""
        default: 1'b0
      }
      {
        package: prim_mubi_pkg
        struct: mubi4
        domain: Main
        signame: kmac_keymgr_sensitive_key
        width: 1
        type: uni
        end_idx: -1
        act: rcv
        suffix: ""
        default: prim_mubi_pkg::MuBi4False
      }
      {
        package: kmac_pkg
        struct: app_req
        domain: Main
        signame: otbn_keymgr_app_req
        width: 1
        type: req_rsp
        end_idx: -1
        act: rsp
        suffix: req
        default: kmac_pkg::APP_REQ_DEFAULT
      }
      {
        package: kmac_pkg
        struct: app_rsp
        domain: Main
        signame: otbn_keymgr_app_rsp
        width: 1
        type: req_rsp
        end_idx: -1
        act: rsp
        suffix: rsp
        default: ""
      }
      {
        package: prim_mubi_pkg
        struct: mubi4
        domain: Main
        signame: otbn_keymgr_sensitive_key
        width: 1
        type: uni
        end_idx: -1
        act: rcv
        suffix: ""
        default: prim_mubi_pkg::MuBi4False
      }
      {
        package: otp_ctrl_pkg
        struct: otp_lc_data
        domain: Main
        signame: otp_ctrl_otp_lc_data
        width: 1
        type: uni
        end_idx: -1
        act: req
        suffix: ""
        default: "'0"
      }
      {
        package: otp_ctrl_pkg
        struct: lc_otp_program_req
        domain: Main
        signame: lc_ctrl_lc_otp_program_req
        width: 1
        type: req_rsp
        end_idx: -1
        act: req
        suffix: req
        default: ""
      }
      {
        package: otp_ctrl_pkg
        struct: lc_otp_program_rsp
        domain: Main
        signame: lc_ctrl_lc_otp_program_rsp
        width: 1
        type: req_rsp
        end_idx: -1
        act: req
        suffix: rsp
        default: "'0"
      }
      {
        package: otp_macro_pkg
        struct: otp_test_req
        domain: Main
        signame: lc_ctrl_lc_otp_vendor_test_req
        width: 1
        type: req_rsp
        end_idx: -1
        act: req
        suffix: req
        default: ""
      }
      {
        package: otp_macro_pkg
        struct: otp_test_rsp
        domain: Main
        signame: lc_ctrl_lc_otp_vendor_test_rsp
        width: 1
        type: req_rsp
        end_idx: -1
        act: req
        suffix: rsp
        default: "'0"
      }
      {
        package: lc_ctrl_pkg
        struct: lc_keymgr_div
        domain: Main
        signame: lc_ctrl_lc_keymgr_div
        width: 1
        type: uni
        end_idx: -1
        act: req
        suffix: ""
        default: "'0"
      }
      {
        package: ""
        struct: logic
        domain: Main
        signame: lc_ctrl_strap_en_override
        width: 1
        type: uni
        end_idx: -1
        act: req
        suffix: ""
        default: 1'b0
      }
      {
        package: lc_ctrl_pkg
        struct: lc_tx
        domain: Main
        signame: lc_ctrl_lc_raw_test_rma
        width: 1
        type: uni
        end_idx: -1
        act: req
        suffix: ""
        default: lc_ctrl_pkg::Off
      }
      {
        package: lc_ctrl_pkg
        struct: lc_tx
        domain: Main
        signame: lc_ctrl_lc_dft_en
        width: 1
        type: uni
        end_idx: -1
        act: req
        suffix: ""
        default: lc_ctrl_pkg::Off
      }
      {
        package: lc_ctrl_pkg
        struct: lc_tx
        domain: Main
        signame: lc_ctrl_lc_hw_debug_clr
        width: 1
        type: uni
        end_idx: -1
        act: req
        suffix: ""
        default: lc_ctrl_pkg::Off
      }
      {
        package: lc_ctrl_pkg
        struct: lc_tx
        domain: Main
        signame: lc_ctrl_lc_init_done
        width: 1
        type: uni
        end_idx: -1
        act: req
        suffix: ""
        default: lc_ctrl_pkg::Off
      }
      {
        package: lc_ctrl_pkg
        struct: lc_tx
        domain: Main
        signame: lc_ctrl_lc_hw_debug_en
        width: 1
        type: uni
        end_idx: -1
        act: req
        suffix: ""
        default: lc_ctrl_pkg::Off
      }
      {
        package: lc_ctrl_pkg
        struct: lc_tx
        domain: Main
        signame: lc_ctrl_lc_cpu_en
        width: 1
        type: uni
        end_idx: -1
        act: req
        suffix: ""
        default: lc_ctrl_pkg::Off
      }
      {
        package: lc_ctrl_pkg
        struct: lc_tx
        domain: Main
        signame: lc_ctrl_lc_keymgr_en
        width: 1
        type: uni
        end_idx: -1
        act: req
        suffix: ""
        default: lc_ctrl_pkg::Off
      }
      {
        package: lc_ctrl_pkg
        struct: lc_tx
        domain: Main
        signame: lc_ctrl_lc_escalate_en
        width: 1
        type: uni
        end_idx: -1
        act: req
        suffix: ""
        default: lc_ctrl_pkg::Off
      }
      {
        package: lc_ctrl_pkg
        struct: lc_tx
        domain: Main
        signame: lc_ctrl_lc_check_byp_en
        width: 1
        type: uni
        end_idx: -1
        act: req
        suffix: ""
        default: lc_ctrl_pkg::Off
      }
      {
        package: lc_ctrl_pkg
        struct: lc_tx
        domain: Main
        signame: lc_ctrl_lc_clk_byp_ack
        width: 1
        type: uni
        end_idx: -1
        act: rcv
        suffix: ""
        default: lc_ctrl_pkg::Off
      }
      {
        package: lc_ctrl_pkg
        struct: lc_tx
        domain: Main
        signame: lc_ctrl_lc_creator_seed_sw_rw_en
        width: 1
        type: uni
        end_idx: -1
        act: req
        suffix: ""
        default: lc_ctrl_pkg::Off
      }
      {
        package: lc_ctrl_pkg
        struct: lc_tx
        domain: Main
        signame: lc_ctrl_lc_owner_seed_sw_rw_en
        width: 1
        type: uni
        end_idx: -1
        act: req
        suffix: ""
        default: lc_ctrl_pkg::Off
      }
      {
        package: lc_ctrl_pkg
        struct: lc_tx
        domain: Main
        signame: lc_ctrl_lc_seed_hw_rd_en
        width: 1
        type: uni
        end_idx: -1
        act: req
        suffix: ""
        default: lc_ctrl_pkg::Off
      }
      {
        package: lc_ctrl_pkg
        struct: lc_tx
        domain: Main
        signame: lc_ctrl_lc_rma_state
        width: 1
        type: uni
        end_idx: -1
        act: req
        suffix: ""
        default: lc_ctrl_pkg::Off
      }
      {
        package: otp_ctrl_macro_pkg
        struct: otp_ctrl_macro_req
        domain: Main
        signame: otp_ctrl_otp_macro_req
        width: 1
        type: req_rsp
        end_idx: -1
        act: req
        suffix: req
        default: ""
      }
      {
        package: otp_ctrl_macro_pkg
        struct: otp_ctrl_macro_rsp
        domain: Main
        signame: otp_ctrl_otp_macro_rsp
        width: 1
        type: req_rsp
        end_idx: -1
        act: req
        suffix: rsp
        default: "'0"
      }
      {
        package: ""
        struct: logic
        domain: Main
        signame: rv_plic_msip
        width: 1
        type: uni
        end_idx: -1
        act: req
        suffix: ""
        default: 1'b0
      }
      {
        package: ""
        struct: logic
        domain: Main
        signame: rv_plic_irq
        width: 1
        type: uni
        end_idx: -1
        act: req
        suffix: ""
        default: 1'b0
      }
      {
        package: ""
        struct: logic [rv_dm_reg_pkg::NrHarts-1:0]
        domain: Main
        signame: rv_dm_debug_req
        width: 1
        type: uni
        end_idx: -1
        act: req
        suffix: ""
        default: "'0"
      }
      {
        package: spi_device_pkg
        struct: passthrough_req
        domain: Main
        signame: spi_device_passthrough_req
        width: 1
        type: req_rsp
        end_idx: -1
        act: req
        suffix: req
        default: ""
      }
      {
        package: spi_device_pkg
        struct: passthrough_rsp
        domain: Main
        signame: spi_device_passthrough_rsp
        width: 1
        type: req_rsp
        end_idx: -1
        act: req
        suffix: rsp
        default: spi_device_pkg::PASSTHROUGH_RSP_DEFAULT
      }
      {
        package: prim_mubi_pkg
        struct: mubi4
        domain: Aon
        signame: rstmgr_sw_rst_req
        width: 1
        type: uni
        end_idx: -1
        act: req
        suffix: ""
        default: prim_mubi_pkg::MUBI4_DEFAULT
      }
      {
        package: ""
        struct: logic
        domain: Aon
        signame: pwrmgr_wakeups
        width: 3
        type: uni
        end_idx: -1
        act: rcv
        suffix: ""
        default: "'0"
      }
      {
        package: ""
        struct: logic
        domain: Aon
        signame: pwrmgr_rstreqs
        width: 2
        type: uni
        end_idx: -1
        act: rcv
        suffix: ""
        default: "'0"
      }
      {
        package: tlul_pkg
        struct: tl_h2d
        domain: Main
        signame: main_tl_rv_core_ibex__corei_req
        width: 1
        type: req_rsp
        end_idx: -1
        act: rsp
        suffix: req
        default: tlul_pkg::TL_H2D_DEFAULT
      }
      {
        package: tlul_pkg
        struct: tl_d2h
        domain: Main
        signame: main_tl_rv_core_ibex__corei_rsp
        width: 1
        type: req_rsp
        end_idx: -1
        act: rsp
        suffix: rsp
        default: ""
      }
      {
        package: tlul_pkg
        struct: tl_h2d
        domain: Main
        signame: main_tl_rv_core_ibex__cored_req
        width: 1
        type: req_rsp
        end_idx: -1
        act: rsp
        suffix: req
        default: tlul_pkg::TL_H2D_DEFAULT
      }
      {
        package: tlul_pkg
        struct: tl_d2h
        domain: Main
        signame: main_tl_rv_core_ibex__cored_rsp
        width: 1
        type: req_rsp
        end_idx: -1
        act: rsp
        suffix: rsp
        default: ""
      }
      {
        package: tlul_pkg
        struct: tl_h2d
        domain: Main
        signame: main_tl_rv_dm__sba_req
        width: 1
        type: req_rsp
        end_idx: -1
        act: rsp
        suffix: req
        default: tlul_pkg::TL_H2D_DEFAULT
      }
      {
        package: tlul_pkg
        struct: tl_d2h
        domain: Main
        signame: main_tl_rv_dm__sba_rsp
        width: 1
        type: req_rsp
        end_idx: -1
        act: rsp
        suffix: rsp
        default: ""
      }
      {
        package: tlul_pkg
        struct: tl_h2d
        domain: Main
        signame: rv_dm_regs_tl_d_req
        width: 1
        type: req_rsp
        end_idx: -1
        act: rsp
        suffix: req
        default: tlul_pkg::TL_H2D_DEFAULT
      }
      {
        package: tlul_pkg
        struct: tl_d2h
        domain: Main
        signame: rv_dm_regs_tl_d_rsp
        width: 1
        type: req_rsp
        end_idx: -1
        act: rsp
        suffix: rsp
        default: ""
      }
      {
        package: tlul_pkg
        struct: tl_h2d
        domain: Main
        signame: rv_dm_mem_tl_d_req
        width: 1
        type: req_rsp
        end_idx: -1
        act: rsp
        suffix: req
        default: tlul_pkg::TL_H2D_DEFAULT
      }
      {
        package: tlul_pkg
        struct: tl_d2h
        domain: Main
        signame: rv_dm_mem_tl_d_rsp
        width: 1
        type: req_rsp
        end_idx: -1
        act: rsp
        suffix: rsp
        default: ""
      }
      {
        package: tlul_pkg
        struct: tl_h2d
        domain: Main
        signame: rom_ctrl0_rom_tl_req
        width: 1
        type: req_rsp
        end_idx: -1
        act: rsp
        suffix: req
        default: tlul_pkg::TL_H2D_DEFAULT
      }
      {
        package: tlul_pkg
        struct: tl_d2h
        domain: Main
        signame: rom_ctrl0_rom_tl_rsp
        width: 1
        type: req_rsp
        end_idx: -1
        act: rsp
        suffix: rsp
        default: ""
      }
      {
        package: tlul_pkg
        struct: tl_h2d
        domain: Main
        signame: rom_ctrl0_regs_tl_req
        width: 1
        type: req_rsp
        end_idx: -1
        act: rsp
        suffix: req
        default: tlul_pkg::TL_H2D_DEFAULT
      }
      {
        package: tlul_pkg
        struct: tl_d2h
        domain: Main
        signame: rom_ctrl0_regs_tl_rsp
        width: 1
        type: req_rsp
        end_idx: -1
        act: rsp
        suffix: rsp
        default: ""
      }
      {
        package: tlul_pkg
        struct: tl_h2d
        domain: Main
        signame: rom_ctrl1_rom_tl_req
        width: 1
        type: req_rsp
        end_idx: -1
        act: rsp
        suffix: req
        default: tlul_pkg::TL_H2D_DEFAULT
      }
      {
        package: tlul_pkg
        struct: tl_d2h
        domain: Main
        signame: rom_ctrl1_rom_tl_rsp
        width: 1
        type: req_rsp
        end_idx: -1
        act: rsp
        suffix: rsp
        default: ""
      }
      {
        package: tlul_pkg
        struct: tl_h2d
        domain: Main
        signame: rom_ctrl1_regs_tl_req
        width: 1
        type: req_rsp
        end_idx: -1
        act: rsp
        suffix: req
        default: tlul_pkg::TL_H2D_DEFAULT
      }
      {
        package: tlul_pkg
        struct: tl_d2h
        domain: Main
        signame: rom_ctrl1_regs_tl_rsp
        width: 1
        type: req_rsp
        end_idx: -1
        act: rsp
        suffix: rsp
        default: ""
      }
      {
        package: tlul_pkg
        struct: tl_h2d
        domain: Main
        signame: main_tl_peri_req
        width: 1
        type: req_rsp
        end_idx: -1
        act: req
        suffix: req
        default: ""
      }
      {
        package: tlul_pkg
        struct: tl_d2h
        domain: Main
        signame: main_tl_peri_rsp
        width: 1
        type: req_rsp
        end_idx: -1
        act: req
        suffix: rsp
        default: tlul_pkg::TL_D2H_DEFAULT
      }
      {
        package: tlul_pkg
        struct: tl_h2d
        domain: Main
        signame: hmac_tl_req
        width: 1
        type: req_rsp
        end_idx: -1
        act: rsp
        suffix: req
        default: tlul_pkg::TL_H2D_DEFAULT
      }
      {
        package: tlul_pkg
        struct: tl_d2h
        domain: Main
        signame: hmac_tl_rsp
        width: 1
        type: req_rsp
        end_idx: -1
        act: rsp
        suffix: rsp
        default: ""
      }
      {
        package: tlul_pkg
        struct: tl_h2d
        domain: Main
        signame: kmac_tl_req
        width: 1
        type: req_rsp
        end_idx: -1
        act: rsp
        suffix: req
        default: tlul_pkg::TL_H2D_DEFAULT
      }
      {
        package: tlul_pkg
        struct: tl_d2h
        domain: Main
        signame: kmac_tl_rsp
        width: 1
        type: req_rsp
        end_idx: -1
        act: rsp
        suffix: rsp
        default: ""
      }
      {
        package: tlul_pkg
        struct: tl_h2d
        domain: Main
        signame: aes_tl_req
        width: 1
        type: req_rsp
        end_idx: -1
        act: rsp
        suffix: req
        default: tlul_pkg::TL_H2D_DEFAULT
      }
      {
        package: tlul_pkg
        struct: tl_d2h
        domain: Main
        signame: aes_tl_rsp
        width: 1
        type: req_rsp
        end_idx: -1
        act: rsp
        suffix: rsp
        default: ""
      }
      {
        package: tlul_pkg
        struct: tl_h2d
        domain: Main
        signame: entropy_src_tl_req
        width: 1
        type: req_rsp
        end_idx: -1
        act: rsp
        suffix: req
        default: tlul_pkg::TL_H2D_DEFAULT
      }
      {
        package: tlul_pkg
        struct: tl_d2h
        domain: Main
        signame: entropy_src_tl_rsp
        width: 1
        type: req_rsp
        end_idx: -1
        act: rsp
        suffix: rsp
        default: ""
      }
      {
        package: tlul_pkg
        struct: tl_h2d
        domain: Main
        signame: csrng_tl_req
        width: 1
        type: req_rsp
        end_idx: -1
        act: rsp
        suffix: req
        default: tlul_pkg::TL_H2D_DEFAULT
      }
      {
        package: tlul_pkg
        struct: tl_d2h
        domain: Main
        signame: csrng_tl_rsp
        width: 1
        type: req_rsp
        end_idx: -1
        act: rsp
        suffix: rsp
        default: ""
      }
      {
        package: tlul_pkg
        struct: tl_h2d
        domain: Main
        signame: edn0_tl_req
        width: 1
        type: req_rsp
        end_idx: -1
        act: rsp
        suffix: req
        default: tlul_pkg::TL_H2D_DEFAULT
      }
      {
        package: tlul_pkg
        struct: tl_d2h
        domain: Main
        signame: edn0_tl_rsp
        width: 1
        type: req_rsp
        end_idx: -1
        act: rsp
        suffix: rsp
        default: ""
      }
      {
        package: tlul_pkg
        struct: tl_h2d
        domain: Main
        signame: edn1_tl_req
        width: 1
        type: req_rsp
        end_idx: -1
        act: rsp
        suffix: req
        default: tlul_pkg::TL_H2D_DEFAULT
      }
      {
        package: tlul_pkg
        struct: tl_d2h
        domain: Main
        signame: edn1_tl_rsp
        width: 1
        type: req_rsp
        end_idx: -1
        act: rsp
        suffix: rsp
        default: ""
      }
      {
        package: tlul_pkg
        struct: tl_h2d
        domain: Main
        signame: rv_plic_tl_req
        width: 1
        type: req_rsp
        end_idx: -1
        act: rsp
        suffix: req
        default: tlul_pkg::TL_H2D_DEFAULT
      }
      {
        package: tlul_pkg
        struct: tl_d2h
        domain: Main
        signame: rv_plic_tl_rsp
        width: 1
        type: req_rsp
        end_idx: -1
        act: rsp
        suffix: rsp
        default: ""
      }
      {
        package: tlul_pkg
        struct: tl_h2d
        domain: Main
        signame: otbn_tl_req
        width: 1
        type: req_rsp
        end_idx: -1
        act: rsp
        suffix: req
        default: tlul_pkg::TL_H2D_DEFAULT
      }
      {
        package: tlul_pkg
        struct: tl_d2h
        domain: Main
        signame: otbn_tl_rsp
        width: 1
        type: req_rsp
        end_idx: -1
        act: rsp
        suffix: rsp
        default: ""
      }
      {
        package: tlul_pkg
        struct: tl_h2d
        domain: Main
        signame: keymgr_dpe_tl_req
        width: 1
        type: req_rsp
        end_idx: -1
        act: rsp
        suffix: req
        default: tlul_pkg::TL_H2D_DEFAULT
      }
      {
        package: tlul_pkg
        struct: tl_d2h
        domain: Main
        signame: keymgr_dpe_tl_rsp
        width: 1
        type: req_rsp
        end_idx: -1
        act: rsp
        suffix: rsp
        default: ""
      }
      {
        package: tlul_pkg
        struct: tl_h2d
        domain: Main
        signame: rv_core_ibex_cfg_tl_d_req
        width: 1
        type: req_rsp
        end_idx: -1
        act: rsp
        suffix: req
        default: tlul_pkg::TL_H2D_DEFAULT
      }
      {
        package: tlul_pkg
        struct: tl_d2h
        domain: Main
        signame: rv_core_ibex_cfg_tl_d_rsp
        width: 1
        type: req_rsp
        end_idx: -1
        act: rsp
        suffix: rsp
        default: ""
      }
      {
        package: tlul_pkg
        struct: tl_h2d
        domain: Main
        signame: sram_ctrl_main_regs_tl_req
        width: 1
        type: req_rsp
        end_idx: -1
        act: rsp
        suffix: req
        default: tlul_pkg::TL_H2D_DEFAULT
      }
      {
        package: tlul_pkg
        struct: tl_d2h
        domain: Main
        signame: sram_ctrl_main_regs_tl_rsp
        width: 1
        type: req_rsp
        end_idx: -1
        act: rsp
        suffix: rsp
        default: ""
      }
      {
        package: tlul_pkg
        struct: tl_h2d
        domain: Main
        signame: sram_ctrl_main_ram_tl_req
        width: 1
        type: req_rsp
        end_idx: -1
        act: rsp
        suffix: req
        default: tlul_pkg::TL_H2D_DEFAULT
      }
      {
        package: tlul_pkg
        struct: tl_d2h
        domain: Main
        signame: sram_ctrl_main_ram_tl_rsp
        width: 1
        type: req_rsp
        end_idx: -1
        act: rsp
        suffix: rsp
        default: ""
      }
      {
        package: tlul_pkg
        struct: tl_h2d
        domain: Main
        signame: sram_ctrl_mbox_regs_tl_req
        width: 1
        type: req_rsp
        end_idx: -1
        act: rsp
        suffix: req
        default: tlul_pkg::TL_H2D_DEFAULT
      }
      {
        package: tlul_pkg
        struct: tl_d2h
        domain: Main
        signame: sram_ctrl_mbox_regs_tl_rsp
        width: 1
        type: req_rsp
        end_idx: -1
        act: rsp
        suffix: rsp
        default: ""
      }
      {
        package: tlul_pkg
        struct: tl_h2d
        domain: Main
        signame: sram_ctrl_mbox_ram_tl_req
        width: 1
        type: req_rsp
        end_idx: -1
        act: rsp
        suffix: req
        default: tlul_pkg::TL_H2D_DEFAULT
      }
      {
        package: tlul_pkg
        struct: tl_d2h
        domain: Main
        signame: sram_ctrl_mbox_ram_tl_rsp
        width: 1
        type: req_rsp
        end_idx: -1
        act: rsp
        suffix: rsp
        default: ""
      }
      {
        package: tlul_pkg
        struct: tl_h2d
        domain: Main
        signame: dma_tl_d_req
        width: 1
        type: req_rsp
        end_idx: -1
        act: rsp
        suffix: req
        default: tlul_pkg::TL_H2D_DEFAULT
      }
      {
        package: tlul_pkg
        struct: tl_d2h
        domain: Main
        signame: dma_tl_d_rsp
        width: 1
        type: req_rsp
        end_idx: -1
        act: rsp
        suffix: rsp
        default: ""
      }
      {
        package: tlul_pkg
        struct: tl_h2d
        domain: Main
        signame: main_tl_dma__host_req
        width: 1
        type: req_rsp
        end_idx: -1
        act: rsp
        suffix: req
        default: tlul_pkg::TL_H2D_DEFAULT
      }
      {
        package: tlul_pkg
        struct: tl_d2h
        domain: Main
        signame: main_tl_dma__host_rsp
        width: 1
        type: req_rsp
        end_idx: -1
        act: rsp
        suffix: rsp
        default: ""
      }
      {
        package: tlul_pkg
        struct: tl_h2d
        domain: Main
        signame: mbx0_core_tl_d_req
        width: 1
        type: req_rsp
        end_idx: -1
        act: rsp
        suffix: req
        default: tlul_pkg::TL_H2D_DEFAULT
      }
      {
        package: tlul_pkg
        struct: tl_d2h
        domain: Main
        signame: mbx0_core_tl_d_rsp
        width: 1
        type: req_rsp
        end_idx: -1
        act: rsp
        suffix: rsp
        default: ""
      }
      {
        package: tlul_pkg
        struct: tl_h2d
        domain: Main
        signame: main_tl_mbx0__sram_req
        width: 1
        type: req_rsp
        end_idx: -1
        act: rsp
        suffix: req
        default: tlul_pkg::TL_H2D_DEFAULT
      }
      {
        package: tlul_pkg
        struct: tl_d2h
        domain: Main
        signame: main_tl_mbx0__sram_rsp
        width: 1
        type: req_rsp
        end_idx: -1
        act: rsp
        suffix: rsp
        default: ""
      }
      {
        package: tlul_pkg
        struct: tl_h2d
        domain: Main
        signame: mbx1_core_tl_d_req
        width: 1
        type: req_rsp
        end_idx: -1
        act: rsp
        suffix: req
        default: tlul_pkg::TL_H2D_DEFAULT
      }
      {
        package: tlul_pkg
        struct: tl_d2h
        domain: Main
        signame: mbx1_core_tl_d_rsp
        width: 1
        type: req_rsp
        end_idx: -1
        act: rsp
        suffix: rsp
        default: ""
      }
      {
        package: tlul_pkg
        struct: tl_h2d
        domain: Main
        signame: main_tl_mbx1__sram_req
        width: 1
        type: req_rsp
        end_idx: -1
        act: rsp
        suffix: req
        default: tlul_pkg::TL_H2D_DEFAULT
      }
      {
        package: tlul_pkg
        struct: tl_d2h
        domain: Main
        signame: main_tl_mbx1__sram_rsp
        width: 1
        type: req_rsp
        end_idx: -1
        act: rsp
        suffix: rsp
        default: ""
      }
      {
        package: tlul_pkg
        struct: tl_h2d
        domain: Main
        signame: mbx2_core_tl_d_req
        width: 1
        type: req_rsp
        end_idx: -1
        act: rsp
        suffix: req
        default: tlul_pkg::TL_H2D_DEFAULT
      }
      {
        package: tlul_pkg
        struct: tl_d2h
        domain: Main
        signame: mbx2_core_tl_d_rsp
        width: 1
        type: req_rsp
        end_idx: -1
        act: rsp
        suffix: rsp
        default: ""
      }
      {
        package: tlul_pkg
        struct: tl_h2d
        domain: Main
        signame: main_tl_mbx2__sram_req
        width: 1
        type: req_rsp
        end_idx: -1
        act: rsp
        suffix: req
        default: tlul_pkg::TL_H2D_DEFAULT
      }
      {
        package: tlul_pkg
        struct: tl_d2h
        domain: Main
        signame: main_tl_mbx2__sram_rsp
        width: 1
        type: req_rsp
        end_idx: -1
        act: rsp
        suffix: rsp
        default: ""
      }
      {
        package: tlul_pkg
        struct: tl_h2d
        domain: Main
        signame: mbx3_core_tl_d_req
        width: 1
        type: req_rsp
        end_idx: -1
        act: rsp
        suffix: req
        default: tlul_pkg::TL_H2D_DEFAULT
      }
      {
        package: tlul_pkg
        struct: tl_d2h
        domain: Main
        signame: mbx3_core_tl_d_rsp
        width: 1
        type: req_rsp
        end_idx: -1
        act: rsp
        suffix: rsp
        default: ""
      }
      {
        package: tlul_pkg
        struct: tl_h2d
        domain: Main
        signame: main_tl_mbx3__sram_req
        width: 1
        type: req_rsp
        end_idx: -1
        act: rsp
        suffix: req
        default: tlul_pkg::TL_H2D_DEFAULT
      }
      {
        package: tlul_pkg
        struct: tl_d2h
        domain: Main
        signame: main_tl_mbx3__sram_rsp
        width: 1
        type: req_rsp
        end_idx: -1
        act: rsp
        suffix: rsp
        default: ""
      }
      {
        package: tlul_pkg
        struct: tl_h2d
        domain: Main
        signame: mbx4_core_tl_d_req
        width: 1
        type: req_rsp
        end_idx: -1
        act: rsp
        suffix: req
        default: tlul_pkg::TL_H2D_DEFAULT
      }
      {
        package: tlul_pkg
        struct: tl_d2h
        domain: Main
        signame: mbx4_core_tl_d_rsp
        width: 1
        type: req_rsp
        end_idx: -1
        act: rsp
        suffix: rsp
        default: ""
      }
      {
        package: tlul_pkg
        struct: tl_h2d
        domain: Main
        signame: main_tl_mbx4__sram_req
        width: 1
        type: req_rsp
        end_idx: -1
        act: rsp
        suffix: req
        default: tlul_pkg::TL_H2D_DEFAULT
      }
      {
        package: tlul_pkg
        struct: tl_d2h
        domain: Main
        signame: main_tl_mbx4__sram_rsp
        width: 1
        type: req_rsp
        end_idx: -1
        act: rsp
        suffix: rsp
        default: ""
      }
      {
        package: tlul_pkg
        struct: tl_h2d
        domain: Main
        signame: mbx5_core_tl_d_req
        width: 1
        type: req_rsp
        end_idx: -1
        act: rsp
        suffix: req
        default: tlul_pkg::TL_H2D_DEFAULT
      }
      {
        package: tlul_pkg
        struct: tl_d2h
        domain: Main
        signame: mbx5_core_tl_d_rsp
        width: 1
        type: req_rsp
        end_idx: -1
        act: rsp
        suffix: rsp
        default: ""
      }
      {
        package: tlul_pkg
        struct: tl_h2d
        domain: Main
        signame: main_tl_mbx5__sram_req
        width: 1
        type: req_rsp
        end_idx: -1
        act: rsp
        suffix: req
        default: tlul_pkg::TL_H2D_DEFAULT
      }
      {
        package: tlul_pkg
        struct: tl_d2h
        domain: Main
        signame: main_tl_mbx5__sram_rsp
        width: 1
        type: req_rsp
        end_idx: -1
        act: rsp
        suffix: rsp
        default: ""
      }
      {
        package: tlul_pkg
        struct: tl_h2d
        domain: Main
        signame: mbx6_core_tl_d_req
        width: 1
        type: req_rsp
        end_idx: -1
        act: rsp
        suffix: req
        default: tlul_pkg::TL_H2D_DEFAULT
      }
      {
        package: tlul_pkg
        struct: tl_d2h
        domain: Main
        signame: mbx6_core_tl_d_rsp
        width: 1
        type: req_rsp
        end_idx: -1
        act: rsp
        suffix: rsp
        default: ""
      }
      {
        package: tlul_pkg
        struct: tl_h2d
        domain: Main
        signame: main_tl_mbx6__sram_req
        width: 1
        type: req_rsp
        end_idx: -1
        act: rsp
        suffix: req
        default: tlul_pkg::TL_H2D_DEFAULT
      }
      {
        package: tlul_pkg
        struct: tl_d2h
        domain: Main
        signame: main_tl_mbx6__sram_rsp
        width: 1
        type: req_rsp
        end_idx: -1
        act: rsp
        suffix: rsp
        default: ""
      }
      {
        package: tlul_pkg
        struct: tl_h2d
        domain: Main
        signame: mbx_jtag_core_tl_d_req
        width: 1
        type: req_rsp
        end_idx: -1
        act: rsp
        suffix: req
        default: tlul_pkg::TL_H2D_DEFAULT
      }
      {
        package: tlul_pkg
        struct: tl_d2h
        domain: Main
        signame: mbx_jtag_core_tl_d_rsp
        width: 1
        type: req_rsp
        end_idx: -1
        act: rsp
        suffix: rsp
        default: ""
      }
      {
        package: tlul_pkg
        struct: tl_h2d
        domain: Main
        signame: main_tl_mbx_jtag__sram_req
        width: 1
        type: req_rsp
        end_idx: -1
        act: rsp
        suffix: req
        default: tlul_pkg::TL_H2D_DEFAULT
      }
      {
        package: tlul_pkg
        struct: tl_d2h
        domain: Main
        signame: main_tl_mbx_jtag__sram_rsp
        width: 1
        type: req_rsp
        end_idx: -1
        act: rsp
        suffix: rsp
        default: ""
      }
      {
        package: tlul_pkg
        struct: tl_h2d
        domain: Main
        signame: mbx_pcie0_core_tl_d_req
        width: 1
        type: req_rsp
        end_idx: -1
        act: rsp
        suffix: req
        default: tlul_pkg::TL_H2D_DEFAULT
      }
      {
        package: tlul_pkg
        struct: tl_d2h
        domain: Main
        signame: mbx_pcie0_core_tl_d_rsp
        width: 1
        type: req_rsp
        end_idx: -1
        act: rsp
        suffix: rsp
        default: ""
      }
      {
        package: tlul_pkg
        struct: tl_h2d
        domain: Main
        signame: main_tl_mbx_pcie0__sram_req
        width: 1
        type: req_rsp
        end_idx: -1
        act: rsp
        suffix: req
        default: tlul_pkg::TL_H2D_DEFAULT
      }
      {
        package: tlul_pkg
        struct: tl_d2h
        domain: Main
        signame: main_tl_mbx_pcie0__sram_rsp
        width: 1
        type: req_rsp
        end_idx: -1
        act: rsp
        suffix: rsp
        default: ""
      }
      {
        package: tlul_pkg
        struct: tl_h2d
        domain: Main
        signame: mbx_pcie1_core_tl_d_req
        width: 1
        type: req_rsp
        end_idx: -1
        act: rsp
        suffix: req
        default: tlul_pkg::TL_H2D_DEFAULT
      }
      {
        package: tlul_pkg
        struct: tl_d2h
        domain: Main
        signame: mbx_pcie1_core_tl_d_rsp
        width: 1
        type: req_rsp
        end_idx: -1
        act: rsp
        suffix: rsp
        default: ""
      }
      {
        package: tlul_pkg
        struct: tl_h2d
        domain: Main
        signame: main_tl_mbx_pcie1__sram_req
        width: 1
        type: req_rsp
        end_idx: -1
        act: rsp
        suffix: req
        default: tlul_pkg::TL_H2D_DEFAULT
      }
      {
        package: tlul_pkg
        struct: tl_d2h
        domain: Main
        signame: main_tl_mbx_pcie1__sram_rsp
        width: 1
        type: req_rsp
        end_idx: -1
        act: rsp
        suffix: rsp
        default: ""
      }
      {
        package: tlul_pkg
        struct: tl_h2d
        domain: Main
        signame: uart0_tl_req
        width: 1
        type: req_rsp
        end_idx: -1
        act: rsp
        suffix: req
        default: tlul_pkg::TL_H2D_DEFAULT
      }
      {
        package: tlul_pkg
        struct: tl_d2h
        domain: Main
        signame: uart0_tl_rsp
        width: 1
        type: req_rsp
        end_idx: -1
        act: rsp
        suffix: rsp
        default: ""
      }
      {
        package: tlul_pkg
        struct: tl_h2d
        domain: Main
        signame: i2c0_tl_req
        width: 1
        type: req_rsp
        end_idx: -1
        act: rsp
        suffix: req
        default: tlul_pkg::TL_H2D_DEFAULT
      }
      {
        package: tlul_pkg
        struct: tl_d2h
        domain: Main
        signame: i2c0_tl_rsp
        width: 1
        type: req_rsp
        end_idx: -1
        act: rsp
        suffix: rsp
        default: ""
      }
      {
        package: tlul_pkg
        struct: tl_h2d
        domain: Main
        signame: gpio0_tl_req
        width: 1
        type: req_rsp
        end_idx: -1
        act: rsp
        suffix: req
        default: tlul_pkg::TL_H2D_DEFAULT
      }
      {
        package: tlul_pkg
        struct: tl_d2h
        domain: Main
        signame: gpio0_tl_rsp
        width: 1
        type: req_rsp
        end_idx: -1
        act: rsp
        suffix: rsp
        default: ""
      }
      {
        package: tlul_pkg
        struct: tl_h2d
        domain: Main
        signame: spi_host0_tl_req
        width: 1
        type: req_rsp
        end_idx: -1
        act: rsp
        suffix: req
        default: tlul_pkg::TL_H2D_DEFAULT
      }
      {
        package: tlul_pkg
        struct: tl_d2h
        domain: Main
        signame: spi_host0_tl_rsp
        width: 1
        type: req_rsp
        end_idx: -1
        act: rsp
        suffix: rsp
        default: ""
      }
      {
        package: tlul_pkg
        struct: tl_h2d
        domain: Main
        signame: spi_device_tl_req
        width: 1
        type: req_rsp
        end_idx: -1
        act: rsp
        suffix: req
        default: tlul_pkg::TL_H2D_DEFAULT
      }
      {
        package: tlul_pkg
        struct: tl_d2h
        domain: Main
        signame: spi_device_tl_rsp
        width: 1
        type: req_rsp
        end_idx: -1
        act: rsp
        suffix: rsp
        default: ""
      }
      {
        package: tlul_pkg
        struct: tl_h2d
        domain: Main
        signame: rv_timer_tl_req
        width: 1
        type: req_rsp
        end_idx: -1
        act: rsp
        suffix: req
        default: tlul_pkg::TL_H2D_DEFAULT
      }
      {
        package: tlul_pkg
        struct: tl_d2h
        domain: Main
        signame: rv_timer_tl_rsp
        width: 1
        type: req_rsp
        end_idx: -1
        act: rsp
        suffix: rsp
        default: ""
      }
      {
        package: tlul_pkg
        struct: tl_h2d
        domain: Main
        signame: pinmux_tl_req
        width: 1
        type: req_rsp
        end_idx: -1
        act: rsp
        suffix: req
        default: tlul_pkg::TL_H2D_DEFAULT
      }
      {
        package: tlul_pkg
        struct: tl_d2h
        domain: Main
        signame: pinmux_tl_rsp
        width: 1
        type: req_rsp
        end_idx: -1
        act: rsp
        suffix: rsp
        default: ""
      }
      {
        package: tlul_pkg
        struct: tl_h2d
        domain: Main
        signame: otp_ctrl_core_tl_req
        width: 1
        type: req_rsp
        end_idx: -1
        act: rsp
        suffix: req
        default: tlul_pkg::TL_H2D_DEFAULT
      }
      {
        package: tlul_pkg
        struct: tl_d2h
        domain: Main
        signame: otp_ctrl_core_tl_rsp
        width: 1
        type: req_rsp
        end_idx: -1
        act: rsp
        suffix: rsp
        default: ""
      }
      {
        package: tlul_pkg
        struct: tl_h2d
        domain: Main
        signame: otp_macro_prim_tl_req
        width: 1
        type: req_rsp
        end_idx: -1
        act: rsp
        suffix: req
        default: tlul_pkg::TL_H2D_DEFAULT
      }
      {
        package: tlul_pkg
        struct: tl_d2h
        domain: Main
        signame: otp_macro_prim_tl_rsp
        width: 1
        type: req_rsp
        end_idx: -1
        act: rsp
        suffix: rsp
        default: ""
      }
      {
        package: tlul_pkg
        struct: tl_h2d
        domain: Main
        signame: lc_ctrl_regs_tl_req
        width: 1
        type: req_rsp
        end_idx: -1
        act: rsp
        suffix: req
        default: tlul_pkg::TL_H2D_DEFAULT
      }
      {
        package: tlul_pkg
        struct: tl_d2h
        domain: Main
        signame: lc_ctrl_regs_tl_rsp
        width: 1
        type: req_rsp
        end_idx: -1
        act: rsp
        suffix: rsp
        default: ""
      }
      {
        package: tlul_pkg
        struct: tl_h2d
        domain: Main
        signame: alert_handler_tl_req
        width: 1
        type: req_rsp
        end_idx: -1
        act: rsp
        suffix: req
        default: tlul_pkg::TL_H2D_DEFAULT
      }
      {
        package: tlul_pkg
        struct: tl_d2h
        domain: Main
        signame: alert_handler_tl_rsp
        width: 1
        type: req_rsp
        end_idx: -1
        act: rsp
        suffix: rsp
        default: ""
      }
      {
        package: tlul_pkg
        struct: tl_h2d
        domain: Main
        signame: soc_dbg_ctrl_core_tl_req
        width: 1
        type: req_rsp
        end_idx: -1
        act: rsp
        suffix: req
        default: tlul_pkg::TL_H2D_DEFAULT
      }
      {
        package: tlul_pkg
        struct: tl_d2h
        domain: Main
        signame: soc_dbg_ctrl_core_tl_rsp
        width: 1
        type: req_rsp
        end_idx: -1
        act: rsp
        suffix: rsp
        default: ""
      }
      {
        package: tlul_pkg
        struct: tl_h2d
        domain: Main
        signame: mbx0_soc_tl_d_req
        width: 1
        type: req_rsp
        end_idx: -1
        act: rsp
        suffix: req
        default: tlul_pkg::TL_H2D_DEFAULT
      }
      {
        package: tlul_pkg
        struct: tl_d2h
        domain: Main
        signame: mbx0_soc_tl_d_rsp
        width: 1
        type: req_rsp
        end_idx: -1
        act: rsp
        suffix: rsp
        default: ""
      }
      {
        package: tlul_pkg
        struct: tl_h2d
        domain: Main
        signame: mbx1_soc_tl_d_req
        width: 1
        type: req_rsp
        end_idx: -1
        act: rsp
        suffix: req
        default: tlul_pkg::TL_H2D_DEFAULT
      }
      {
        package: tlul_pkg
        struct: tl_d2h
        domain: Main
        signame: mbx1_soc_tl_d_rsp
        width: 1
        type: req_rsp
        end_idx: -1
        act: rsp
        suffix: rsp
        default: ""
      }
      {
        package: tlul_pkg
        struct: tl_h2d
        domain: Main
        signame: mbx2_soc_tl_d_req
        width: 1
        type: req_rsp
        end_idx: -1
        act: rsp
        suffix: req
        default: tlul_pkg::TL_H2D_DEFAULT
      }
      {
        package: tlul_pkg
        struct: tl_d2h
        domain: Main
        signame: mbx2_soc_tl_d_rsp
        width: 1
        type: req_rsp
        end_idx: -1
        act: rsp
        suffix: rsp
        default: ""
      }
      {
        package: tlul_pkg
        struct: tl_h2d
        domain: Main
        signame: mbx3_soc_tl_d_req
        width: 1
        type: req_rsp
        end_idx: -1
        act: rsp
        suffix: req
        default: tlul_pkg::TL_H2D_DEFAULT
      }
      {
        package: tlul_pkg
        struct: tl_d2h
        domain: Main
        signame: mbx3_soc_tl_d_rsp
        width: 1
        type: req_rsp
        end_idx: -1
        act: rsp
        suffix: rsp
        default: ""
      }
      {
        package: tlul_pkg
        struct: tl_h2d
        domain: Main
        signame: mbx4_soc_tl_d_req
        width: 1
        type: req_rsp
        end_idx: -1
        act: rsp
        suffix: req
        default: tlul_pkg::TL_H2D_DEFAULT
      }
      {
        package: tlul_pkg
        struct: tl_d2h
        domain: Main
        signame: mbx4_soc_tl_d_rsp
        width: 1
        type: req_rsp
        end_idx: -1
        act: rsp
        suffix: rsp
        default: ""
      }
      {
        package: tlul_pkg
        struct: tl_h2d
        domain: Main
        signame: mbx5_soc_tl_d_req
        width: 1
        type: req_rsp
        end_idx: -1
        act: rsp
        suffix: req
        default: tlul_pkg::TL_H2D_DEFAULT
      }
      {
        package: tlul_pkg
        struct: tl_d2h
        domain: Main
        signame: mbx5_soc_tl_d_rsp
        width: 1
        type: req_rsp
        end_idx: -1
        act: rsp
        suffix: rsp
        default: ""
      }
      {
        package: tlul_pkg
        struct: tl_h2d
        domain: Main
        signame: mbx6_soc_tl_d_req
        width: 1
        type: req_rsp
        end_idx: -1
        act: rsp
        suffix: req
        default: tlul_pkg::TL_H2D_DEFAULT
      }
      {
        package: tlul_pkg
        struct: tl_d2h
        domain: Main
        signame: mbx6_soc_tl_d_rsp
        width: 1
        type: req_rsp
        end_idx: -1
        act: rsp
        suffix: rsp
        default: ""
      }
      {
        package: tlul_pkg
        struct: tl_h2d
        domain: Main
        signame: mbx_pcie0_soc_tl_d_req
        width: 1
        type: req_rsp
        end_idx: -1
        act: rsp
        suffix: req
        default: tlul_pkg::TL_H2D_DEFAULT
      }
      {
        package: tlul_pkg
        struct: tl_d2h
        domain: Main
        signame: mbx_pcie0_soc_tl_d_rsp
        width: 1
        type: req_rsp
        end_idx: -1
        act: rsp
        suffix: rsp
        default: ""
      }
      {
        package: tlul_pkg
        struct: tl_h2d
        domain: Main
        signame: mbx_pcie1_soc_tl_d_req
        width: 1
        type: req_rsp
        end_idx: -1
        act: rsp
        suffix: req
        default: tlul_pkg::TL_H2D_DEFAULT
      }
      {
        package: tlul_pkg
        struct: tl_d2h
        domain: Main
        signame: mbx_pcie1_soc_tl_d_rsp
        width: 1
        type: req_rsp
        end_idx: -1
        act: rsp
        suffix: rsp
        default: ""
      }
      {
        package: tlul_pkg
        struct: tl_h2d
        domain: Main
        signame: racl_ctrl_tl_req
        width: 1
        type: req_rsp
        end_idx: -1
        act: rsp
        suffix: req
        default: tlul_pkg::TL_H2D_DEFAULT
      }
      {
        package: tlul_pkg
        struct: tl_d2h
        domain: Main
        signame: racl_ctrl_tl_rsp
        width: 1
        type: req_rsp
        end_idx: -1
        act: rsp
        suffix: rsp
        default: ""
      }
      {
        package: tlul_pkg
        struct: tl_h2d
        domain: Main
        signame: ac_range_check_tl_req
        width: 1
        type: req_rsp
        end_idx: -1
        act: rsp
        suffix: req
        default: tlul_pkg::TL_H2D_DEFAULT
      }
      {
        package: tlul_pkg
        struct: tl_d2h
        domain: Main
        signame: ac_range_check_tl_rsp
        width: 1
        type: req_rsp
        end_idx: -1
        act: rsp
        suffix: rsp
        default: ""
      }
      {
        package: tlul_pkg
        struct: tl_h2d
        domain: Main
        signame: rv_dm_dbg_tl_d_req
        width: 1
        type: req_rsp
        end_idx: -1
        act: rsp
        suffix: req
        default: tlul_pkg::TL_H2D_DEFAULT
      }
      {
        package: tlul_pkg
        struct: tl_d2h
        domain: Main
        signame: rv_dm_dbg_tl_d_rsp
        width: 1
        type: req_rsp
        end_idx: -1
        act: rsp
        suffix: rsp
        default: ""
      }
      {
        package: tlul_pkg
        struct: tl_h2d
        domain: Main
        signame: mbx_jtag_soc_tl_d_req
        width: 1
        type: req_rsp
        end_idx: -1
        act: rsp
        suffix: req
        default: tlul_pkg::TL_H2D_DEFAULT
      }
      {
        package: tlul_pkg
        struct: tl_d2h
        domain: Main
        signame: mbx_jtag_soc_tl_d_rsp
        width: 1
        type: req_rsp
        end_idx: -1
        act: rsp
        suffix: rsp
        default: ""
      }
      {
        package: tlul_pkg
        struct: tl_h2d
        domain: Main
        signame: lc_ctrl_dmi_tl_req
        width: 1
        type: req_rsp
        end_idx: -1
        act: rsp
        suffix: req
        default: tlul_pkg::TL_H2D_DEFAULT
      }
      {
        package: tlul_pkg
        struct: tl_d2h
        domain: Main
        signame: lc_ctrl_dmi_tl_rsp
        width: 1
        type: req_rsp
        end_idx: -1
        act: rsp
        suffix: rsp
        default: ""
      }
      {
        package: tlul_pkg
        struct: tl_h2d
        domain: Main
        signame: soc_dbg_ctrl_jtag_tl_req
        width: 1
        type: req_rsp
        end_idx: -1
        act: rsp
        suffix: req
        default: tlul_pkg::TL_H2D_DEFAULT
      }
      {
        package: tlul_pkg
        struct: tl_d2h
        domain: Main
        signame: soc_dbg_ctrl_jtag_tl_rsp
        width: 1
        type: req_rsp
        end_idx: -1
        act: rsp
        suffix: rsp
        default: ""
      }
      {
        package: top_racl_pkg
        struct: racl_policy_vec
        domain: Main
        signame: racl_ctrl_racl_policies
        width: 1
        type: uni
        end_idx: -1
        act: req
        suffix: ""
        default: top_racl_pkg::RACL_POLICY_VEC_DEFAULT
      }
      {
        package: top_racl_pkg
        struct: racl_error_log
        domain: Main
        signame: racl_ctrl_racl_error
        width:
        {
          name: NumSubscribingIps
          desc: Number of subscribing RACL IPs
          param_type: int
          unpacked_dimensions: null
          default: 11
          local: true
          expose: true
          name_top: RaclCtrlNumSubscribingIps
        }
        type: uni
        end_idx: -1
        act: rcv
        suffix: ""
        default: "{RaclCtrlNumSubscribingIps{top_racl_pkg::RACL_ERROR_LOG_DEFAULT}}"
      }
      {
        package: clkmgr_pkg
        struct: clkmgr_out
        signame: clkmgr_clocks
        domain: Aon
        width: 1
        type: uni
        end_idx: -1
        default: ""
      }
      {
        package: clkmgr_pkg
        struct: clkmgr_cg_en
        signame: clkmgr_cg_en
        domain: Aon
        width: 1
        type: uni
        end_idx: -1
        default: ""
      }
      {
        package: rstmgr_pkg
        struct: rstmgr_out
        signame: rstmgr_resets
        domain: Aon
        width: 1
        type: uni
        end_idx: -1
        default: ""
      }
      {
        package: rstmgr_pkg
        struct: rstmgr_rst_en
        signame: rstmgr_rst_en
        domain: Aon
        width: 1
        type: uni
        end_idx: -1
        default: ""
      }
      {
        package: ""
        struct: logic
        signame: rv_core_ibex_irq_timer
        domain: Main
        width: 1
        type: uni
        end_idx: -1
        default: ""
      }
      {
        package: ""
        struct: logic
        signame: rv_core_ibex_hart_id
        domain: Main
        width: 32
        type: uni
        end_idx: -1
        default: ""
      }
      {
        package: ""
        struct: logic
        signame: rv_core_ibex_boot_addr
        domain: Main
        width: 32
        type: uni
        end_idx: -1
        default: ""
      }
      {
        package: otp_ctrl_part_pkg
        struct: otp_broadcast
        signame: otp_ctrl_otp_broadcast
        domain: Main
        width: 1
        type: uni
        end_idx: -1
        default: "'0"
      }
      {
        package: lc_ctrl_state_pkg
        struct: soc_dbg_state
        signame: soc_dbg_ctrl_soc_dbg_state
        domain: Main
        width: 1
        type: uni
        end_idx: -1
        default: ""
      }
      {
        package: otp_ctrl_pkg
        struct: otp_device_id
        signame: lc_ctrl_otp_device_id
        domain: Main
        width: 1
        type: uni
        end_idx: -1
        default: "'0"
      }
      {
        package: otp_ctrl_pkg
        struct: otp_manuf_state
        signame: lc_ctrl_otp_manuf_state
        domain: Main
        width: 1
        type: uni
        end_idx: -1
        default: "'0"
      }
      {
        package: keymgr_dpe_pkg
        struct: keymgr_dpe_device_id
        signame: keymgr_dpe_device_id
        domain: Main
        width: 1
        type: uni
        end_idx: -1
        default: ""
      }
      {
        package: prim_mubi_pkg
        struct: mubi8
        signame: sram_ctrl_main_otp_en_sram_ifetch
        domain: Main
        width: 1
        type: uni
        end_idx: -1
        default: prim_mubi_pkg::MuBi8False
      }
      {
        package: prim_mubi_pkg
        struct: mubi8
        signame: rv_dm_otp_dis_rv_dm_late_debug
        domain: Main
        width: 1
        type: uni
        end_idx: -1
        default: prim_mubi_pkg::MuBi8False
      }
    ]
  }
}
