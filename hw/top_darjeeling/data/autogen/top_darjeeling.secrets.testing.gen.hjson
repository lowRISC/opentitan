// Copyright lowRISC contributors (OpenTitan project).
// Licensed under the Apache License, Version 2.0, see LICENSE for details.
// SPDX-License-Identifier: Apache-2.0
//
// ------------------- W A R N I N G: A U T O - G E N E R A T E D   C O D E !! -------------------//
// PLEASE DO NOT HAND-EDIT THIS FILE. IT HAS BEEN AUTO-GENERATED WITH THE FOLLOWING COMMAND:
// util/topgen.py -t hw/top_darjeeling/data/top_darjeeling.hjson
//                -o hw/top_darjeeling/
{
  seed:
  {
    topgen_seed:
    {
      seed_mode: testing
      value: 30303603493614338660957087945302489777030192937656386903877022866265637632015
    }
    otp_img_seed:
    {
      seed_mode: testing
      value: 85452983286950371191603618368782861611109037138182535346147818831008789508651
    }
    lc_ctrl_seed:
    {
      seed_mode: testing
      value: 73183785937994765942105269559576336430731269166614113490738802526276329963158
    }
  }
  module:
  [
    {
      name: otp_ctrl
      type: otp_ctrl
      base_addrs:
      {
        core:
        {
          hart: 0x30130000
        }
      }
      memory: {}
      param_list:
      [
        {
          name: RndCnstLfsrSeed
          desc: Compile-time random bits for initial LFSR seed
          type: otp_ctrl_top_specific_pkg::lfsr_seed_t
          randcount: 40
          randtype: data
          name_top: RndCnstOtpCtrlLfsrSeed
          default: 0xeba4d1f0aa
          randwidth: 40
        }
        {
          name: RndCnstLfsrPerm
          desc: Compile-time random permutation for LFSR output
          type: otp_ctrl_top_specific_pkg::lfsr_perm_t
          randcount: 40
          randtype: perm
          name_top: RndCnstOtpCtrlLfsrPerm
          default: 0x1602c23d095a54e5dc2919044c019d6c70cd65e85f2098e70568a6512318
          randwidth: 240
        }
        {
          name: RndCnstScrmblKeyInit
          desc: Compile-time random permutation for scrambling key/nonce register reset value
          type: otp_ctrl_top_specific_pkg::scrmbl_key_init_t
          randcount: 256
          randtype: data
          name_top: RndCnstOtpCtrlScrmblKeyInit
          default: 0x2762e7af02fad0a0b00419df7239bc95afb3198caae47de9bb857ed548272082
          randwidth: 256
        }
        {
          name: RndCnstScrmblKey0
          desc: Compile-time scrambling key
          type: otp_ctrl_top_specific_pkg::key_t
          randcount: 128
          randtype: extdata
          name_top: RndCnstOtpCtrlScrmblKey0
          default: 0x688a9a20b68e0d35660e593f560f6866
          randwidth: 128
        }
        {
          name: RndCnstScrmblKey1
          desc: Compile-time scrambling key
          type: otp_ctrl_top_specific_pkg::key_t
          randcount: 128
          randtype: extdata
          name_top: RndCnstOtpCtrlScrmblKey1
          default: 0xa1ad90a50942397740ab78c5737a2379
          randwidth: 128
        }
        {
          name: RndCnstScrmblKey2
          desc: Compile-time scrambling key
          type: otp_ctrl_top_specific_pkg::key_t
          randcount: 128
          randtype: extdata
          name_top: RndCnstOtpCtrlScrmblKey2
          default: 0xc2ede5b25ec5514b680ccaab361c3f85
          randwidth: 128
        }
        {
          name: RndCnstScrmblKey3
          desc: Compile-time scrambling key
          type: otp_ctrl_top_specific_pkg::key_t
          randcount: 128
          randtype: extdata
          name_top: RndCnstOtpCtrlScrmblKey3
          default: 0x8e1c5cccc121a2c95d21294d190ab75c
          randwidth: 128
        }
        {
          name: RndCnstDigestConst0
          desc: Compile-time digest const
          type: otp_ctrl_top_specific_pkg::digest_const_t
          randcount: 128
          randtype: extdata
          name_top: RndCnstOtpCtrlDigestConst0
          default: 0x9c87e42745452d8a010a9f0ef3221d5
          randwidth: 128
        }
        {
          name: RndCnstDigestConst1
          desc: Compile-time digest const
          type: otp_ctrl_top_specific_pkg::digest_const_t
          randcount: 128
          randtype: extdata
          name_top: RndCnstOtpCtrlDigestConst1
          default: 0x4dcba329ff2f7d4b8a3acdb325087fab
          randwidth: 128
        }
        {
          name: RndCnstDigestIV0
          desc: Compile-time digest initial vector
          type: otp_ctrl_top_specific_pkg::digest_iv_t
          randcount: 64
          randtype: extdata
          name_top: RndCnstOtpCtrlDigestIV0
          default: 0xa0806e02a1fba55b
          randwidth: 64
        }
        {
          name: RndCnstDigestIV1
          desc: Compile-time digest initial vector
          type: otp_ctrl_top_specific_pkg::digest_iv_t
          randcount: 64
          randtype: extdata
          name_top: RndCnstOtpCtrlDigestIV1
          default: 0x9bd623e40aec9b61
          randwidth: 64
        }
        {
          name: RndCnstPartInvDefault
          desc: OTP invalid partition default for buffered partitions
          type: logic [131071:0]
          randcount: 131072
          randtype: extdata
          name_top: RndCnstOtpCtrlPartInvDefault
          default:
          [
            {
              size: 704
              items:
              [
                {
                  size: 320
                  inv_default: 1740163610035578858103898302773429044443128827890610586479008287934284440493394280935669489663884
                }
                {
                  size: 384
                  inv_default: 14973992796729436808066378999705846639531905052544376352002892737561959261552710366946253675634166805643724298065935
                }
              ]
            }
            {
              size: 384
              items:
              [
                {
                  size: 64
                  inv_default: 0
                }
                {
                  size: 64
                  inv_default: 13418438502867544032
                }
                {
                  size: 256
                  inv_default: 70686486377297932620694155829978992075095653265301635643322899792586608109306
                }
              ]
            }
            {
              size: 1024
              items:
              [
                {
                  size: 64
                  inv_default: 0
                }
                {
                  size: 64
                  inv_default: 6520999107440904866
                }
                {
                  size: 256
                  inv_default: 17833865895625802678504757898438306129490488436729400947978243968268591742052
                }
                {
                  size: 256
                  inv_default: 1304928998077618167994330237584170289335028615580548538480488972898025704836
                }
                {
                  size: 256
                  inv_default: 34629914360704372211018394036838819133727768471239971144446686782216090585462
                }
                {
                  size: 128
                  inv_default: 318948098383762964490193881142352172697
                }
              ]
            }
            {
              size: 256
              items:
              [
                {
                  size: 64
                  inv_default: 0
                }
                {
                  size: 64
                  inv_default: 9694113004490520906
                }
                {
                  size: 128
                  inv_default: 49610584572420053792236730456054518552
                }
              ]
            }
            {
              size: 384
              items:
              [
                {
                  size: 64
                  inv_default: 0
                }
                {
                  size: 64
                  inv_default: 15994060125354592494
                }
                {
                  size: 128
                  inv_default: 241193388044955693821746483131132302114
                }
                {
                  size: 128
                  inv_default: 42146219275086284332081154515457931983
                }
              ]
            }
            {
              size: 128
              items:
              [
                {
                  size: 64
                  inv_default: 2245725931179433842
                }
                {
                  comment: unallocated space
                  size: 16
                  inv_default: 0
                }
                {
                  size: 8
                  inv_default: 105
                }
                {
                  size: 8
                  inv_default: 105
                }
                {
                  size: 32
                  inv_default: 0
                }
              ]
            }
            {
              size: 576
              items:
              [
                {
                  size: 64
                  inv_default: 8050338520295093693
                }
                {
                  size: 256
                  inv_default: 104735823630885006896435419055152518946049592294862500793111622154345667968901
                }
                {
                  size: 256
                  inv_default: 40117173308102545085356168480633505499540504862520500713288653871548071919464
                }
              ]
            }
            {
              size: 78848
              items:
              [
                {
                  size: 64
                  inv_default: 14592557388175589354
                }
                {
                  comment: unallocated space
                  size: 5248
                  inv_default: 0
                }
                {
                  size: 73536
                  inv_default: 0
                }
              ]
            }
            {
              size: 8192
              items:
              [
                {
                  size: 8192
                  inv_default: 0
                }
              ]
            }
            {
              size: 2624
              items:
              [
                {
                  size: 64
                  inv_default: 2932316366930412108
                }
                {
                  size: 1280
                  inv_default: 0
                }
                {
                  size: 1280
                  inv_default: 0
                }
              ]
            }
            {
              size: 2624
              items:
              [
                {
                  size: 64
                  inv_default: 16981414814768445627
                }
                {
                  size: 1280
                  inv_default: 0
                }
                {
                  size: 1280
                  inv_default: 0
                }
              ]
            }
            {
              size: 2624
              items:
              [
                {
                  size: 64
                  inv_default: 9966431396093675977
                }
                {
                  size: 1280
                  inv_default: 0
                }
                {
                  size: 1280
                  inv_default: 0
                }
              ]
            }
            {
              size: 2624
              items:
              [
                {
                  size: 64
                  inv_default: 13089428196878425884
                }
                {
                  size: 1280
                  inv_default: 0
                }
                {
                  size: 1280
                  inv_default: 0
                }
              ]
            }
            {
              size: 2624
              items:
              [
                {
                  size: 64
                  inv_default: 13047861355720130167
                }
                {
                  size: 1280
                  inv_default: 0
                }
                {
                  size: 1280
                  inv_default: 0
                }
              ]
            }
            {
              size: 2624
              items:
              [
                {
                  size: 64
                  inv_default: 18297828617386945793
                }
                {
                  size: 1280
                  inv_default: 0
                }
                {
                  size: 1280
                  inv_default: 0
                }
              ]
            }
            {
              size: 2624
              items:
              [
                {
                  size: 64
                  inv_default: 5471265045120329804
                }
                {
                  size: 1280
                  inv_default: 0
                }
                {
                  size: 1280
                  inv_default: 0
                }
              ]
            }
            {
              size: 2624
              items:
              [
                {
                  size: 64
                  inv_default: 18001735645508761512
                }
                {
                  size: 1280
                  inv_default: 0
                }
                {
                  size: 1280
                  inv_default: 0
                }
              ]
            }
            {
              size: 11392
              items:
              [
                {
                  size: 64
                  inv_default: 13936327800626111575
                }
                {
                  comment: unallocated space
                  size: 32
                  inv_default: 0
                }
                {
                  size: 6144
                  inv_default: 0
                }
                {
                  size: 1280
                  inv_default: 0
                }
                {
                  size: 1280
                  inv_default: 0
                }
                {
                  size: 1280
                  inv_default: 0
                }
                {
                  size: 32
                  inv_default: 0
                }
                {
                  size: 1280
                  inv_default: 0
                }
              ]
            }
            {
              size: 384
              items:
              [
                {
                  size: 128
                  inv_default: 0
                }
                {
                  size: 128
                  inv_default: 0
                }
                {
                  size: 128
                  inv_default: 0
                }
              ]
            }
            {
              size: 4800
              items:
              [
                {
                  size: 64
                  inv_default: 3036799796741757437
                }
                {
                  size: 32
                  inv_default: 0
                }
                {
                  size: 32
                  inv_default: 0
                }
                {
                  size: 32
                  inv_default: 0
                }
                {
                  size: 32
                  inv_default: 0
                }
                {
                  size: 32
                  inv_default: 0
                }
                {
                  size: 32
                  inv_default: 0
                }
                {
                  size: 32
                  inv_default: 0
                }
                {
                  size: 32
                  inv_default: 0
                }
                {
                  size: 512
                  inv_default: 0
                }
                {
                  size: 128
                  inv_default: 0
                }
                {
                  size: 128
                  inv_default: 0
                }
                {
                  size: 224
                  inv_default: 0
                }
                {
                  size: 3360
                  inv_default: 0
                }
                {
                  size: 32
                  inv_default: 0
                }
                {
                  size: 32
                  inv_default: 0
                }
                {
                  size: 32
                  inv_default: 0
                }
                {
                  size: 32
                  inv_default: 0
                }
              ]
            }
            {
              size: 2496
              items:
              [
                {
                  size: 64
                  inv_default: 10745993536467849044
                }
                {
                  comment: unallocated space
                  size: 32
                  inv_default: 0
                }
                {
                  size: 32
                  inv_default: 0
                }
                {
                  size: 32
                  inv_default: 0
                }
                {
                  size: 32
                  inv_default: 0
                }
                {
                  size: 32
                  inv_default: 0
                }
                {
                  size: 32
                  inv_default: 0
                }
                {
                  size: 32
                  inv_default: 0
                }
                {
                  size: 32
                  inv_default: 0
                }
                {
                  size: 32
                  inv_default: 0
                }
                {
                  size: 32
                  inv_default: 0
                }
                {
                  size: 32
                  inv_default: 0
                }
                {
                  size: 32
                  inv_default: 0
                }
                {
                  size: 32
                  inv_default: 0
                }
                {
                  size: 32
                  inv_default: 0
                }
                {
                  size: 32
                  inv_default: 0
                }
                {
                  size: 32
                  inv_default: 0
                }
                {
                  size: 32
                  inv_default: 0
                }
                {
                  size: 32
                  inv_default: 0
                }
                {
                  size: 32
                  inv_default: 0
                }
                {
                  size: 32
                  inv_default: 0
                }
                {
                  size: 32
                  inv_default: 0
                }
                {
                  size: 32
                  inv_default: 0
                }
                {
                  size: 32
                  inv_default: 0
                }
                {
                  size: 32
                  inv_default: 0
                }
                {
                  size: 32
                  inv_default: 0
                }
                {
                  size: 32
                  inv_default: 0
                }
                {
                  size: 32
                  inv_default: 0
                }
                {
                  size: 32
                  inv_default: 0
                }
                {
                  size: 32
                  inv_default: 0
                }
                {
                  size: 64
                  inv_default: 0
                }
                {
                  size: 32
                  inv_default: 0
                }
                {
                  size: 64
                  inv_default: 0
                }
                {
                  size: 32
                  inv_default: 0
                }
                {
                  size: 32
                  inv_default: 0
                }
                {
                  size: 256
                  inv_default: 0
                }
                {
                  size: 32
                  inv_default: 0
                }
                {
                  size: 992
                  inv_default: 0
                }
              ]
            }
            {
              size: 512
              items:
              [
                {
                  size: 64
                  inv_default: 312179291205032755
                }
                {
                  size: 448
                  inv_default: 0
                }
              ]
            }
          ]
          randwidth: 131072
        }
      ]
      template_type: otp_ctrl
      otp_mmap:
      {
        otp:
        {
          width: 2
          depth: 8192
          size: 16384
          addr_width: 13
          byte_addr_width: 14
        }
        scrambling:
        {
          key_size: 16
          iv_size: 8
          cnst_size: 16
          keys:
          [
            {
              name: Secret0Key
              value: 138959374610987221438102940065509369958
            }
            {
              name: Secret1Key
              value: 214906908420393146978604154423181190009
            }
            {
              name: Secret2Key
              value: 259105464341488730475238499589165956997
            }
            {
              name: Secret3Key
              value: 188897641917496988174986683742771918684
            }
          ]
          digests:
          [
            {
              name: CnstyDigest
              iv_value: 11565364800674047323
              cnst_value: 13004072182442196571965938888816599509
            }
            {
              name: SramDataKey
              iv_value: 11229202183237704545
              cnst_value: 103407901297817239236543323158765666219
            }
          ]
          num_keys: 4
          num_digests: 2
        }
        partitions:
        [
          {
            name: VENDOR_TEST
            variant: Unbuffered
            absorb: false
            secret: false
            sw_digest: true
            hw_digest: false
            write_lock: Digest
            read_lock: CSR
            key_sel: NoKey
            integrity: false
            bkout_type: false
            zeroizable: false
            skip_sw_header: true
            items:
            [
              {
                name: SCRATCH
                size: 56
                isdigest: false
                iszer: false
                ismubi: false
                iskeymgr_creator: false
                iskeymgr_owner: false
                inv_default: 0
                offset: 0
              }
              {
                name: VENDOR_TEST_DIGEST
                size: 8
                offset: 56
                ismubi: false
                isdigest: true
                iszer: false
                inv_default: 312179291205032755
                iskeymgr_creator: false
                iskeymgr_owner: false
              }
            ]
            desc:
              '''
              Vendor test partition.
              This is reserved for manufacturing smoke checks. The OTP wrapper
              control logic inside prim_otp is allowed to read/write to this
              region. ECC uncorrectable errors seen on the functional prim_otp
              interface will not lead to an alert for this partition.
              Instead, such errors will be reported as correctable ECC errors.
              '''
            iskeymgr_creator: false
            iskeymgr_owner: false
            ignore_read_lock_in_rma: false
            size: 64
            offset: 0
          }
          {
            name: CREATOR_SW_CFG
            variant: Unbuffered
            absorb: false
            secret: false
            sw_digest: true
            hw_digest: false
            write_lock: Digest
            read_lock: CSR
            key_sel: NoKey
            integrity: true
            bkout_type: false
            zeroizable: false
            items:
            [
              {
                name: CREATOR_SW_CFG_AST_CFG
                size: 124
                isdigest: false
                iszer: false
                ismubi: false
                iskeymgr_creator: false
                iskeymgr_owner: false
                inv_default: 0
                offset: 64
              }
              {
                name: CREATOR_SW_CFG_AST_INIT_EN
                size: 4
                isdigest: false
                iszer: false
                ismubi: false
                iskeymgr_creator: false
                iskeymgr_owner: false
                inv_default: 0
                offset: 188
              }
              {
                name: CREATOR_SW_CFG_OVERRIDES
                size: 32
                isdigest: false
                iszer: false
                ismubi: false
                iskeymgr_creator: false
                iskeymgr_owner: false
                inv_default: 0
                offset: 192
              }
              {
                name: CREATOR_SW_CFG_ROM_EXT_SKU
                size: 4
                isdigest: false
                iszer: false
                ismubi: false
                iskeymgr_creator: false
                iskeymgr_owner: false
                inv_default: 0
                offset: 224
              }
              {
                name: CREATOR_SW_CFG_SIGVERIFY_RSA_MOD_EXP_IBEX_EN
                size: 4
                isdigest: false
                iszer: false
                ismubi: false
                iskeymgr_creator: false
                iskeymgr_owner: false
                inv_default: 0
                offset: 228
              }
              {
                name: CREATOR_SW_CFG_SIGVERIFY_RSA_KEY_EN
                size: 8
                isdigest: false
                iszer: false
                ismubi: false
                iskeymgr_creator: false
                iskeymgr_owner: false
                inv_default: 0
                offset: 232
              }
              {
                name: CREATOR_SW_CFG_SIGVERIFY_SPX_EN
                size: 4
                isdigest: false
                iszer: false
                ismubi: false
                iskeymgr_creator: false
                iskeymgr_owner: false
                inv_default: 0
                offset: 240
              }
              {
                name: CREATOR_SW_CFG_SIGVERIFY_SPX_KEY_EN
                size: 8
                isdigest: false
                iszer: false
                ismubi: false
                iskeymgr_creator: false
                iskeymgr_owner: false
                inv_default: 0
                offset: 244
              }
              {
                name: CREATOR_SW_CFG_NVM_DATA_DEFAULT_CFG
                size: 4
                isdigest: false
                iszer: false
                ismubi: false
                iskeymgr_creator: false
                iskeymgr_owner: false
                inv_default: 0
                offset: 252
              }
              {
                name: CREATOR_SW_CFG_NVM_INFO_BOOT_DATA_CFG
                size: 4
                isdigest: false
                iszer: false
                ismubi: false
                iskeymgr_creator: false
                iskeymgr_owner: false
                inv_default: 0
                offset: 256
              }
              {
                name: CREATOR_SW_CFG_NVM_HW_INFO_CFG_OVERRIDE
                size: 4
                isdigest: false
                iszer: false
                ismubi: false
                iskeymgr_creator: false
                iskeymgr_owner: false
                inv_default: 0
                offset: 260
              }
              {
                name: CREATOR_SW_CFG_RNG_EN
                size: 4
                isdigest: false
                iszer: false
                ismubi: false
                iskeymgr_creator: false
                iskeymgr_owner: false
                inv_default: 0
                offset: 264
              }
              {
                name: CREATOR_SW_CFG_JITTER_EN
                size: 4
                isdigest: false
                iszer: false
                ismubi: false
                iskeymgr_creator: false
                iskeymgr_owner: false
                inv_default: 0
                offset: 268
              }
              {
                name: CREATOR_SW_CFG_RET_RAM_RESET_MASK
                size: 4
                isdigest: false
                iszer: false
                ismubi: false
                iskeymgr_creator: false
                iskeymgr_owner: false
                inv_default: 0
                offset: 272
              }
              {
                name: CREATOR_SW_CFG_MANUF_STATE
                size: 4
                isdigest: false
                iszer: false
                ismubi: false
                iskeymgr_creator: false
                iskeymgr_owner: false
                inv_default: 0
                offset: 276
              }
              {
                name: CREATOR_SW_CFG_ROM_EXEC_EN
                size: 4
                isdigest: false
                iszer: false
                ismubi: false
                iskeymgr_creator: false
                iskeymgr_owner: false
                inv_default: 0
                offset: 280
              }
              {
                name: CREATOR_SW_CFG_CPUCTRL
                size: 4
                isdigest: false
                iszer: false
                ismubi: false
                iskeymgr_creator: false
                iskeymgr_owner: false
                inv_default: 0
                offset: 284
              }
              {
                name: CREATOR_SW_CFG_MIN_SEC_VER_ROM_EXT
                size: 4
                isdigest: false
                iszer: false
                ismubi: false
                iskeymgr_creator: false
                iskeymgr_owner: false
                inv_default: 0
                offset: 288
              }
              {
                name: CREATOR_SW_CFG_MIN_SEC_VER_BL0
                size: 4
                isdigest: false
                iszer: false
                ismubi: false
                iskeymgr_creator: false
                iskeymgr_owner: false
                inv_default: 0
                offset: 292
              }
              {
                name: CREATOR_SW_CFG_DEFAULT_BOOT_DATA_IN_PROD_EN
                size: 4
                isdigest: false
                iszer: false
                ismubi: false
                iskeymgr_creator: false
                iskeymgr_owner: false
                inv_default: 0
                offset: 296
              }
              {
                name: CREATOR_SW_CFG_RMA_SPIN_EN
                size: 4
                isdigest: false
                iszer: false
                ismubi: false
                iskeymgr_creator: false
                iskeymgr_owner: false
                inv_default: 0
                offset: 300
              }
              {
                name: CREATOR_SW_CFG_RMA_SPIN_CYCLES
                size: 4
                isdigest: false
                iszer: false
                ismubi: false
                iskeymgr_creator: false
                iskeymgr_owner: false
                inv_default: 0
                offset: 304
              }
              {
                name: CREATOR_SW_CFG_RNG_REPCNT_THRESHOLDS
                size: 4
                isdigest: false
                iszer: false
                ismubi: false
                iskeymgr_creator: false
                iskeymgr_owner: false
                inv_default: 0
                offset: 308
              }
              {
                name: CREATOR_SW_CFG_RNG_REPCNTS_THRESHOLDS
                size: 4
                isdigest: false
                iszer: false
                ismubi: false
                iskeymgr_creator: false
                iskeymgr_owner: false
                inv_default: 0
                offset: 312
              }
              {
                name: CREATOR_SW_CFG_RNG_ADAPTP_HI_THRESHOLDS
                size: 4
                isdigest: false
                iszer: false
                ismubi: false
                iskeymgr_creator: false
                iskeymgr_owner: false
                inv_default: 0
                offset: 316
              }
              {
                name: CREATOR_SW_CFG_RNG_ADAPTP_LO_THRESHOLDS
                size: 4
                isdigest: false
                iszer: false
                ismubi: false
                iskeymgr_creator: false
                iskeymgr_owner: false
                inv_default: 0
                offset: 320
              }
              {
                name: CREATOR_SW_CFG_RNG_BUCKET_THRESHOLDS
                size: 4
                isdigest: false
                iszer: false
                ismubi: false
                iskeymgr_creator: false
                iskeymgr_owner: false
                inv_default: 0
                offset: 324
              }
              {
                name: CREATOR_SW_CFG_RNG_MARKOV_HI_THRESHOLDS
                size: 4
                isdigest: false
                iszer: false
                ismubi: false
                iskeymgr_creator: false
                iskeymgr_owner: false
                inv_default: 0
                offset: 328
              }
              {
                name: CREATOR_SW_CFG_RNG_MARKOV_LO_THRESHOLDS
                size: 4
                isdigest: false
                iszer: false
                ismubi: false
                iskeymgr_creator: false
                iskeymgr_owner: false
                inv_default: 0
                offset: 332
              }
              {
                name: CREATOR_SW_CFG_RNG_EXTHT_HI_THRESHOLDS
                size: 4
                isdigest: false
                iszer: false
                ismubi: false
                iskeymgr_creator: false
                iskeymgr_owner: false
                inv_default: 0
                offset: 336
              }
              {
                name: CREATOR_SW_CFG_RNG_EXTHT_LO_THRESHOLDS
                size: 4
                isdigest: false
                iszer: false
                ismubi: false
                iskeymgr_creator: false
                iskeymgr_owner: false
                inv_default: 0
                offset: 340
              }
              {
                name: CREATOR_SW_CFG_RNG_BOOT_ALERT_THRESHOLD
                size: 4
                isdigest: false
                iszer: false
                ismubi: false
                iskeymgr_creator: false
                iskeymgr_owner: false
                inv_default: 0
                offset: 344
              }
              {
                name: CREATOR_SW_CFG_RNG_FIPS_ALERT_THRESHOLD
                size: 4
                isdigest: false
                iszer: false
                ismubi: false
                iskeymgr_creator: false
                iskeymgr_owner: false
                inv_default: 0
                offset: 348
              }
              {
                name: CREATOR_SW_CFG_RNG_BOOT_CONFIG_DIGEST
                size: 4
                isdigest: false
                iszer: false
                ismubi: false
                iskeymgr_creator: false
                iskeymgr_owner: false
                inv_default: 0
                offset: 352
              }
              {
                name: CREATOR_SW_CFG_RNG_FIPS_CONFIG_DIGEST
                size: 4
                isdigest: false
                iszer: false
                ismubi: false
                iskeymgr_creator: false
                iskeymgr_owner: false
                inv_default: 0
                offset: 356
              }
              {
                name: CREATOR_SW_CFG_SRAM_KEY_RENEW_AND_INIT_EN
                size: 4
                isdigest: false
                iszer: false
                ismubi: false
                iskeymgr_creator: false
                iskeymgr_owner: false
                inv_default: 0
                offset: 360
              }
              {
                name: CREATOR_SW_CFG_DIGEST
                size: 8
                offset: 368
                ismubi: false
                isdigest: true
                iszer: false
                inv_default: 10745993536467849044
                iskeymgr_creator: false
                iskeymgr_owner: false
              }
            ]
            desc:
              '''
              Software configuration partition.
              This is for device-specific calibration data. For example, clock,
              LDO, RNG.
              '''
            iskeymgr_creator: false
            iskeymgr_owner: false
            ignore_read_lock_in_rma: false
            size: 312
            offset: 64
          }
          {
            name: OWNER_SW_CFG
            variant: Unbuffered
            absorb: false
            secret: false
            sw_digest: true
            hw_digest: false
            write_lock: Digest
            read_lock: CSR
            key_sel: NoKey
            integrity: true
            bkout_type: false
            zeroizable: false
            items:
            [
              {
                name: OWNER_SW_CFG_ROM_ERROR_REPORTING
                size: 4
                isdigest: false
                iszer: false
                ismubi: false
                iskeymgr_creator: false
                iskeymgr_owner: false
                inv_default: 0
                offset: 376
              }
              {
                name: OWNER_SW_CFG_ROM_BOOTSTRAP_DIS
                size: 4
                isdigest: false
                iszer: false
                ismubi: false
                iskeymgr_creator: false
                iskeymgr_owner: false
                inv_default: 0
                offset: 380
              }
              {
                name: OWNER_SW_CFG_ROM_ALERT_CLASS_EN
                size: 4
                isdigest: false
                iszer: false
                ismubi: false
                iskeymgr_creator: false
                iskeymgr_owner: false
                inv_default: 0
                offset: 384
              }
              {
                name: OWNER_SW_CFG_ROM_ALERT_ESCALATION
                size: 4
                isdigest: false
                iszer: false
                ismubi: false
                iskeymgr_creator: false
                iskeymgr_owner: false
                inv_default: 0
                offset: 388
              }
              {
                name: OWNER_SW_CFG_ROM_ALERT_CLASSIFICATION
                size: 420
                isdigest: false
                iszer: false
                ismubi: false
                iskeymgr_creator: false
                iskeymgr_owner: false
                inv_default: 0
                offset: 392
              }
              {
                name: OWNER_SW_CFG_ROM_LOCAL_ALERT_CLASSIFICATION
                size: 28
                isdigest: false
                iszer: false
                ismubi: false
                iskeymgr_creator: false
                iskeymgr_owner: false
                inv_default: 0
                offset: 812
              }
              {
                name: OWNER_SW_CFG_ROM_ALERT_ACCUM_THRESH
                size: 16
                isdigest: false
                iszer: false
                ismubi: false
                iskeymgr_creator: false
                iskeymgr_owner: false
                inv_default: 0
                offset: 840
              }
              {
                name: OWNER_SW_CFG_ROM_ALERT_TIMEOUT_CYCLES
                size: 16
                isdigest: false
                iszer: false
                ismubi: false
                iskeymgr_creator: false
                iskeymgr_owner: false
                inv_default: 0
                offset: 856
              }
              {
                name: OWNER_SW_CFG_ROM_ALERT_PHASE_CYCLES
                size: 64
                isdigest: false
                iszer: false
                ismubi: false
                iskeymgr_creator: false
                iskeymgr_owner: false
                inv_default: 0
                offset: 872
              }
              {
                name: OWNER_SW_CFG_ROM_ALERT_DIGEST_PROD
                size: 4
                isdigest: false
                iszer: false
                ismubi: false
                iskeymgr_creator: false
                iskeymgr_owner: false
                inv_default: 0
                offset: 936
              }
              {
                name: OWNER_SW_CFG_ROM_ALERT_DIGEST_PROD_END
                size: 4
                isdigest: false
                iszer: false
                ismubi: false
                iskeymgr_creator: false
                iskeymgr_owner: false
                inv_default: 0
                offset: 940
              }
              {
                name: OWNER_SW_CFG_ROM_ALERT_DIGEST_DEV
                size: 4
                isdigest: false
                iszer: false
                ismubi: false
                iskeymgr_creator: false
                iskeymgr_owner: false
                inv_default: 0
                offset: 944
              }
              {
                name: OWNER_SW_CFG_ROM_ALERT_DIGEST_RMA
                size: 4
                isdigest: false
                iszer: false
                ismubi: false
                iskeymgr_creator: false
                iskeymgr_owner: false
                inv_default: 0
                offset: 948
              }
              {
                name: OWNER_SW_CFG_ROM_WATCHDOG_BITE_THRESHOLD_CYCLES
                size: 4
                isdigest: false
                iszer: false
                ismubi: false
                iskeymgr_creator: false
                iskeymgr_owner: false
                inv_default: 0
                offset: 952
              }
              {
                name: OWNER_SW_CFG_ROM_KEYMGR_ROM_EXT_MEAS_EN
                size: 4
                isdigest: false
                iszer: false
                ismubi: false
                iskeymgr_creator: false
                iskeymgr_owner: false
                inv_default: 0
                offset: 956
              }
              {
                name: OWNER_SW_CFG_MANUF_STATE
                size: 4
                isdigest: false
                iszer: false
                ismubi: false
                iskeymgr_creator: false
                iskeymgr_owner: false
                inv_default: 0
                offset: 960
              }
              {
                name: OWNER_SW_CFG_ROM_RSTMGR_INFO_EN
                size: 4
                isdigest: false
                iszer: false
                ismubi: false
                iskeymgr_creator: false
                iskeymgr_owner: false
                inv_default: 0
                offset: 964
              }
              {
                name: OWNER_SW_CFG_DIGEST
                size: 8
                offset: 968
                ismubi: false
                isdigest: true
                iszer: false
                inv_default: 3036799796741757437
                iskeymgr_creator: false
                iskeymgr_owner: false
              }
            ]
            desc:
              '''
              Software configuration partition.
              This contains data that changes software behavior in the ROM, for
              example enabling defensive features in ROM or selecting failure
              modes if verification fails.
              '''
            iskeymgr_creator: false
            iskeymgr_owner: false
            ignore_read_lock_in_rma: false
            size: 600
            offset: 376
          }
          {
            name: OWNERSHIP_SLOT_STATE
            variant: Unbuffered
            absorb: false
            secret: false
            sw_digest: false
            hw_digest: false
            write_lock: None
            read_lock: CSR
            key_sel: NoKey
            integrity: true
            bkout_type: false
            zeroizable: false
            items:
            [
              {
                name: OWNERSHIP_SLOT_STATE_ROT_OWNER_AUTH
                size: 16
                desc:
                  '''
                  Creator Ownership transfer state management
                  OWNERSHIP_ST_RAW:       ownership not yet claimed (factory default)
                  OWNERSHIP_ST_LOCKED0:   first ownership slot claimed
                  OWNERSHIP_ST_RELEASED0: first ownership slot released (assets have been cleared, ready to xfer)
                  OWNERSHIP_ST_LOCKED1:   second ownership slot claimed
                  OWNERSHIP_ST_SCRAPPED:  scrap state - terminal
                  '''
                isdigest: false
                iszer: false
                ismubi: false
                iskeymgr_creator: false
                iskeymgr_owner: false
                inv_default: 0
                offset: 976
              }
              {
                name: OWNERSHIP_SLOT_STATE_PLAT_INTEG_AUTH
                size: 16
                desc:
                  '''
                  Creator Ownership transfer state management
                  OWNERSHIP_ST_RAW:       ownership not yet claimed (factory default)
                  OWNERSHIP_ST_LOCKED0:   first ownership slot claimed
                  OWNERSHIP_ST_RELEASED0: first ownership slot released (assets have been cleared, ready to xfer)
                  OWNERSHIP_ST_LOCKED1:   second ownership slot claimed
                  OWNERSHIP_ST_SCRAPPED:  scrap state - terminal
                  '''
                isdigest: false
                iszer: false
                ismubi: false
                iskeymgr_creator: false
                iskeymgr_owner: false
                inv_default: 0
                offset: 992
              }
              {
                name: OWNERSHIP_SLOT_STATE_PLAT_OWNER_AUTH
                size: 16
                desc:
                  '''
                  Creator Ownership transfer state management
                  OWNERSHIP_ST_RAW:       ownership not yet claimed (factory default)
                  OWNERSHIP_ST_LOCKED0:   first ownership slot claimed
                  OWNERSHIP_ST_RELEASED0: first ownership slot released (assets have been cleared, ready to xfer)
                  OWNERSHIP_ST_LOCKED1:   second ownership slot claimed
                  OWNERSHIP_ST_RELEASED1: second ownership slot released (assets have been cleared, ready to xfer)
                  OWNERSHIP_ST_LOCKED2:   third ownership slot claimed
                  OWNERSHIP_ST_RELEASED2: third ownership slot released (assets have been cleared, ready to xfer)
                  OWNERSHIP_ST_LOCKED3:   fourth ownership slot claimed
                  OWNERSHIP_ST_SCRAPPED:  scrap state - terminal
                  '''
                isdigest: false
                iszer: false
                ismubi: false
                iskeymgr_creator: false
                iskeymgr_owner: false
                inv_default: 0
                offset: 1008
              }
            ]
            desc:
              '''
              SW managed asset ownership states partition.

              Multibit enable value for the tracking the asset ownership states.
              Note that the states can be written multiple times in a device lifetime.
              The values to be written are engineered in the same way as the LC_CTRL
              state encoding words so that the ECC encoding remains valid even after
              updating the values.

              The constants can be found in the lc_ctrl_state_pkg.sv package.

              The programming order has to adhere to:

              OWNERSHIP_ST_RAW (factory all-zero state) ->
              OWNERSHIP_ST_LOCKED0 ->
              OWNERSHIP_ST_RELEASED0 ->
              ...
              OWNERSHIP_ST_SCRAPPED

              Note that if there are less than 4 slots available the higher slot states
              become logically equivalent to OWNERSHIP_SCRAPPED (firmware has to handle
              this correctly).
              '''
            iskeymgr_creator: false
            iskeymgr_owner: false
            ignore_read_lock_in_rma: false
            size: 48
            offset: 976
          }
          {
            name: ROT_CREATOR_AUTH
            variant: Unbuffered
            absorb: false
            secret: false
            sw_digest: true
            hw_digest: false
            write_lock: Digest
            read_lock: CSR
            key_sel: NoKey
            integrity: true
            bkout_type: false
            zeroizable: false
            items:
            [
              {
                name: ROT_CREATOR_AUTH_NON_RAW_MFW_CODESIGN_KEY
                size: 160
                desc:
                  '''
                  Pub Key used to verify the manufacturing provisioning Software container
                  160B = Custom Cert --> {PubKey:48, Signature:48, Device ID:32, metadata:16}
                  It is expected to be provisioned at Chip Probe stage when LC = TEST
                  i.e. provisioning protected under proper lifecycle logistics / secure supplychain management
                  '''
                isdigest: false
                iszer: false
                ismubi: false
                iskeymgr_creator: false
                iskeymgr_owner: false
                inv_default: 0
                offset: 1024
              }
              {
                name: ROT_CREATOR_AUTH_OWNERSHIP_STATE
                size: 4
                desc:
                  '''
                  Creator Ownership transfer state management
                  UNLOCKED - ownership of ROT not yet claimed
                  LOCKED   - ownership claimed and
                  RELEASED - Release ownership (assets have been cleared, ready to xfer)
                  '''
                isdigest: false
                iszer: false
                ismubi: false
                iskeymgr_creator: false
                iskeymgr_owner: false
                inv_default: 0
                offset: 1184
              }
              {
                name: ROT_CREATOR_AUTH_ROM2_PATCH_SIGVERIFY_KEY
                size: 160
                desc:
                  '''
                  Pub Key used to verify the ROM2 OTP based patch
                  160B = Custom Cert --> {PubKey:48, Signature:48, Device ID:32, metadata:16}
                  It is expected to be provisioned at Chip Probe stage when LC = TEST
                  i.e. provisioning protected under proper lifecycle logistics / secure supplychain management
                    OTP based key (instead of ROM) facilitates easy key rotation
                  '''
                isdigest: false
                iszer: false
                ismubi: false
                iskeymgr_creator: false
                iskeymgr_owner: false
                inv_default: 0
                offset: 1188
              }
              {
                name: ROT_CREATOR_AUTH_KEYMANIFEST_KEY
                size: 160
                desc:
                  '''
                  Pub Key used to verify the ROT CREATOR KEY MANIFEST.
                  KM is used to provisioning additional keys in (external) flash
                  160B = Custom Cert --> {PubKey:48, Signature:48, Device ID:32, metadata:16}
                  It is expected to be provisioned at Chip Probe stage when LC = TEST
                  i.e. provisioning protected under proper lifecycle logistics / secure supplychain management
                  '''
                isdigest: false
                iszer: false
                ismubi: false
                iskeymgr_creator: false
                iskeymgr_owner: false
                inv_default: 0
                offset: 1348
              }
              {
                name: ROT_CREATOR_AUTH_UNLOCK4XFER_KEY
                size: 160
                desc:
                  '''
                  Pub Key used to verify the ROT CREATOR KEY MANIFEST.
                  Used to authenticate the Unlock Ownership payload. Key Type: ECC NIST-P384 Curve.
                  160B = Custom Cert --> {PubKey:48, Signature:48, Device ID:32, metadata:16}
                  Can be made part bound i.e. unique per part key cert
                  i.e. provisioning protected under proper lifecycle logistics / secure supplychain management
                  '''
                isdigest: false
                iszer: false
                ismubi: false
                iskeymgr_creator: false
                iskeymgr_owner: false
                inv_default: 0
                offset: 1508
              }
              {
                name: ROT_CREATOR_AUTH_IDENTITY_CERT
                size: 768
                desc: ROT Device Identity Certificate endorsed by Silicon Creator stable off device PKI
                isdigest: false
                iszer: false
                ismubi: false
                iskeymgr_creator: false
                iskeymgr_owner: false
                inv_default: 0
                offset: 1668
              }
              {
                name: ROT_CREATOR_AUTH_DIGEST
                size: 8
                offset: 2440
                ismubi: false
                isdigest: true
                iszer: false
                inv_default: 13936327800626111575
                iskeymgr_creator: false
                iskeymgr_owner: false
              }
            ]
            desc: Software managed creator partition.
            iskeymgr_creator: false
            iskeymgr_owner: false
            ignore_read_lock_in_rma: false
            size: 1424
            offset: 1024
          }
          {
            name: ROT_OWNER_AUTH_SLOT0
            variant: Unbuffered
            absorb: false
            secret: false
            sw_digest: true
            hw_digest: false
            write_lock: Digest
            read_lock: CSR
            key_sel: NoKey
            integrity: true
            bkout_type: false
            zeroizable: false
            items:
            [
              {
                name: ROT_OWNER_AUTH_SLOT0_KEYMANIFEST_KEY
                size: 160
                desc:
                  '''
                  Pub Key used to verify the ROT OWNER KEY MANIFEST.
                  KM is used to provisioning additional keys in (external) flash
                  160B = Custom Cert --> {PubKey:48, Signature:48, Device ID:32, metadata:16}
                  It is expected to be provisioned at Chip Probe stage when LC = TEST
                  i.e. provisioning protected under proper lifecycle logistics / secure supplychain management
                  '''
                isdigest: false
                iszer: false
                ismubi: false
                iskeymgr_creator: false
                iskeymgr_owner: false
                inv_default: 0
                offset: 2448
              }
              {
                name: ROT_OWNER_AUTH_SLOT0_UNLOCK4XFER_KEY
                size: 160
                desc:
                  '''
                  Pub Key used to verify the ROT OWNER KEY MANIFEST.
                  Used to authenticate the Unlock Ownership payload. Key Type: ECC NIST-P384 Curve.
                  160B = Custom Cert --> {PubKey:48, Signature:48, Device ID:32, metadata:16}
                  Can be made part bound i.e. unique per part key cert
                  i.e. provisioning protected under proper lifecycle logistics / secure supplychain management
                  '''
                isdigest: false
                iszer: false
                ismubi: false
                iskeymgr_creator: false
                iskeymgr_owner: false
                inv_default: 0
                offset: 2608
              }
              {
                name: ROT_OWNER_AUTH_SLOT0_DIGEST
                size: 8
                offset: 2768
                ismubi: false
                isdigest: true
                iszer: false
                inv_default: 18001735645508761512
                iskeymgr_creator: false
                iskeymgr_owner: false
              }
            ]
            desc: Software managed owner slot 0 partition.
            iskeymgr_creator: false
            iskeymgr_owner: false
            ignore_read_lock_in_rma: false
            size: 328
            offset: 2448
          }
          {
            name: ROT_OWNER_AUTH_SLOT1
            variant: Unbuffered
            absorb: false
            secret: false
            sw_digest: true
            hw_digest: false
            write_lock: Digest
            read_lock: CSR
            key_sel: NoKey
            integrity: true
            bkout_type: false
            zeroizable: false
            items:
            [
              {
                name: ROT_OWNER_AUTH_SLOT1_KEYMANIFEST_KEY
                size: 160
                desc:
                  '''
                  Pub Key used to verify the ROT OWNER KEY MANIFEST.
                  KM is used to provisioning additional keys in (external) flash
                  160B = Custom Cert --> {PubKey:48, Signature:48, Device ID:32, metadata:16}
                  It is expected to be provisioned at Chip Probe stage when LC = TEST
                  i.e. provisioning protected under proper lifecycle logistics / secure supplychain management
                  '''
                isdigest: false
                iszer: false
                ismubi: false
                iskeymgr_creator: false
                iskeymgr_owner: false
                inv_default: 0
                offset: 2776
              }
              {
                name: ROT_OWNER_AUTH_SLOT1_UNLOCK4XFER_KEY
                size: 160
                desc:
                  '''
                  Pub Key used to verify the ROT OWNER KEY MANIFEST.
                  Used to authenticate the Unlock Ownership payload. Key Type: ECC NIST-P384 Curve.
                  160B = Custom Cert --> {PubKey:48, Signature:48, Device ID:32, metadata:16}
                  Can be made part bound i.e. unique per part key cert
                  i.e. provisioning protected under proper lifecycle logistics / secure supplychain management
                  '''
                isdigest: false
                iszer: false
                ismubi: false
                iskeymgr_creator: false
                iskeymgr_owner: false
                inv_default: 0
                offset: 2936
              }
              {
                name: ROT_OWNER_AUTH_SLOT1_DIGEST
                size: 8
                offset: 3096
                ismubi: false
                isdigest: true
                iszer: false
                inv_default: 5471265045120329804
                iskeymgr_creator: false
                iskeymgr_owner: false
              }
            ]
            desc: Software managed owner slot 1 partition.
            iskeymgr_creator: false
            iskeymgr_owner: false
            ignore_read_lock_in_rma: false
            size: 328
            offset: 2776
          }
          {
            name: PLAT_INTEG_AUTH_SLOT0
            variant: Unbuffered
            absorb: false
            secret: false
            sw_digest: true
            hw_digest: false
            write_lock: Digest
            read_lock: CSR
            key_sel: NoKey
            integrity: true
            bkout_type: false
            zeroizable: false
            items:
            [
              {
                name: PLAT_INTEG_AUTH_SLOT0_KEYMANIFEST_KEY
                size: 160
                desc:
                  '''
                  Pub Key used to verify the ROT OWNER KEY MANIFEST.
                  KM is used to provisioning additional keys in (external) flash
                  160B = Custom Cert --> {PubKey:48, Signature:48, Device ID:32, metadata:16}
                  It is expected to be provisioned at Chip Probe stage when LC = TEST
                  i.e. provisioning protected under proper lifecycle logistics / secure supplychain management
                  '''
                isdigest: false
                iszer: false
                ismubi: false
                iskeymgr_creator: false
                iskeymgr_owner: false
                inv_default: 0
                offset: 3104
              }
              {
                name: PLAT_INTEG_AUTH_SLOT0_UNLOCK4XFER_KEY
                size: 160
                desc:
                  '''
                  Pub Key used to verify the ROT OWNER KEY MANIFEST.
                  Used to authenticate the Unlock Ownership payload. Key Type: ECC NIST-P384 Curve.
                  160B = Custom Cert --> {PubKey:48, Signature:48, Device ID:32, metadata:16}
                  Can be made part bound i.e. unique per part key cert
                  i.e. provisioning protected under proper lifecycle logistics / secure supplychain management
                  '''
                isdigest: false
                iszer: false
                ismubi: false
                iskeymgr_creator: false
                iskeymgr_owner: false
                inv_default: 0
                offset: 3264
              }
              {
                name: PLAT_INTEG_AUTH_SLOT0_DIGEST
                size: 8
                offset: 3424
                ismubi: false
                isdigest: true
                iszer: false
                inv_default: 18297828617386945793
                iskeymgr_creator: false
                iskeymgr_owner: false
              }
            ]
            desc: Software managed platform integrator slot 0 partition.
            iskeymgr_creator: false
            iskeymgr_owner: false
            ignore_read_lock_in_rma: false
            size: 328
            offset: 3104
          }
          {
            name: PLAT_INTEG_AUTH_SLOT1
            variant: Unbuffered
            absorb: false
            secret: false
            sw_digest: true
            hw_digest: false
            write_lock: Digest
            read_lock: CSR
            key_sel: NoKey
            integrity: true
            bkout_type: false
            zeroizable: false
            items:
            [
              {
                name: PLAT_INTEG_AUTH_SLOT1_KEYMANIFEST_KEY
                size: 160
                desc:
                  '''
                  Pub Key used to verify the ROT OWNER KEY MANIFEST.
                  KM is used to provisioning additional keys in (external) flash
                  160B = Custom Cert --> {PubKey:48, Signature:48, Device ID:32, metadata:16}
                  It is expected to be provisioned at Chip Probe stage when LC = TEST
                  i.e. provisioning protected under proper lifecycle logistics / secure supplychain management
                  '''
                isdigest: false
                iszer: false
                ismubi: false
                iskeymgr_creator: false
                iskeymgr_owner: false
                inv_default: 0
                offset: 3432
              }
              {
                name: PLAT_INTEG_AUTH_SLOT1_UNLOCK4XFER_KEY
                size: 160
                desc:
                  '''
                  Pub Key used to verify the ROT OWNER KEY MANIFEST.
                  Used to authenticate the Unlock Ownership payload. Key Type: ECC NIST-P384 Curve.
                  160B = Custom Cert --> {PubKey:48, Signature:48, Device ID:32, metadata:16}
                  Can be made part bound i.e. unique per part key cert
                  i.e. provisioning protected under proper lifecycle logistics / secure supplychain management
                  '''
                isdigest: false
                iszer: false
                ismubi: false
                iskeymgr_creator: false
                iskeymgr_owner: false
                inv_default: 0
                offset: 3592
              }
              {
                name: PLAT_INTEG_AUTH_SLOT1_DIGEST
                size: 8
                offset: 3752
                ismubi: false
                isdigest: true
                iszer: false
                inv_default: 13047861355720130167
                iskeymgr_creator: false
                iskeymgr_owner: false
              }
            ]
            desc: Software managed platform integrator slot 1 partition.
            iskeymgr_creator: false
            iskeymgr_owner: false
            ignore_read_lock_in_rma: false
            size: 328
            offset: 3432
          }
          {
            name: PLAT_OWNER_AUTH_SLOT0
            variant: Unbuffered
            absorb: false
            secret: false
            sw_digest: true
            hw_digest: false
            write_lock: Digest
            read_lock: CSR
            key_sel: NoKey
            integrity: true
            bkout_type: false
            zeroizable: false
            items:
            [
              {
                name: PLAT_OWNER_AUTH_SLOT0_KEYMANIFEST_KEY
                size: 160
                desc:
                  '''
                  Pub Key used to verify the ROT OWNER KEY MANIFEST.
                  KM is used to provisioning additional keys in (external) flash
                  160B = Custom Cert --> {PubKey:48, Signature:48, Device ID:32, metadata:16}
                  It is expected to be provisioned at Chip Probe stage when LC = TEST
                  i.e. provisioning protected under proper lifecycle logistics / secure supplychain management
                  '''
                isdigest: false
                iszer: false
                ismubi: false
                iskeymgr_creator: false
                iskeymgr_owner: false
                inv_default: 0
                offset: 3760
              }
              {
                name: PLAT_OWNER_AUTH_SLOT0_UNLOCK4XFER_KEY
                size: 160
                desc:
                  '''
                  Pub Key used to verify the ROT OWNER KEY MANIFEST.
                  Used to authenticate the Unlock Ownership payload. Key Type: ECC NIST-P384 Curve.
                  160B = Custom Cert --> {PubKey:48, Signature:48, Device ID:32, metadata:16}
                  Can be made part bound i.e. unique per part key cert
                  i.e. provisioning protected under proper lifecycle logistics / secure supplychain management
                  '''
                isdigest: false
                iszer: false
                ismubi: false
                iskeymgr_creator: false
                iskeymgr_owner: false
                inv_default: 0
                offset: 3920
              }
              {
                name: PLAT_OWNER_AUTH_SLOT0_DIGEST
                size: 8
                offset: 4080
                ismubi: false
                isdigest: true
                iszer: false
                inv_default: 13089428196878425884
                iskeymgr_creator: false
                iskeymgr_owner: false
              }
            ]
            desc: Software managed platform owner slot 0 partition.
            iskeymgr_creator: false
            iskeymgr_owner: false
            ignore_read_lock_in_rma: false
            size: 328
            offset: 3760
          }
          {
            name: PLAT_OWNER_AUTH_SLOT1
            variant: Unbuffered
            absorb: false
            secret: false
            sw_digest: true
            hw_digest: false
            write_lock: Digest
            read_lock: CSR
            key_sel: NoKey
            integrity: true
            bkout_type: false
            zeroizable: false
            items:
            [
              {
                name: PLAT_OWNER_AUTH_SLOT1_KEYMANIFEST_KEY
                size: 160
                desc:
                  '''
                  Pub Key used to verify the ROT OWNER KEY MANIFEST.
                  KM is used to provisioning additional keys in (external) flash
                  160B = Custom Cert --> {PubKey:48, Signature:48, Device ID:32, metadata:16}
                  It is expected to be provisioned at Chip Probe stage when LC = TEST
                  i.e. provisioning protected under proper lifecycle logistics / secure supplychain management
                  '''
                isdigest: false
                iszer: false
                ismubi: false
                iskeymgr_creator: false
                iskeymgr_owner: false
                inv_default: 0
                offset: 4088
              }
              {
                name: PLAT_OWNER_AUTH_SLOT1_UNLOCK4XFER_KEY
                size: 160
                desc:
                  '''
                  Pub Key used to verify the ROT OWNER KEY MANIFEST.
                  Used to authenticate the Unlock Ownership payload. Key Type: ECC NIST-P384 Curve.
                  160B = Custom Cert --> {PubKey:48, Signature:48, Device ID:32, metadata:16}
                  Can be made part bound i.e. unique per part key cert
                  i.e. provisioning protected under proper lifecycle logistics / secure supplychain management
                  '''
                isdigest: false
                iszer: false
                ismubi: false
                iskeymgr_creator: false
                iskeymgr_owner: false
                inv_default: 0
                offset: 4248
              }
              {
                name: PLAT_OWNER_AUTH_SLOT1_DIGEST
                size: 8
                offset: 4408
                ismubi: false
                isdigest: true
                iszer: false
                inv_default: 9966431396093675977
                iskeymgr_creator: false
                iskeymgr_owner: false
              }
            ]
            desc: Software managed platform owner slot 1 partition.
            iskeymgr_creator: false
            iskeymgr_owner: false
            ignore_read_lock_in_rma: false
            size: 328
            offset: 4088
          }
          {
            name: PLAT_OWNER_AUTH_SLOT2
            variant: Unbuffered
            absorb: false
            secret: false
            sw_digest: true
            hw_digest: false
            write_lock: Digest
            read_lock: CSR
            key_sel: NoKey
            integrity: true
            bkout_type: false
            zeroizable: false
            items:
            [
              {
                name: PLAT_OWNER_AUTH_SLOT2_KEYMANIFEST_KEY
                size: 160
                desc:
                  '''
                  Pub Key used to verify the ROT OWNER KEY MANIFEST.
                  KM is used to provisioning additional keys in (external) flash
                  160B = Custom Cert --> {PubKey:48, Signature:48, Device ID:32, metadata:16}
                  It is expected to be provisioned at Chip Probe stage when LC = TEST
                  i.e. provisioning protected under proper lifecycle logistics / secure supplychain management
                  '''
                isdigest: false
                iszer: false
                ismubi: false
                iskeymgr_creator: false
                iskeymgr_owner: false
                inv_default: 0
                offset: 4416
              }
              {
                name: PLAT_OWNER_AUTH_SLOT2_UNLOCK4XFER_KEY
                size: 160
                desc:
                  '''
                  Pub Key used to verify the ROT OWNER KEY MANIFEST.
                  Used to authenticate the Unlock Ownership payload. Key Type: ECC NIST-P384 Curve.
                  160B = Custom Cert --> {PubKey:48, Signature:48, Device ID:32, metadata:16}
                  Can be made part bound i.e. unique per part key cert
                  i.e. provisioning protected under proper lifecycle logistics / secure supplychain management
                  '''
                isdigest: false
                iszer: false
                ismubi: false
                iskeymgr_creator: false
                iskeymgr_owner: false
                inv_default: 0
                offset: 4576
              }
              {
                name: PLAT_OWNER_AUTH_SLOT2_DIGEST
                size: 8
                offset: 4736
                ismubi: false
                isdigest: true
                iszer: false
                inv_default: 16981414814768445627
                iskeymgr_creator: false
                iskeymgr_owner: false
              }
            ]
            desc: Software managed platform owner slot 2 partition.
            iskeymgr_creator: false
            iskeymgr_owner: false
            ignore_read_lock_in_rma: false
            size: 328
            offset: 4416
          }
          {
            name: PLAT_OWNER_AUTH_SLOT3
            variant: Unbuffered
            absorb: false
            secret: false
            sw_digest: true
            hw_digest: false
            write_lock: Digest
            read_lock: CSR
            key_sel: NoKey
            integrity: true
            bkout_type: false
            zeroizable: false
            items:
            [
              {
                name: PLAT_OWNER_AUTH_SLOT3_KEYMANIFEST_KEY
                size: 160
                desc:
                  '''
                  Pub Key used to verify the ROT OWNER KEY MANIFEST.
                  KM is used to provisioning additional keys in (external) flash
                  160B = Custom Cert --> {PubKey:48, Signature:48, Device ID:32, metadata:16}
                  It is expected to be provisioned at Chip Probe stage when LC = TEST
                  i.e. provisioning protected under proper lifecycle logistics / secure supplychain management
                  '''
                isdigest: false
                iszer: false
                ismubi: false
                iskeymgr_creator: false
                iskeymgr_owner: false
                inv_default: 0
                offset: 4744
              }
              {
                name: PLAT_OWNER_AUTH_SLOT3_UNLOCK4XFER_KEY
                size: 160
                desc:
                  '''
                  Pub Key used to verify the ROT OWNER KEY MANIFEST.
                  Used to authenticate the Unlock Ownership payload. Key Type: ECC NIST-P384 Curve.
                  160B = Custom Cert --> {PubKey:48, Signature:48, Device ID:32, metadata:16}
                  Can be made part bound i.e. unique per part key cert
                  i.e. provisioning protected under proper lifecycle logistics / secure supplychain management
                  '''
                isdigest: false
                iszer: false
                ismubi: false
                iskeymgr_creator: false
                iskeymgr_owner: false
                inv_default: 0
                offset: 4904
              }
              {
                name: PLAT_OWNER_AUTH_SLOT3_DIGEST
                size: 8
                offset: 5064
                ismubi: false
                isdigest: true
                iszer: false
                inv_default: 2932316366930412108
                iskeymgr_creator: false
                iskeymgr_owner: false
              }
            ]
            desc: Software managed platform owner slot 3 partition.
            iskeymgr_creator: false
            iskeymgr_owner: false
            ignore_read_lock_in_rma: false
            size: 328
            offset: 4744
          }
          {
            name: EXT_NVM
            variant: Unbuffered
            absorb: false
            secret: false
            sw_digest: false
            hw_digest: false
            write_lock: None
            read_lock: CSR
            key_sel: NoKey
            integrity: false
            bkout_type: false
            zeroizable: false
            items:
            [
              {
                name: EXT_NVM_ANTIREPLAY_FRESHNESS_CNT
                size: 1024
                desc:
                  '''
                  Fully SW managed partition
                  1 bit (double bit allocated for redundancy - i.e. 2 physical bits for every logical bit) per day
                  assuming 10 year product lifecycle, allocating 8192 bits of freshness protection.
                  Implemented as thermometer encoding. Redundant bit programming & logical OR-ing managed by
                  software. Cannot be ECC protected since different bits in a fuse row are programmed at different times.
                  '''
                isdigest: false
                iszer: false
                ismubi: false
                iskeymgr_creator: false
                iskeymgr_owner: false
                inv_default: 0
                offset: 5072
              }
            ]
            desc: Anti-replay protection Strike Counters partition.
            iskeymgr_creator: false
            iskeymgr_owner: false
            ignore_read_lock_in_rma: false
            size: 1024
            offset: 5072
          }
          {
            name: ROM_PATCH
            variant: Unbuffered
            absorb: true
            secret: false
            sw_digest: true
            hw_digest: false
            write_lock: Digest
            read_lock: CSR
            key_sel: NoKey
            integrity: true
            bkout_type: false
            zeroizable: false
            items:
            [
              {
                name: ROM_PATCH_DATA
                size: 9192
                desc:
                  '''
                  Fully SW managed partition
                  ROM patch section
                  signed patch(es)
                  Each patch Contains header, signature, patch match/redirect configuration and patch code
                  Please refer to the ROM boot & patching specification for Integrated OT for more details
                  '''
                isdigest: false
                iszer: false
                ismubi: false
                iskeymgr_creator: false
                iskeymgr_owner: false
                inv_default: 0
                offset: 6096
              }
              {
                name: ROM_PATCH_DIGEST
                size: 8
                offset: 15944
                ismubi: false
                isdigest: true
                iszer: false
                inv_default: 14592557388175589354
                iskeymgr_creator: false
                iskeymgr_owner: false
              }
            ]
            desc: ROM Patch Code section. May contain multiple signed ROM2 patches.
            iskeymgr_creator: false
            iskeymgr_owner: false
            ignore_read_lock_in_rma: false
            size: 9856
            offset: 6096
          }
          {
            name: HW_CFG0
            variant: Buffered
            secret: false
            sw_digest: false
            hw_digest: true
            write_lock: Digest
            read_lock: None
            key_sel: NoKey
            integrity: true
            bkout_type: true
            zeroizable: false
            skip_sw_header: true
            items:
            [
              {
                name: DEVICE_ID
                size: 32
                inv_default: 40117173308102545085356168480633505499540504862520500713288653871548071919464
                isdigest: false
                iszer: false
                ismubi: false
                iskeymgr_creator: false
                iskeymgr_owner: false
                offset: 15952
              }
              {
                name: MANUF_STATE
                size: 32
                inv_default: 104735823630885006896435419055152518946049592294862500793111622154345667968901
                isdigest: false
                iszer: false
                ismubi: false
                iskeymgr_creator: false
                iskeymgr_owner: false
                offset: 15984
              }
              {
                name: HW_CFG0_DIGEST
                size: 8
                offset: 16016
                ismubi: false
                isdigest: true
                iszer: false
                inv_default: 8050338520295093693
                iskeymgr_creator: false
                iskeymgr_owner: false
              }
            ]
            desc:
              '''
              Hardware configuration 0 partition.
              This contains
              - DEVICE_ID: Unique device identifier.
              - MANUF_STATE: Vector for capturing the manufacturing status.
              '''
            absorb: false
            iskeymgr_creator: false
            iskeymgr_owner: false
            ignore_read_lock_in_rma: false
            size: 72
            offset: 15952
          }
          {
            name: HW_CFG1
            variant: Buffered
            secret: false
            sw_digest: false
            hw_digest: true
            write_lock: Digest
            read_lock: None
            key_sel: NoKey
            integrity: true
            bkout_type: true
            zeroizable: false
            skip_sw_header: true
            items:
            [
              {
                name: SOC_DBG_STATE
                size: 4
                inv_default: 0
                desc:
                  '''
                  Multibit enable value for the SOC debug authorization.
                  Encoding:
                  SOC_DBG_RAW: this value is all-zeroes and will be the NOP state;
                  the LC controller will take precedence.
                  SOC_DBG_PRE_PROD: this is where the ROT will be in PROD state
                  but SOC will be in the pre-production unlock state
                  SOC_DBG_PROD: this is the state where the SOC moves to production,
                  and the challenge-response based authentication protocol is
                  required to unlock SOC debug features
                  '''
                isdigest: false
                iszer: false
                ismubi: false
                iskeymgr_creator: false
                iskeymgr_owner: false
                offset: 16024
              }
              {
                name: EN_CSRNG_SW_APP_READ
                size: 1
                ismubi: true
                inv_default: 105
                desc:
                  '''
                  Enablement of CSRNG software application interface. A
                  kMultiBitBool8True value enables, while all other values
                  disable. Enablement is required to extract output from
                  CSRNG via software.
                  '''
                isdigest: false
                iszer: false
                iskeymgr_creator: false
                iskeymgr_owner: false
                offset: 16028
              }
              {
                name: EN_SRAM_IFETCH
                size: 1
                ismubi: true
                inv_default: 105
                isdigest: false
                iszer: false
                iskeymgr_creator: false
                iskeymgr_owner: false
                offset: 16029
              }
              {
                name: HW_CFG1_DIGEST
                size: 8
                offset: 16032
                ismubi: false
                isdigest: true
                iszer: false
                inv_default: 2245725931179433842
                iskeymgr_creator: false
                iskeymgr_owner: false
              }
            ]
            desc:
              '''
              Hardware configuration 1 partition.
              This contains
              EN_SRAM_IFETCH: Enable / disable execute from SRAM CSR switch.
              SOC_DBG_STATE: Multibit enable value for the SOC debug authorization.
              Note SOC_DBG_STATE will be written twice in a device lifetime. The
              values to be written are engineered in the same way as the LC_CTRL
              state encoding words: the ECC encoding remains valid even after
              writing the second value on top of the first.

              The constants can be found in the lc_ctrl_state_pkg.sv package.

              The programming order has to adhere to:

              SOC_DBG_RAW -> SOC_DBG_PRE_PROD -> SOC_DBG_PROD.
              '''
            absorb: false
            iskeymgr_creator: false
            iskeymgr_owner: false
            ignore_read_lock_in_rma: false
            size: 16
            offset: 16024
          }
          {
            name: SECRET0
            variant: Buffered
            secret: true
            sw_digest: false
            hw_digest: true
            write_lock: Digest
            read_lock: Digest
            ignore_read_lock_in_rma: true
            key_sel: Secret0Key
            integrity: true
            bkout_type: false
            zeroizable: true
            skip_sw_header: true
            items:
            [
              {
                name: TEST_UNLOCK_TOKEN
                inv_default: 42146219275086284332081154515457931983
                size: 16
                isdigest: false
                iszer: false
                ismubi: false
                iskeymgr_creator: false
                iskeymgr_owner: false
                offset: 16040
              }
              {
                name: TEST_EXIT_TOKEN
                inv_default: 241193388044955693821746483131132302114
                size: 16
                isdigest: false
                iszer: false
                ismubi: false
                iskeymgr_creator: false
                iskeymgr_owner: false
                offset: 16056
              }
              {
                name: SECRET0_DIGEST
                size: 8
                offset: 16072
                ismubi: false
                isdigest: true
                iszer: false
                inv_default: 15994060125354592494
                iskeymgr_creator: false
                iskeymgr_owner: false
              }
              {
                name: SECRET0_ZER
                size: 8
                offset: 16080
                ismubi: false
                isdigest: false
                iszer: true
                inv_default: 0
                iskeymgr_creator: false
                iskeymgr_owner: false
              }
            ]
            desc:
              '''
              Secret partition 0.
              This contains TEST lifecycle unlock tokens.
              '''
            absorb: false
            iskeymgr_creator: false
            iskeymgr_owner: false
            size: 48
            offset: 16040
          }
          {
            name: SECRET1
            variant: Buffered
            secret: true
            sw_digest: false
            hw_digest: true
            write_lock: Digest
            read_lock: Digest
            ignore_read_lock_in_rma: true
            key_sel: Secret1Key
            integrity: true
            bkout_type: false
            zeroizable: true
            skip_sw_header: true
            items:
            [
              {
                name: SRAM_DATA_KEY_SEED
                inv_default: 49610584572420053792236730456054518552
                size: 16
                isdigest: false
                iszer: false
                ismubi: false
                iskeymgr_creator: false
                iskeymgr_owner: false
                offset: 16088
              }
              {
                name: SECRET1_DIGEST
                size: 8
                offset: 16104
                ismubi: false
                isdigest: true
                iszer: false
                inv_default: 9694113004490520906
                iskeymgr_creator: false
                iskeymgr_owner: false
              }
              {
                name: SECRET1_ZER
                size: 8
                offset: 16112
                ismubi: false
                isdigest: false
                iszer: true
                inv_default: 0
                iskeymgr_creator: false
                iskeymgr_owner: false
              }
            ]
            desc:
              '''
              Secret partition 1.
              This contains the SRAM scrambling key seed.
              '''
            absorb: false
            iskeymgr_creator: false
            iskeymgr_owner: false
            size: 32
            offset: 16088
          }
          {
            name: SECRET2
            variant: Buffered
            secret: true
            sw_digest: false
            hw_digest: true
            write_lock: Digest
            read_lock: Digest
            ignore_read_lock_in_rma: true
            key_sel: Secret2Key
            integrity: true
            bkout_type: false
            zeroizable: true
            skip_sw_header: true
            items:
            [
              {
                name: RMA_TOKEN
                inv_default: 318948098383762964490193881142352172697
                size: 16
                isdigest: false
                iszer: false
                ismubi: false
                iskeymgr_creator: false
                iskeymgr_owner: false
                offset: 16120
              }
              {
                name: CREATOR_ROOT_KEY_SHARE0
                inv_default: 34629914360704372211018394036838819133727768471239971144446686782216090585462
                size: 32
                iskeymgr_creator: true
                isdigest: false
                iszer: false
                ismubi: false
                iskeymgr_owner: false
                offset: 16136
              }
              {
                name: CREATOR_ROOT_KEY_SHARE1
                inv_default: 1304928998077618167994330237584170289335028615580548538480488972898025704836
                size: 32
                iskeymgr_creator: true
                isdigest: false
                iszer: false
                ismubi: false
                iskeymgr_owner: false
                offset: 16168
              }
              {
                name: CREATOR_SEED
                inv_default: 17833865895625802678504757898438306129490488436729400947978243968268591742052
                size: 32
                iskeymgr_creator: true
                isdigest: false
                iszer: false
                ismubi: false
                iskeymgr_owner: false
                offset: 16200
              }
              {
                name: SECRET2_DIGEST
                size: 8
                offset: 16232
                ismubi: false
                isdigest: true
                iszer: false
                inv_default: 6520999107440904866
                iskeymgr_creator: false
                iskeymgr_owner: false
              }
              {
                name: SECRET2_ZER
                size: 8
                offset: 16240
                ismubi: false
                isdigest: false
                iszer: true
                inv_default: 0
                iskeymgr_creator: false
                iskeymgr_owner: false
              }
            ]
            desc:
              '''
              Secret partition 2.
              This contains RMA unlock token, creator root key, and creator seed.
              '''
            absorb: false
            iskeymgr_creator: true
            iskeymgr_owner: false
            size: 128
            offset: 16120
          }
          {
            name: SECRET3
            variant: Buffered
            secret: true
            sw_digest: false
            hw_digest: true
            write_lock: Digest
            read_lock: Digest
            key_sel: Secret3Key
            integrity: true
            bkout_type: false
            zeroizable: true
            skip_sw_header: true
            items:
            [
              {
                name: OWNER_SEED
                inv_default: 70686486377297932620694155829978992075095653265301635643322899792586608109306
                size: 32
                iskeymgr_owner: true
                isdigest: false
                iszer: false
                ismubi: false
                iskeymgr_creator: false
                offset: 16248
              }
              {
                name: SECRET3_DIGEST
                size: 8
                offset: 16280
                ismubi: false
                isdigest: true
                iszer: false
                inv_default: 13418438502867544032
                iskeymgr_creator: false
                iskeymgr_owner: false
              }
              {
                name: SECRET3_ZER
                size: 8
                offset: 16288
                ismubi: false
                isdigest: false
                iszer: true
                inv_default: 0
                iskeymgr_creator: false
                iskeymgr_owner: false
              }
            ]
            desc:
              '''
              Secret partition 3.
              This contains the owner seed.
              '''
            absorb: false
            iskeymgr_creator: false
            iskeymgr_owner: true
            ignore_read_lock_in_rma: false
            size: 48
            offset: 16248
          }
          {
            name: LIFE_CYCLE
            variant: LifeCycle
            secret: false
            sw_digest: false
            hw_digest: false
            write_lock: None
            read_lock: None
            key_sel: NoKey
            integrity: true
            bkout_type: false
            skip_sw_header: true
            items:
            [
              {
                name: LC_TRANSITION_CNT
                inv_default: 14973992796729436808066378999705846639531905052544376352002892737561959261552710366946253675634166805643724298065935
                size: 48
                isdigest: false
                iszer: false
                ismubi: false
                iskeymgr_creator: false
                iskeymgr_owner: false
                offset: 16296
              }
              {
                name: LC_STATE
                inv_default: 1740163610035578858103898302773429044443128827890610586479008287934284440493394280935669489663884
                size: 40
                isdigest: false
                iszer: false
                ismubi: false
                iskeymgr_creator: false
                iskeymgr_owner: false
                offset: 16344
              }
            ]
            desc:
              '''
              Lifecycle partition.
              This contains lifecycle transition count and state. This partition
              cannot be locked since the life cycle state needs to advance to RMA
              in-field. Note that while this partition is not marked secret, it
              is not readable nor writeable via the DAI. Only the LC controller
              can access this partition, and even via the LC controller it is not
              possible to read the raw manufacturing life cycle state in encoded
              form, since that encoding is considered a netlist secret. The LC
              controller only exposes a decoded version of this state.
              '''
            absorb: false
            iskeymgr_creator: false
            iskeymgr_owner: false
            zeroizable: false
            ignore_read_lock_in_rma: false
            size: 88
            offset: 16296
          }
        ]
      }
    }
    {
      name: lc_ctrl
      type: lc_ctrl
      base_addrs:
      {
        regs:
        {
          hart: 0x30150000
        }
        dmi:
        {
          soc_dbg: 0x3000
        }
      }
      memory: {}
      param_list:
      [
        {
          name: RndCnstLcKeymgrDivInvalid
          desc: Diversification value used for all invalid life cycle states.
          type: lc_ctrl_pkg::lc_keymgr_div_t
          randcount: 128
          randtype: data
          name_top: RndCnstLcCtrlLcKeymgrDivInvalid
          default: 0x722a788a2fa6d50784bd3b82d9d4653d
          randwidth: 128
        }
        {
          name: RndCnstLcKeymgrDivTestUnlocked
          desc: Diversification value used for the TEST_UNLOCKED* life cycle states.
          type: lc_ctrl_pkg::lc_keymgr_div_t
          randcount: 128
          randtype: data
          name_top: RndCnstLcCtrlLcKeymgrDivTestUnlocked
          default: 0xe5a5288e14d20d64d95e54c5b57d5fe6
          randwidth: 128
        }
        {
          name: RndCnstLcKeymgrDivDev
          desc: Diversification value used for the DEV life cycle state.
          type: lc_ctrl_pkg::lc_keymgr_div_t
          randcount: 128
          randtype: data
          name_top: RndCnstLcCtrlLcKeymgrDivDev
          default: 0x1f96e6c540d47a3c4757ec8a8986b08f
          randwidth: 128
        }
        {
          name: RndCnstLcKeymgrDivProduction
          desc: Diversification value used for the PROD/PROD_END life cycle states.
          type: lc_ctrl_pkg::lc_keymgr_div_t
          randcount: 128
          randtype: data
          name_top: RndCnstLcCtrlLcKeymgrDivProduction
          default: 0xcb77d0831159f3250b813449c66dcbb0
          randwidth: 128
        }
        {
          name: RndCnstLcKeymgrDivRma
          desc: Diversification value used for the RMA life cycle state.
          type: lc_ctrl_pkg::lc_keymgr_div_t
          randcount: 128
          randtype: data
          name_top: RndCnstLcCtrlLcKeymgrDivRma
          default: 0x21f7a92cf5c0c6ae053b995562d7fcaf
          randwidth: 128
        }
        {
          name: RndCnstInvalidTokens
          desc: Compile-time random bits used for invalid tokens in the token mux
          type: lc_ctrl_pkg::lc_token_mux_t
          randcount: 1024
          randtype: data
          name_top: RndCnstLcCtrlInvalidTokens
          default: 0x6ddca62003655ceb43f3e842f268fbe26bda6f7fb2d7f5c5a0bc44a9ae1e094d11eb4ce4297a9b8ea751d5730c85237ab633c27080416fbcbca04bc1fe5d4087c45f755d6824ec5d5e48742dd52e434b64d69e2e2ff6ad2c726ff1aec6468a27e6fba3203934135d0eec1a8769c1e22ffbc6d0cee9597baf791f6ed7367ff7e8
          randwidth: 1024
        }
      ]
    }
    {
      name: alert_handler
      type: alert_handler
      base_addrs:
      {
        null:
        {
          hart: 0x30160000
        }
      }
      memory: {}
      param_list:
      [
        {
          name: RndCnstLfsrSeed
          desc: Compile-time random bits for initial LFSR seed
          type: alert_handler_pkg::lfsr_seed_t
          randcount: 32
          randtype: data
          name_top: RndCnstAlertHandlerLfsrSeed
          default: 0x869207ed
          randwidth: 32
        }
        {
          name: RndCnstLfsrPerm
          desc: Compile-time random permutation for LFSR output
          type: alert_handler_pkg::lfsr_perm_t
          randcount: 32
          randtype: perm
          name_top: RndCnstAlertHandlerLfsrPerm
          default: 0xe35c612fc8afe44b654c853097867dd94f1be860
          randwidth: 160
        }
      ]
      template_type: alert_handler
    }
    {
      name: sram_ctrl_ret
      type: sram_ctrl
      base_addrs:
      {
        regs:
        {
          hart: 0x30500000
        }
        ram:
        {
          hart: 0x30600000
        }
      }
      memory:
      {
        ram:
        {
          label: ram_ret_aon
          swaccess: rw
          data_intg_passthru: "true"
          exec: True
          byte_write: True
          size: 0x1000
        }
      }
      param_list:
      [
        {
          name: RndCnstSramKey
          desc: Compile-time random reset value for SRAM scrambling key.
          type: otp_ctrl_pkg::sram_key_t
          randcount: 128
          randtype: data
          name_top: RndCnstSramCtrlRetSramKey
          default: 0x792b7da71dd3e63d444a8f8d3187278
          randwidth: 128
        }
        {
          name: RndCnstSramNonce
          desc: Compile-time random reset value for SRAM scrambling nonce.
          type: otp_ctrl_pkg::sram_nonce_t
          randcount: 128
          randtype: data
          name_top: RndCnstSramCtrlRetSramNonce
          default: 0x8bc872f9b80347177c4a9a3f840b2f50
          randwidth: 128
        }
        {
          name: RndCnstLfsrSeed
          desc: Compile-time random bits for initial LFSR seed
          type: sram_ctrl_pkg::lfsr_seed_t
          randcount: 64
          randtype: data
          name_top: RndCnstSramCtrlRetLfsrSeed
          default: 0xcb196701842511ea
          randwidth: 64
        }
        {
          name: RndCnstLfsrPerm
          desc: Compile-time random permutation for LFSR output
          type: sram_ctrl_pkg::lfsr_perm_t
          randcount: 64
          randtype: perm
          name_top: RndCnstSramCtrlRetLfsrPerm
          default: 0x17d9df4ebbaa682715bfa6ffe76934dd846500f5fc762506d44050229b5e2e133098e5a0663cb32b8b3e3432684bb1f1
          randwidth: 384
        }
      ]
    }
    {
      name: aes
      type: aes
      base_addrs:
      {
        null:
        {
          hart: 0x21100000
        }
      }
      memory: {}
      param_list:
      [
        {
          name: RndCnstClearingLfsrSeed
          desc: Default seed of the PRNG used for register clearing.
          type: aes_pkg::clearing_lfsr_seed_t
          randcount: 64
          randtype: data
          name_top: RndCnstAesClearingLfsrSeed
          default: 0x2cc5a50b94886c60
          randwidth: 64
        }
        {
          name: RndCnstClearingLfsrPerm
          desc: Permutation applied to the LFSR of the PRNG used for clearing.
          type: aes_pkg::clearing_lfsr_perm_t
          randcount: 64
          randtype: perm
          name_top: RndCnstAesClearingLfsrPerm
          default: 0x5938c856b601146734351f6989ab7bdec6cb4bc87992fcffa979990303830ba2719f529e31fda5a2ef9443880774f132
          randwidth: 384
        }
        {
          name: RndCnstClearingSharePerm
          desc: Permutation applied to the clearing PRNG output for clearing the second share of registers.
          type: aes_pkg::clearing_lfsr_perm_t
          randcount: 64
          randtype: perm
          name_top: RndCnstAesClearingSharePerm
          default: 0x27c6c22de24f6ad6589417eeb71cd9ae66bee3d3f45fd9c32119b49d54abe00f9c8f381c28cd76a92c443c4c909859e
          randwidth: 384
        }
        {
          name: RndCnstMaskingLfsrSeed
          desc: Default seed of the PRNG used for masking.
          type: aes_pkg::masking_lfsr_seed_t
          randcount: 288
          randtype: data
          name_top: RndCnstAesMaskingLfsrSeed
          default: 0xccc4b270a9c0dfd4abd37bcde2cfc891e919bd3fed814528a693bfa5292f2dfccedb7ccd
          randwidth: 288
        }
        {
          name: RndCnstMaskingLfsrPerm
          desc: Permutation applied to the output of the PRNG used for masking.
          type: aes_pkg::masking_lfsr_perm_t
          randcount: 160
          randtype: perm
          name_top: RndCnstAesMaskingLfsrPerm
          default: 0x4820621c8f251864833b96821e310e0c608a9b7e306a3f5b4b17636b531636512977276c695f0947459f210f37703d1b92545839035c7f6610002d15193c4c4d025699220d862c2b069c554372440a7d6e61947689085e9a95986f938724658b3e1312807b429e0185730b3526759750148c1a4e324184712f57408e9d4649818868112a90077a342e2379385d28914f5a7c746d671d594a528d04051f3a3378
          randwidth: 1280
        }
      ]
    }
    {
      name: kmac
      type: kmac
      base_addrs:
      {
        null:
        {
          hart: 0x21120000
        }
      }
      memory: {}
      param_list:
      [
        {
          name: RndCnstLfsrSeed
          desc: Compile-time random data for PRNG default seed
          type: kmac_pkg::lfsr_seed_t
          randcount: 288
          randtype: data
          name_top: RndCnstKmacLfsrSeed
          default: 0xdac323093759ebc8b6a87b66f0faeeef05efdac7d8e2cc0ae938f1759a842ccdf4b2ec9
          randwidth: 288
        }
        {
          name: RndCnstLfsrPerm
          desc: Compile-time random permutation for PRNG output
          type: kmac_pkg::lfsr_perm_t
          randcount: 800
          randtype: perm
          name_top: RndCnstKmacLfsrPerm
          default: 0x662297519a6c0f61da396b6b90bdc04ac9a7313b1f582ba0c8736fb1c94b5671b20ac9a9edc88e2e4792abc004b80adbcd46696c211f09a5706672b6c7e94c72103a61b3183f015999b1e05695c1247f08ca50064cc4c5c4d70b2b9420b5c56d0e71298b3247a7299b07ce3085ed74e4d4e6b58fd9ec062521d4a864898917d0407710cb953d94685f081f042c2a6818c25ad189410da72eb5c9bcb8ac0450d5c798d60e9873b193b952621f4800168a16259ad522a68b3a8f4cd5f9660f29c2990e2d9ad7b67717c1f0876c3c6bd093b5c8a7836aaa3b485cf49e03846082744813ed810a6e34de3c59ffaf205525fa7de9b64a53680f2374f955ef89047868a3a301979aaa2022db9e82a3aade30ec30b9ab8c4d2afaf709714559554d179480e4a95156a461404c44f845018952c6fd5e28143125448079ece68593d97c8dc340d4c0886286f9cefe5a1f54c5aa15c592428d95d67b6817316fc2ce97262ff88174691fd5a67242cf8009896dec51c2f9acc6791a6f41e55ab20a9c24f5f02ca4a1309aad79452ae1637443d655657e2f6412f42809b429708992d3451bbea0206553834cd1ec5f389bb5b0132e12c379d2408dc358a4aac4e4fe51b40793ddb34e996026147b074b31e15061298a7704ad90c14843da8b205a3ae8a6c6ec9d8f4182740627d53a5e924fc89db81c632219328568b6324e861ef6f841601c11b0408d906201d07a24756c28545b5112d620c1b09e86abca68ac3267cbe23d1da0a91a246a502d24a0c11acda7fa8eb5cbb5b61a350f05fca10d5fc997057896a79d4da10339b6a350e30bb9d7b040e8e09663a6902eed6e884615d9c01101babf5cc20a405bc6ad4bbd71aec4622c1d360fd248ef205eba82a8915f31924837c5545b0c7da714dc942f2ca7ee85131083d558ab8f1725a3871f10564ba31005f8248f1362b10e00ee39823e078b245c624471187ee58109c028a870e3788a640e2ea1427fbc70ead242ba45e1a46dadc00381ea69cbfc0ce5bc96f79a9f135848d62f4697576b180dccc25e0b576e4a0d1f4beb2052ba9119198e612ac110d0cea5a932bca232c8e18d453a1381f899145ac4f2c68a9b27e69d8382277ec72d27eb7c668865a2ea541f0bda66673f8933ee803eb02579617a4b7491c72d581a1cc77565ca20a3824aa4a5a694ae7b110570926b864a97465232f5552014ba171d6cb64e7c8d26644cb62a5de27db67620c1603aaa40ca6ad3a8550c3d64791b93cc3eb451c36d23770ff4894463cd75b9ae24679c28d940d8651d603b1878cf1d0aeb1068e15d831642e61cecd3422cb3e7833e402157a176bd4665b0edcbb75bf2780f6f5f2776a48785695a3dc54ca71a587594c12f100e6b0876757bb12070685dc5371054
          randwidth: 8000
        }
        {
          name: RndCnstBufferLfsrSeed
          desc: Compile-time random data for PRNG buffer default seed
          type: kmac_pkg::buffer_lfsr_seed_t
          randcount: 800
          randtype: data
          name_top: RndCnstKmacBufferLfsrSeed
          default: 0x4eeab2cb48658673c5090fd03a6691079f269a2c4e75e01b250eda1845a3ba41613cff3edbf802d571e7ce403175d29c8626841da8319954bac164d043f0e2db0eed7dc7acc05b042a3b0d84089ff2c44e2d7678924d4fa99f1120c5235af18eeda8546d
          randwidth: 800
        }
        {
          name: RndCnstMsgPerm
          desc: Compile-time random permutation for LFSR Message output
          type: kmac_pkg::msg_perm_t
          randcount: 64
          randtype: perm
          name_top: RndCnstKmacMsgPerm
          default: 0x9bf4b091ca466a08c784dca59cf09b0c554a7b15b6a3400e511b37bc441d7d7bb9cf523e67cf6da81253ea22d8af833b
          randwidth: 384
        }
      ]
    }
    {
      name: otbn
      type: otbn
      base_addrs:
      {
        null:
        {
          hart: 0x21130000
        }
      }
      memory: {}
      param_list:
      [
        {
          name: RndCnstUrndPrngSeed
          desc: Default seed of the PRNG used for URND.
          type: otbn_pkg::urnd_prng_seed_t
          randcount: 288
          randtype: data
          name_top: RndCnstOtbnUrndPrngSeed
          default: 0x45eafed86197812700d8b2054a4e2d7f43f958574f82c637c99a345ec541edaa20bb9295
          randwidth: 288
        }
        {
          name: RndCnstUrndPerm
          desc: Compile-time random permutation applied to the primary URND output, directly after the PRNG and before it is distributed to the rest of the design.
          type: otbn_pkg::urnd_perm_t
          randcount: 389
          randtype: perm
          name_top: RndCnstOtbnUrndPerm
          default: 0x12b6d9a626a2b2d8a25278024212b63c3d2e09e0b0087c9fbd9e68c800ecf23cb2752ae36bf9ed0efe5732bb98cba338f248214a141cb117ad085a497889caa171c466a0354c1c306bbb58a0c4e6bf4caa2545a829e4d496c564d0f58b2ed3185b86e02d668afa069a7e52f02c85004cbb4c26b79f04861c14d6b33a948fe0e8d10e20f39f3769e765c36958e1ad2b85e5c69290f6260045e1c9698a0968581bb72ee6e44ca53a0c2294c836683052d8bd62ab444246706a400f821119e9bba8c28001a25049e842c8940d546c5e1990c6bd3ad0c0bea2895222654ae88685834c18242c0993073307cbceb9a92ead2e05dc5dec232336c22b3e1de512abb4c152fb63c366f6f6ac74253a738a83d1ca4ba66629190b0ad6a01c22b74a7f298745f6c984b73b085808ed0723822818391c5275e9188c088d7d1f9114837abee55f0c9b2cf58b6cbd72814ac5aa77304a39d94da3b4de1217b9387605a2a9f0040341cef8c4ac8daf263aba2e72971cbfca2f9101d2580892a71db84582f1c76eb258d243d088c5068c3e8cd5138550d02b55bd4fd82a39a4285c463d37e6cfd6501cda5a71570855d1f87132917b3a10ea53547d1ea1
          randwidth: 3501
        }
        {
          name: RndCnstBnMacUrndPerm
          desc: Compile-time random permutation for URND permutation in BN MAC.
          type: otbn_pkg::bn_mac_urnd_perm_t
          randcount: 256
          randtype: perm
          name_top: RndCnstOtbnBnMacUrndPerm
          default: 0xe4ae650d2b50ca8f489d292e9862afcceda08879665d59a4df2086a7684edb8af255ee27fc2558516741ffb7e78cac14a299c607199f709196f931b5dd107aa33eb1b6a6814706f5a56b4c1ea1b2386a36d4cb39a9ab7c921c951bf4d3453d409453faea782f161d2dd6231512e0e94f04ba00bec36080de89f89e4bd977fb26e29cb842dae6fe0ed58b1f18b3326d8757ebbc177b495e224a71ef8e0baac23f24bb525fd705c7850af328302cb4e3560184d2c45a356ebf7661dc97c982b99bd13cc1f60854b07d37cd93fd098d1a0fbd647f4313c02183cef1757263cf2aeca802e146e8e5745c5b7e44d0f70cc89034034df011c5696f333a9aad3b736cd8
          randwidth: 2048
        }
        {
          name: RndCnstMaiUrndPerm
          desc: Compile-time random permutation for URND permutation in MAI.
          type: otbn_pkg::mai_urnd_perm_t
          randcount: 389
          randtype: perm
          name_top: RndCnstOtbnMaiUrndPerm
          default: 0xaa49694f4f35c8dd54aaae054cc60a5ec696539d52b76da198808f9a41fd1250ad06c9d2b4c5a307809a8717751303156e26b9df51b26661108d6f37c0e2c69891e508823692a2aebb88d551537d88d370a263d6b95606d102409b1a683a490ac52e44f502f0b82b2eb56eecf5647196bec13e90b1f6d42e742c5ab664e6e59256975207c30a8ef0b80248e90fc6221014c88462d73ec22dc8767082b0079f94491780c1f25ee26e4165b3792bc6cd20478b97efcb651c864d5216ee833afbdc64c0554e18e916989d84f45cad194e698c1d014583289da7639351c2e77288a053ca6c6d246aaf59e1e4743162725f098f4183764069c806bf530331e1d8bccd594b4115edb8cac16d3364da5d8421cd9096bd443ca6d009dae0b2c34a1d2eacd2b89612679102222ad6e9f85b3e58d89d12e31a4e423c366113d2ab55fdad3060de93b5d408a46d3d293f516a1571001d0d1f0a91411b5a8e84ee41d86e17c4bbe0bc533c37c0a108bde65241abacd74909638c750e8e8fdbcd88d310ea0299114eed146159e6550b502c0f6681e91cd21c1862671019ee6950528c1fcf032b8016ff12192ecab94270d001a7518e14154878509f
          randwidth: 3501
        }
        {
          name: RndCnstOtbnKey
          desc: Compile-time random reset value for IMem/DMem scrambling key.
          type: otp_ctrl_pkg::otbn_key_t
          randcount: 128
          randtype: data
          name_top: RndCnstOtbnOtbnKey
          default: 0xed46051c8a570336b49d386c69d93864
          randwidth: 128
        }
        {
          name: RndCnstOtbnNonce
          desc: Compile-time random reset value for IMem/DMem scrambling nonce.
          type: otp_ctrl_pkg::otbn_nonce_t
          randcount: 64
          randtype: data
          name_top: RndCnstOtbnOtbnNonce
          default: 0xa9284ab703ccee4
          randwidth: 64
        }
      ]
    }
    {
      name: keymgr_dpe
      type: keymgr_dpe
      base_addrs:
      {
        null:
        {
          hart: 0x21140000
        }
      }
      memory: {}
      param_list:
      [
        {
          name: RndCnstLfsrSeed
          desc: Compile-time random bits for initial LFSR seed
          type: keymgr_pkg::lfsr_seed_t
          randcount: 64
          randtype: data
          name_top: RndCnstKeymgrDpeLfsrSeed
          default: 0x1fff9cb984752f8f
          randwidth: 64
        }
        {
          name: RndCnstLfsrPerm
          desc: Compile-time random permutation for LFSR output
          type: keymgr_pkg::lfsr_perm_t
          randcount: 64
          randtype: perm
          name_top: RndCnstKeymgrDpeLfsrPerm
          default: 0x899c6bdc76fa420982692a04cd1b1d60114697e3ade1f2767b2ab0f7f9e43ee4f55d58ca20b0fc00ce6135cbd6529ef4
          randwidth: 384
        }
        {
          name: RndCnstRandPerm
          desc: Compile-time random permutation for entropy used in share overriding
          type: keymgr_pkg::rand_perm_t
          randcount: 32
          randtype: perm
          name_top: RndCnstKeymgrDpeRandPerm
          default: 0xbed3dfc441a9387442d3c987a07a547296f660ad
          randwidth: 160
        }
        {
          name: RndCnstRevisionSeed
          desc: Compile-time random bits for revision seed
          type: keymgr_pkg::seed_t
          randcount: 256
          randtype: data
          name_top: RndCnstKeymgrDpeRevisionSeed
          default: 0xe47ad94f5821271e989d6bf03e6d542ca581a594a3386c070f167a20a40e1d28
          randwidth: 256
        }
        {
          name: RndCnstSoftOutputSeed
          desc: Compile-time random bits for software generation seed
          type: keymgr_pkg::seed_t
          randcount: 256
          randtype: data
          name_top: RndCnstKeymgrDpeSoftOutputSeed
          default: 0xba99dce506fc589be1de2d8ab7ac5145761eec8245451d88e292d0b0d1b10882
          randwidth: 256
        }
        {
          name: RndCnstHardOutputSeed
          desc: Compile-time random bits for hardware generation seed
          type: keymgr_pkg::seed_t
          randcount: 256
          randtype: data
          name_top: RndCnstKeymgrDpeHardOutputSeed
          default: 0xa692c834639f678325eea439476204210404c00b6f6efa3997e2b24e53c49217
          randwidth: 256
        }
        {
          name: RndCnstAesSeed
          desc: Compile-time random bits for generation seed when aes destination selected
          type: keymgr_pkg::seed_t
          randcount: 256
          randtype: data
          name_top: RndCnstKeymgrDpeAesSeed
          default: 0x9fe8105ac442a5ebc0f3d85163644ada3407543c75421f2aadf4c0892e3f7b37
          randwidth: 256
        }
        {
          name: RndCnstKmacSeed
          desc: Compile-time random bits for generation seed when kmac destination selected
          type: keymgr_pkg::seed_t
          randcount: 256
          randtype: data
          name_top: RndCnstKeymgrDpeKmacSeed
          default: 0x84405243a4aa4fb8970df6e0f78b643410259e59cda4fc00e7ed67286f310752
          randwidth: 256
        }
        {
          name: RndCnstOtbnSeed
          desc: Compile-time random bits for generation seed when otbn destination selected
          type: keymgr_pkg::seed_t
          randcount: 256
          randtype: data
          name_top: RndCnstKeymgrDpeOtbnSeed
          default: 0x618844d2f81c19255fe753b7995ccb8a2eec70f22745c139db09b25b0fedc9f6
          randwidth: 256
        }
        {
          name: RndCnstNoneSeed
          desc: Compile-time random bits for generation seed when no destination selected
          type: keymgr_pkg::seed_t
          randcount: 256
          randtype: data
          name_top: RndCnstKeymgrDpeNoneSeed
          default: 0x1c67905e31cc3f1003d7ab6375b104a4631fd6e1f9a5cacea485646e645f99c7
          randwidth: 256
        }
      ]
    }
    {
      name: csrng
      type: csrng
      base_addrs:
      {
        null:
        {
          hart: 0x21150000
        }
      }
      memory: {}
      param_list:
      [
        {
          name: RndCnstCsKeymgrDivNonProduction
          desc: Compile-time random bits for csrng state group diversification value
          type: csrng_pkg::cs_keymgr_div_t
          randcount: 384
          randtype: data
          name_top: RndCnstCsrngCsKeymgrDivNonProduction
          default: 0xd1b6d15df879cf35959c426cb94046ba8d481ec8854002a81e9142af6f4979cbf7fa885b54e5a543092670635efdac15
          randwidth: 384
        }
        {
          name: RndCnstCsKeymgrDivProduction
          desc: Compile-time random bits for csrng state group diversification value
          type: csrng_pkg::cs_keymgr_div_t
          randcount: 384
          randtype: data
          name_top: RndCnstCsrngCsKeymgrDivProduction
          default: 0x8c874489731aaff596844a2255800fecc42eeb5b0460f67ae2ff4389c0d614c4ea2c7ab8188edf8197d16afab1a92765
          randwidth: 384
        }
      ]
    }
    {
      name: sram_ctrl_main
      type: sram_ctrl
      base_addrs:
      {
        regs:
        {
          hart: 0x211c0000
        }
        ram:
        {
          hart: 0x10000000
        }
      }
      memory:
      {
        ram:
        {
          label: ram_main
          swaccess: rw
          data_intg_passthru: "true"
          exec: True
          byte_write: True
          size: 0x10000
        }
      }
      param_list:
      [
        {
          name: RndCnstSramKey
          desc: Compile-time random reset value for SRAM scrambling key.
          type: otp_ctrl_pkg::sram_key_t
          randcount: 128
          randtype: data
          name_top: RndCnstSramCtrlMainSramKey
          default: 0xd13b89fb9fb19038e92f8a0b479da25f
          randwidth: 128
        }
        {
          name: RndCnstSramNonce
          desc: Compile-time random reset value for SRAM scrambling nonce.
          type: otp_ctrl_pkg::sram_nonce_t
          randcount: 128
          randtype: data
          name_top: RndCnstSramCtrlMainSramNonce
          default: 0xd6f656f66df89f4d9aa5be606bedfb0c
          randwidth: 128
        }
        {
          name: RndCnstLfsrSeed
          desc: Compile-time random bits for initial LFSR seed
          type: sram_ctrl_pkg::lfsr_seed_t
          randcount: 64
          randtype: data
          name_top: RndCnstSramCtrlMainLfsrSeed
          default: 0x84f34c979b616815
          randwidth: 64
        }
        {
          name: RndCnstLfsrPerm
          desc: Compile-time random permutation for LFSR output
          type: sram_ctrl_pkg::lfsr_perm_t
          randcount: 64
          randtype: perm
          name_top: RndCnstSramCtrlMainLfsrPerm
          default: 0xe6db025e3fa1e1542f7dc2111a8af2e8a6ae24d1fdd92a938a931679910b830394625d379dd9353c50ff06601bef1f33
          randwidth: 384
        }
      ]
    }
    {
      name: sram_ctrl_mbox
      type: sram_ctrl
      base_addrs:
      {
        regs:
        {
          hart: 0x211d0000
        }
        ram:
        {
          hart: 0x11000000
        }
      }
      memory:
      {
        ram:
        {
          label: ram_mbox
          swaccess: rw
          data_intg_passthru: "true"
          exec: False
          byte_write: True
          size: 0x1000
        }
      }
      param_list:
      [
        {
          name: RndCnstSramKey
          desc: Compile-time random reset value for SRAM scrambling key.
          type: otp_ctrl_pkg::sram_key_t
          randcount: 128
          randtype: data
          name_top: RndCnstSramCtrlMboxSramKey
          default: 0x68f66822dc293e9994114acb4786c929
          randwidth: 128
        }
        {
          name: RndCnstSramNonce
          desc: Compile-time random reset value for SRAM scrambling nonce.
          type: otp_ctrl_pkg::sram_nonce_t
          randcount: 128
          randtype: data
          name_top: RndCnstSramCtrlMboxSramNonce
          default: 0xac237c2958ff0fbc9d282f01b3de6cf9
          randwidth: 128
        }
        {
          name: RndCnstLfsrSeed
          desc: Compile-time random bits for initial LFSR seed
          type: sram_ctrl_pkg::lfsr_seed_t
          randcount: 64
          randtype: data
          name_top: RndCnstSramCtrlMboxLfsrSeed
          default: 0xb76b3b1213b5e18c
          randwidth: 64
        }
        {
          name: RndCnstLfsrPerm
          desc: Compile-time random permutation for LFSR output
          type: sram_ctrl_pkg::lfsr_perm_t
          randcount: 64
          randtype: perm
          name_top: RndCnstSramCtrlMboxLfsrPerm
          default: 0x8f26237147a110b3301376719c518c34f0b39f9015efb56e21545499abd6b7a36987edbfc3cb994829ea75fabb8c8e0
          randwidth: 384
        }
      ]
    }
    {
      name: rom_ctrl0
      type: rom_ctrl
      base_addrs:
      {
        rom:
        {
          hart: 0x00008000
        }
        regs:
        {
          hart: 0x211e0000
        }
      }
      memory:
      {
        rom:
        {
          label: rom0
          swaccess: ro
          data_intg_passthru: True
          exec: True
          byte_write: False
          size: 0x8000
        }
      }
      param_list:
      [
        {
          name: RndCnstScrNonce
          desc: Fixed nonce used for address / data scrambling
          type: bit [63:0]
          randcount: 64
          randtype: data
          name_top: RndCnstRomCtrl0ScrNonce
          default: 0x6166d362fbffee75
          randwidth: 64
        }
        {
          name: RndCnstScrKey
          desc: Randomised constant used as a scrambling key for ROM data
          type: bit [127:0]
          randcount: 128
          randtype: data
          name_top: RndCnstRomCtrl0ScrKey
          default: 0xc4523ff84a85ffd09d820f33db35128a
          randwidth: 128
        }
      ]
    }
    {
      name: rom_ctrl1
      type: rom_ctrl
      base_addrs:
      {
        rom:
        {
          hart: 0x00020000
        }
        regs:
        {
          hart: 0x211e1000
        }
      }
      memory:
      {
        rom:
        {
          label: rom1
          swaccess: ro
          data_intg_passthru: True
          exec: True
          byte_write: False
          size: 0x10000
        }
      }
      param_list:
      [
        {
          name: RndCnstScrNonce
          desc: Fixed nonce used for address / data scrambling
          type: bit [63:0]
          randcount: 64
          randtype: data
          name_top: RndCnstRomCtrl1ScrNonce
          default: 0x76efb984de24fd55
          randwidth: 64
        }
        {
          name: RndCnstScrKey
          desc: Randomised constant used as a scrambling key for ROM data
          type: bit [127:0]
          randcount: 128
          randtype: data
          name_top: RndCnstRomCtrl1ScrKey
          default: 0x2d8f501a3b03b74330f2ceca6554ae38
          randwidth: 128
        }
      ]
    }
    {
      name: rv_core_ibex
      type: rv_core_ibex
      base_addrs:
      {
        cfg:
        {
          hart: 0x211f0000
        }
      }
      memory: {}
      param_list:
      [
        {
          name: RndCnstLfsrSeed
          desc: Default seed of the PRNG used for random instructions.
          type: ibex_pkg::lfsr_seed_t
          randcount: 32
          randtype: data
          name_top: RndCnstRvCoreIbexLfsrSeed
          default: 0x9069b37c
          randwidth: 32
        }
        {
          name: RndCnstLfsrPerm
          desc: Permutation applied to the LFSR of the PRNG used for random instructions.
          type: ibex_pkg::lfsr_perm_t
          randcount: 32
          randtype: perm
          name_top: RndCnstRvCoreIbexLfsrPerm
          default: 0xf5316d353caabec43850204e605f79ec4659adf2
          randwidth: 160
        }
        {
          name: RndCnstIbexKey
          desc: Default icache scrambling key
          type: logic [ibex_pkg::SCRAMBLE_KEY_W-1:0]
          randcount: 128
          randtype: data
          name_top: RndCnstRvCoreIbexIbexKey
          default: 0x171e38f5809ca85d4be0bcb326af7a8a
          randwidth: 128
        }
        {
          name: RndCnstIbexNonce
          desc: Default icache scrambling nonce
          type: logic [ibex_pkg::SCRAMBLE_NONCE_W-1:0]
          randcount: 64
          randtype: data
          name_top: RndCnstRvCoreIbexIbexNonce
          default: 0x39c0abab0c85b5e8
          randwidth: 64
        }
      ]
      template_type: rv_core_ibex
    }
  ]
}
