// Copyright lowRISC contributors (OpenTitan project).
// Licensed under the Apache License, Version 2.0, see LICENSE for details.
// SPDX-License-Identifier: Apache-2.0
//
// ------------------- W A R N I N G: A U T O - G E N E R A T E D   C O D E !! -------------------//
// PLEASE DO NOT HAND-EDIT THIS FILE. IT HAS BEEN AUTO-GENERATED WITH THE FOLLOWING COMMAND:
// util/topgen.py -t hw/top_darjeeling/data/top_darjeeling.hjson
//                -o hw/top_darjeeling/
{
  seed:
  {
    topgen_seed:
    {
      seed_mode: testing
      value: 30303603493614338660957087945302489777030192937656386903877022866265637632015
    }
    otp_img_seed:
    {
      seed_mode: testing
      value: 85452983286950371191603618368782861611109037138182535346147818831008789508651
    }
    lc_ctrl_seed:
    {
      seed_mode: testing
      value: 73183785937994765942105269559576336430731269166614113490738802526276329963158
    }
  }
  module:
  [
    {
      name: otp_ctrl
      type: otp_ctrl
      base_addrs:
      {
        core:
        {
          hart: 0x30130000
        }
      }
      memory: {}
      param_list:
      [
        {
          name: RndCnstLfsrSeed
          desc: Compile-time random bits for initial LFSR seed
          type: otp_ctrl_top_specific_pkg::lfsr_seed_t
          randcount: 40
          randtype: data
          name_top: RndCnstOtpCtrlLfsrSeed
          default: 0x163162d98e
          randwidth: 40
        }
        {
          name: RndCnstLfsrPerm
          desc: Compile-time random permutation for LFSR output
          type: otp_ctrl_top_specific_pkg::lfsr_perm_t
          randcount: 40
          randtype: perm
          name_top: RndCnstOtpCtrlLfsrPerm
          default: 0x99d5c22cf8c86cd6627de9c32856a5551496901407014821313709384198
          randwidth: 240
        }
        {
          name: RndCnstScrmblKeyInit
          desc: Compile-time random permutation for scrambling key/nonce register reset value
          type: otp_ctrl_top_specific_pkg::scrmbl_key_init_t
          randcount: 256
          randtype: data
          name_top: RndCnstOtpCtrlScrmblKeyInit
          default: 0xe9b374a3636a66f969aea3e98fc6f4892beb458d5b4bd644e79a35d690bbb852
          randwidth: 256
        }
        {
          name: RndCnstScrmblKey0
          desc: Compile-time scrambling key
          type: otp_ctrl_top_specific_pkg::key_t
          randcount: 128
          randtype: extdata
          name_top: RndCnstOtpCtrlScrmblKey0
          default: 0x688a9a20b68e0d35660e593f560f6866
          randwidth: 128
        }
        {
          name: RndCnstScrmblKey1
          desc: Compile-time scrambling key
          type: otp_ctrl_top_specific_pkg::key_t
          randcount: 128
          randtype: extdata
          name_top: RndCnstOtpCtrlScrmblKey1
          default: 0xa1ad90a50942397740ab78c5737a2379
          randwidth: 128
        }
        {
          name: RndCnstScrmblKey2
          desc: Compile-time scrambling key
          type: otp_ctrl_top_specific_pkg::key_t
          randcount: 128
          randtype: extdata
          name_top: RndCnstOtpCtrlScrmblKey2
          default: 0xc2ede5b25ec5514b680ccaab361c3f85
          randwidth: 128
        }
        {
          name: RndCnstScrmblKey3
          desc: Compile-time scrambling key
          type: otp_ctrl_top_specific_pkg::key_t
          randcount: 128
          randtype: extdata
          name_top: RndCnstOtpCtrlScrmblKey3
          default: 0x8e1c5cccc121a2c95d21294d190ab75c
          randwidth: 128
        }
        {
          name: RndCnstDigestConst0
          desc: Compile-time digest const
          type: otp_ctrl_top_specific_pkg::digest_const_t
          randcount: 128
          randtype: extdata
          name_top: RndCnstOtpCtrlDigestConst0
          default: 0x9c87e42745452d8a010a9f0ef3221d5
          randwidth: 128
        }
        {
          name: RndCnstDigestConst1
          desc: Compile-time digest const
          type: otp_ctrl_top_specific_pkg::digest_const_t
          randcount: 128
          randtype: extdata
          name_top: RndCnstOtpCtrlDigestConst1
          default: 0x4dcba329ff2f7d4b8a3acdb325087fab
          randwidth: 128
        }
        {
          name: RndCnstDigestIV0
          desc: Compile-time digest initial vector
          type: otp_ctrl_top_specific_pkg::digest_iv_t
          randcount: 64
          randtype: extdata
          name_top: RndCnstOtpCtrlDigestIV0
          default: 0xa0806e02a1fba55b
          randwidth: 64
        }
        {
          name: RndCnstDigestIV1
          desc: Compile-time digest initial vector
          type: otp_ctrl_top_specific_pkg::digest_iv_t
          randcount: 64
          randtype: extdata
          name_top: RndCnstOtpCtrlDigestIV1
          default: 0x9bd623e40aec9b61
          randwidth: 64
        }
        {
          name: RndCnstPartInvDefault
          desc: OTP invalid partition default for buffered partitions
          type: logic [131071:0]
          randcount: 131072
          randtype: extdata
          name_top: RndCnstOtpCtrlPartInvDefault
          default:
          [
            {
              size: 704
              items:
              [
                {
                  size: 320
                  inv_default: 1740163610035578858103898302773429044443128827890610586479008287934284440493394280935669489663884
                }
                {
                  size: 384
                  inv_default: 14973992796729436808066378999705846639531905052544376352002892737561959261552710366946253675634166805643724298065935
                }
              ]
            }
            {
              size: 384
              items:
              [
                {
                  size: 64
                  inv_default: 0
                }
                {
                  size: 64
                  inv_default: 13418438502867544032
                }
                {
                  size: 256
                  inv_default: 70686486377297932620694155829978992075095653265301635643322899792586608109306
                }
              ]
            }
            {
              size: 1024
              items:
              [
                {
                  size: 64
                  inv_default: 0
                }
                {
                  size: 64
                  inv_default: 6520999107440904866
                }
                {
                  size: 256
                  inv_default: 17833865895625802678504757898438306129490488436729400947978243968268591742052
                }
                {
                  size: 256
                  inv_default: 1304928998077618167994330237584170289335028615580548538480488972898025704836
                }
                {
                  size: 256
                  inv_default: 34629914360704372211018394036838819133727768471239971144446686782216090585462
                }
                {
                  size: 128
                  inv_default: 318948098383762964490193881142352172697
                }
              ]
            }
            {
              size: 256
              items:
              [
                {
                  size: 64
                  inv_default: 0
                }
                {
                  size: 64
                  inv_default: 9694113004490520906
                }
                {
                  size: 128
                  inv_default: 49610584572420053792236730456054518552
                }
              ]
            }
            {
              size: 384
              items:
              [
                {
                  size: 64
                  inv_default: 0
                }
                {
                  size: 64
                  inv_default: 15994060125354592494
                }
                {
                  size: 128
                  inv_default: 241193388044955693821746483131132302114
                }
                {
                  size: 128
                  inv_default: 42146219275086284332081154515457931983
                }
              ]
            }
            {
              size: 128
              items:
              [
                {
                  size: 64
                  inv_default: 2245725931179433842
                }
                {
                  comment: unallocated space
                  size: 16
                  inv_default: 0
                }
                {
                  size: 8
                  inv_default: 105
                }
                {
                  size: 8
                  inv_default: 105
                }
                {
                  size: 32
                  inv_default: 0
                }
              ]
            }
            {
              size: 576
              items:
              [
                {
                  size: 64
                  inv_default: 8050338520295093693
                }
                {
                  size: 256
                  inv_default: 104735823630885006896435419055152518946049592294862500793111622154345667968901
                }
                {
                  size: 256
                  inv_default: 40117173308102545085356168480633505499540504862520500713288653871548071919464
                }
              ]
            }
            {
              size: 78848
              items:
              [
                {
                  size: 64
                  inv_default: 14592557388175589354
                }
                {
                  comment: unallocated space
                  size: 5248
                  inv_default: 0
                }
                {
                  size: 73536
                  inv_default: 0
                }
              ]
            }
            {
              size: 8192
              items:
              [
                {
                  size: 8192
                  inv_default: 0
                }
              ]
            }
            {
              size: 2624
              items:
              [
                {
                  size: 64
                  inv_default: 2932316366930412108
                }
                {
                  size: 1280
                  inv_default: 0
                }
                {
                  size: 1280
                  inv_default: 0
                }
              ]
            }
            {
              size: 2624
              items:
              [
                {
                  size: 64
                  inv_default: 16981414814768445627
                }
                {
                  size: 1280
                  inv_default: 0
                }
                {
                  size: 1280
                  inv_default: 0
                }
              ]
            }
            {
              size: 2624
              items:
              [
                {
                  size: 64
                  inv_default: 9966431396093675977
                }
                {
                  size: 1280
                  inv_default: 0
                }
                {
                  size: 1280
                  inv_default: 0
                }
              ]
            }
            {
              size: 2624
              items:
              [
                {
                  size: 64
                  inv_default: 13089428196878425884
                }
                {
                  size: 1280
                  inv_default: 0
                }
                {
                  size: 1280
                  inv_default: 0
                }
              ]
            }
            {
              size: 2624
              items:
              [
                {
                  size: 64
                  inv_default: 13047861355720130167
                }
                {
                  size: 1280
                  inv_default: 0
                }
                {
                  size: 1280
                  inv_default: 0
                }
              ]
            }
            {
              size: 2624
              items:
              [
                {
                  size: 64
                  inv_default: 18297828617386945793
                }
                {
                  size: 1280
                  inv_default: 0
                }
                {
                  size: 1280
                  inv_default: 0
                }
              ]
            }
            {
              size: 2624
              items:
              [
                {
                  size: 64
                  inv_default: 5471265045120329804
                }
                {
                  size: 1280
                  inv_default: 0
                }
                {
                  size: 1280
                  inv_default: 0
                }
              ]
            }
            {
              size: 2624
              items:
              [
                {
                  size: 64
                  inv_default: 18001735645508761512
                }
                {
                  size: 1280
                  inv_default: 0
                }
                {
                  size: 1280
                  inv_default: 0
                }
              ]
            }
            {
              size: 11392
              items:
              [
                {
                  size: 64
                  inv_default: 13936327800626111575
                }
                {
                  comment: unallocated space
                  size: 32
                  inv_default: 0
                }
                {
                  size: 6144
                  inv_default: 0
                }
                {
                  size: 1280
                  inv_default: 0
                }
                {
                  size: 1280
                  inv_default: 0
                }
                {
                  size: 1280
                  inv_default: 0
                }
                {
                  size: 32
                  inv_default: 0
                }
                {
                  size: 1280
                  inv_default: 0
                }
              ]
            }
            {
              size: 384
              items:
              [
                {
                  size: 128
                  inv_default: 0
                }
                {
                  size: 128
                  inv_default: 0
                }
                {
                  size: 128
                  inv_default: 0
                }
              ]
            }
            {
              size: 4800
              items:
              [
                {
                  size: 64
                  inv_default: 3036799796741757437
                }
                {
                  size: 32
                  inv_default: 0
                }
                {
                  size: 32
                  inv_default: 0
                }
                {
                  size: 32
                  inv_default: 0
                }
                {
                  size: 32
                  inv_default: 0
                }
                {
                  size: 32
                  inv_default: 0
                }
                {
                  size: 32
                  inv_default: 0
                }
                {
                  size: 32
                  inv_default: 0
                }
                {
                  size: 32
                  inv_default: 0
                }
                {
                  size: 512
                  inv_default: 0
                }
                {
                  size: 128
                  inv_default: 0
                }
                {
                  size: 128
                  inv_default: 0
                }
                {
                  size: 224
                  inv_default: 0
                }
                {
                  size: 3360
                  inv_default: 0
                }
                {
                  size: 32
                  inv_default: 0
                }
                {
                  size: 32
                  inv_default: 0
                }
                {
                  size: 32
                  inv_default: 0
                }
                {
                  size: 32
                  inv_default: 0
                }
              ]
            }
            {
              size: 2496
              items:
              [
                {
                  size: 64
                  inv_default: 10745993536467849044
                }
                {
                  comment: unallocated space
                  size: 32
                  inv_default: 0
                }
                {
                  size: 32
                  inv_default: 0
                }
                {
                  size: 32
                  inv_default: 0
                }
                {
                  size: 32
                  inv_default: 0
                }
                {
                  size: 32
                  inv_default: 0
                }
                {
                  size: 32
                  inv_default: 0
                }
                {
                  size: 32
                  inv_default: 0
                }
                {
                  size: 32
                  inv_default: 0
                }
                {
                  size: 32
                  inv_default: 0
                }
                {
                  size: 32
                  inv_default: 0
                }
                {
                  size: 32
                  inv_default: 0
                }
                {
                  size: 32
                  inv_default: 0
                }
                {
                  size: 32
                  inv_default: 0
                }
                {
                  size: 32
                  inv_default: 0
                }
                {
                  size: 32
                  inv_default: 0
                }
                {
                  size: 32
                  inv_default: 0
                }
                {
                  size: 32
                  inv_default: 0
                }
                {
                  size: 32
                  inv_default: 0
                }
                {
                  size: 32
                  inv_default: 0
                }
                {
                  size: 32
                  inv_default: 0
                }
                {
                  size: 32
                  inv_default: 0
                }
                {
                  size: 32
                  inv_default: 0
                }
                {
                  size: 32
                  inv_default: 0
                }
                {
                  size: 32
                  inv_default: 0
                }
                {
                  size: 32
                  inv_default: 0
                }
                {
                  size: 32
                  inv_default: 0
                }
                {
                  size: 32
                  inv_default: 0
                }
                {
                  size: 32
                  inv_default: 0
                }
                {
                  size: 32
                  inv_default: 0
                }
                {
                  size: 64
                  inv_default: 0
                }
                {
                  size: 32
                  inv_default: 0
                }
                {
                  size: 64
                  inv_default: 0
                }
                {
                  size: 32
                  inv_default: 0
                }
                {
                  size: 32
                  inv_default: 0
                }
                {
                  size: 256
                  inv_default: 0
                }
                {
                  size: 32
                  inv_default: 0
                }
                {
                  size: 992
                  inv_default: 0
                }
              ]
            }
            {
              size: 512
              items:
              [
                {
                  size: 64
                  inv_default: 312179291205032755
                }
                {
                  size: 448
                  inv_default: 0
                }
              ]
            }
          ]
          randwidth: 131072
        }
      ]
      template_type: otp_ctrl
      otp_mmap:
      {
        otp:
        {
          width: 2
          depth: 8192
          size: 16384
          addr_width: 13
          byte_addr_width: 14
        }
        scrambling:
        {
          key_size: 16
          iv_size: 8
          cnst_size: 16
          keys:
          [
            {
              name: Secret0Key
              value: 138959374610987221438102940065509369958
            }
            {
              name: Secret1Key
              value: 214906908420393146978604154423181190009
            }
            {
              name: Secret2Key
              value: 259105464341488730475238499589165956997
            }
            {
              name: Secret3Key
              value: 188897641917496988174986683742771918684
            }
          ]
          digests:
          [
            {
              name: CnstyDigest
              iv_value: 11565364800674047323
              cnst_value: 13004072182442196571965938888816599509
            }
            {
              name: SramDataKey
              iv_value: 11229202183237704545
              cnst_value: 103407901297817239236543323158765666219
            }
          ]
          num_keys: 4
          num_digests: 2
        }
        partitions:
        [
          {
            name: VENDOR_TEST
            variant: Unbuffered
            absorb: false
            secret: false
            sw_digest: true
            hw_digest: false
            write_lock: Digest
            read_lock: CSR
            key_sel: NoKey
            integrity: false
            bkout_type: false
            zeroizable: false
            skip_sw_header: true
            items:
            [
              {
                name: SCRATCH
                size: 56
                isdigest: false
                iszer: false
                ismubi: false
                iskeymgr_creator: false
                iskeymgr_owner: false
                inv_default: 0
                offset: 0
              }
              {
                name: VENDOR_TEST_DIGEST
                size: 8
                offset: 56
                ismubi: false
                isdigest: true
                iszer: false
                inv_default: 312179291205032755
                iskeymgr_creator: false
                iskeymgr_owner: false
              }
            ]
            desc:
              '''
              Vendor test partition.
              This is reserved for manufacturing smoke checks. The OTP wrapper
              control logic inside prim_otp is allowed to read/write to this
              region. ECC uncorrectable errors seen on the functional prim_otp
              interface will not lead to an alert for this partition.
              Instead, such errors will be reported as correctable ECC errors.
              '''
            iskeymgr_creator: false
            iskeymgr_owner: false
            ignore_read_lock_in_rma: false
            size: 64
            offset: 0
          }
          {
            name: CREATOR_SW_CFG
            variant: Unbuffered
            absorb: false
            secret: false
            sw_digest: true
            hw_digest: false
            write_lock: Digest
            read_lock: CSR
            key_sel: NoKey
            integrity: true
            bkout_type: false
            zeroizable: false
            items:
            [
              {
                name: CREATOR_SW_CFG_AST_CFG
                size: 124
                isdigest: false
                iszer: false
                ismubi: false
                iskeymgr_creator: false
                iskeymgr_owner: false
                inv_default: 0
                offset: 64
              }
              {
                name: CREATOR_SW_CFG_AST_INIT_EN
                size: 4
                isdigest: false
                iszer: false
                ismubi: false
                iskeymgr_creator: false
                iskeymgr_owner: false
                inv_default: 0
                offset: 188
              }
              {
                name: CREATOR_SW_CFG_OVERRIDES
                size: 32
                isdigest: false
                iszer: false
                ismubi: false
                iskeymgr_creator: false
                iskeymgr_owner: false
                inv_default: 0
                offset: 192
              }
              {
                name: CREATOR_SW_CFG_ROM_EXT_SKU
                size: 4
                isdigest: false
                iszer: false
                ismubi: false
                iskeymgr_creator: false
                iskeymgr_owner: false
                inv_default: 0
                offset: 224
              }
              {
                name: CREATOR_SW_CFG_SIGVERIFY_RSA_MOD_EXP_IBEX_EN
                size: 4
                isdigest: false
                iszer: false
                ismubi: false
                iskeymgr_creator: false
                iskeymgr_owner: false
                inv_default: 0
                offset: 228
              }
              {
                name: CREATOR_SW_CFG_SIGVERIFY_RSA_KEY_EN
                size: 8
                isdigest: false
                iszer: false
                ismubi: false
                iskeymgr_creator: false
                iskeymgr_owner: false
                inv_default: 0
                offset: 232
              }
              {
                name: CREATOR_SW_CFG_SIGVERIFY_SPX_EN
                size: 4
                isdigest: false
                iszer: false
                ismubi: false
                iskeymgr_creator: false
                iskeymgr_owner: false
                inv_default: 0
                offset: 240
              }
              {
                name: CREATOR_SW_CFG_SIGVERIFY_SPX_KEY_EN
                size: 8
                isdigest: false
                iszer: false
                ismubi: false
                iskeymgr_creator: false
                iskeymgr_owner: false
                inv_default: 0
                offset: 244
              }
              {
                name: CREATOR_SW_CFG_NVM_DATA_DEFAULT_CFG
                size: 4
                isdigest: false
                iszer: false
                ismubi: false
                iskeymgr_creator: false
                iskeymgr_owner: false
                inv_default: 0
                offset: 252
              }
              {
                name: CREATOR_SW_CFG_NVM_INFO_BOOT_DATA_CFG
                size: 4
                isdigest: false
                iszer: false
                ismubi: false
                iskeymgr_creator: false
                iskeymgr_owner: false
                inv_default: 0
                offset: 256
              }
              {
                name: CREATOR_SW_CFG_NVM_HW_INFO_CFG_OVERRIDE
                size: 4
                isdigest: false
                iszer: false
                ismubi: false
                iskeymgr_creator: false
                iskeymgr_owner: false
                inv_default: 0
                offset: 260
              }
              {
                name: CREATOR_SW_CFG_RNG_EN
                size: 4
                isdigest: false
                iszer: false
                ismubi: false
                iskeymgr_creator: false
                iskeymgr_owner: false
                inv_default: 0
                offset: 264
              }
              {
                name: CREATOR_SW_CFG_JITTER_EN
                size: 4
                isdigest: false
                iszer: false
                ismubi: false
                iskeymgr_creator: false
                iskeymgr_owner: false
                inv_default: 0
                offset: 268
              }
              {
                name: CREATOR_SW_CFG_RET_RAM_RESET_MASK
                size: 4
                isdigest: false
                iszer: false
                ismubi: false
                iskeymgr_creator: false
                iskeymgr_owner: false
                inv_default: 0
                offset: 272
              }
              {
                name: CREATOR_SW_CFG_MANUF_STATE
                size: 4
                isdigest: false
                iszer: false
                ismubi: false
                iskeymgr_creator: false
                iskeymgr_owner: false
                inv_default: 0
                offset: 276
              }
              {
                name: CREATOR_SW_CFG_ROM_EXEC_EN
                size: 4
                isdigest: false
                iszer: false
                ismubi: false
                iskeymgr_creator: false
                iskeymgr_owner: false
                inv_default: 0
                offset: 280
              }
              {
                name: CREATOR_SW_CFG_CPUCTRL
                size: 4
                isdigest: false
                iszer: false
                ismubi: false
                iskeymgr_creator: false
                iskeymgr_owner: false
                inv_default: 0
                offset: 284
              }
              {
                name: CREATOR_SW_CFG_MIN_SEC_VER_ROM_EXT
                size: 4
                isdigest: false
                iszer: false
                ismubi: false
                iskeymgr_creator: false
                iskeymgr_owner: false
                inv_default: 0
                offset: 288
              }
              {
                name: CREATOR_SW_CFG_MIN_SEC_VER_BL0
                size: 4
                isdigest: false
                iszer: false
                ismubi: false
                iskeymgr_creator: false
                iskeymgr_owner: false
                inv_default: 0
                offset: 292
              }
              {
                name: CREATOR_SW_CFG_DEFAULT_BOOT_DATA_IN_PROD_EN
                size: 4
                isdigest: false
                iszer: false
                ismubi: false
                iskeymgr_creator: false
                iskeymgr_owner: false
                inv_default: 0
                offset: 296
              }
              {
                name: CREATOR_SW_CFG_RMA_SPIN_EN
                size: 4
                isdigest: false
                iszer: false
                ismubi: false
                iskeymgr_creator: false
                iskeymgr_owner: false
                inv_default: 0
                offset: 300
              }
              {
                name: CREATOR_SW_CFG_RMA_SPIN_CYCLES
                size: 4
                isdigest: false
                iszer: false
                ismubi: false
                iskeymgr_creator: false
                iskeymgr_owner: false
                inv_default: 0
                offset: 304
              }
              {
                name: CREATOR_SW_CFG_RNG_REPCNT_THRESHOLDS
                size: 4
                isdigest: false
                iszer: false
                ismubi: false
                iskeymgr_creator: false
                iskeymgr_owner: false
                inv_default: 0
                offset: 308
              }
              {
                name: CREATOR_SW_CFG_RNG_REPCNTS_THRESHOLDS
                size: 4
                isdigest: false
                iszer: false
                ismubi: false
                iskeymgr_creator: false
                iskeymgr_owner: false
                inv_default: 0
                offset: 312
              }
              {
                name: CREATOR_SW_CFG_RNG_ADAPTP_HI_THRESHOLDS
                size: 4
                isdigest: false
                iszer: false
                ismubi: false
                iskeymgr_creator: false
                iskeymgr_owner: false
                inv_default: 0
                offset: 316
              }
              {
                name: CREATOR_SW_CFG_RNG_ADAPTP_LO_THRESHOLDS
                size: 4
                isdigest: false
                iszer: false
                ismubi: false
                iskeymgr_creator: false
                iskeymgr_owner: false
                inv_default: 0
                offset: 320
              }
              {
                name: CREATOR_SW_CFG_RNG_BUCKET_THRESHOLDS
                size: 4
                isdigest: false
                iszer: false
                ismubi: false
                iskeymgr_creator: false
                iskeymgr_owner: false
                inv_default: 0
                offset: 324
              }
              {
                name: CREATOR_SW_CFG_RNG_MARKOV_HI_THRESHOLDS
                size: 4
                isdigest: false
                iszer: false
                ismubi: false
                iskeymgr_creator: false
                iskeymgr_owner: false
                inv_default: 0
                offset: 328
              }
              {
                name: CREATOR_SW_CFG_RNG_MARKOV_LO_THRESHOLDS
                size: 4
                isdigest: false
                iszer: false
                ismubi: false
                iskeymgr_creator: false
                iskeymgr_owner: false
                inv_default: 0
                offset: 332
              }
              {
                name: CREATOR_SW_CFG_RNG_EXTHT_HI_THRESHOLDS
                size: 4
                isdigest: false
                iszer: false
                ismubi: false
                iskeymgr_creator: false
                iskeymgr_owner: false
                inv_default: 0
                offset: 336
              }
              {
                name: CREATOR_SW_CFG_RNG_EXTHT_LO_THRESHOLDS
                size: 4
                isdigest: false
                iszer: false
                ismubi: false
                iskeymgr_creator: false
                iskeymgr_owner: false
                inv_default: 0
                offset: 340
              }
              {
                name: CREATOR_SW_CFG_RNG_BOOT_ALERT_THRESHOLD
                size: 4
                isdigest: false
                iszer: false
                ismubi: false
                iskeymgr_creator: false
                iskeymgr_owner: false
                inv_default: 0
                offset: 344
              }
              {
                name: CREATOR_SW_CFG_RNG_FIPS_ALERT_THRESHOLD
                size: 4
                isdigest: false
                iszer: false
                ismubi: false
                iskeymgr_creator: false
                iskeymgr_owner: false
                inv_default: 0
                offset: 348
              }
              {
                name: CREATOR_SW_CFG_RNG_BOOT_CONFIG_DIGEST
                size: 4
                isdigest: false
                iszer: false
                ismubi: false
                iskeymgr_creator: false
                iskeymgr_owner: false
                inv_default: 0
                offset: 352
              }
              {
                name: CREATOR_SW_CFG_RNG_FIPS_CONFIG_DIGEST
                size: 4
                isdigest: false
                iszer: false
                ismubi: false
                iskeymgr_creator: false
                iskeymgr_owner: false
                inv_default: 0
                offset: 356
              }
              {
                name: CREATOR_SW_CFG_SRAM_KEY_RENEW_AND_INIT_EN
                size: 4
                isdigest: false
                iszer: false
                ismubi: false
                iskeymgr_creator: false
                iskeymgr_owner: false
                inv_default: 0
                offset: 360
              }
              {
                name: CREATOR_SW_CFG_DIGEST
                size: 8
                offset: 368
                ismubi: false
                isdigest: true
                iszer: false
                inv_default: 10745993536467849044
                iskeymgr_creator: false
                iskeymgr_owner: false
              }
            ]
            desc:
              '''
              Software configuration partition.
              This is for device-specific calibration data. For example, clock,
              LDO, RNG.
              '''
            iskeymgr_creator: false
            iskeymgr_owner: false
            ignore_read_lock_in_rma: false
            size: 312
            offset: 64
          }
          {
            name: OWNER_SW_CFG
            variant: Unbuffered
            absorb: false
            secret: false
            sw_digest: true
            hw_digest: false
            write_lock: Digest
            read_lock: CSR
            key_sel: NoKey
            integrity: true
            bkout_type: false
            zeroizable: false
            items:
            [
              {
                name: OWNER_SW_CFG_ROM_ERROR_REPORTING
                size: 4
                isdigest: false
                iszer: false
                ismubi: false
                iskeymgr_creator: false
                iskeymgr_owner: false
                inv_default: 0
                offset: 376
              }
              {
                name: OWNER_SW_CFG_ROM_BOOTSTRAP_DIS
                size: 4
                isdigest: false
                iszer: false
                ismubi: false
                iskeymgr_creator: false
                iskeymgr_owner: false
                inv_default: 0
                offset: 380
              }
              {
                name: OWNER_SW_CFG_ROM_ALERT_CLASS_EN
                size: 4
                isdigest: false
                iszer: false
                ismubi: false
                iskeymgr_creator: false
                iskeymgr_owner: false
                inv_default: 0
                offset: 384
              }
              {
                name: OWNER_SW_CFG_ROM_ALERT_ESCALATION
                size: 4
                isdigest: false
                iszer: false
                ismubi: false
                iskeymgr_creator: false
                iskeymgr_owner: false
                inv_default: 0
                offset: 388
              }
              {
                name: OWNER_SW_CFG_ROM_ALERT_CLASSIFICATION
                size: 420
                isdigest: false
                iszer: false
                ismubi: false
                iskeymgr_creator: false
                iskeymgr_owner: false
                inv_default: 0
                offset: 392
              }
              {
                name: OWNER_SW_CFG_ROM_LOCAL_ALERT_CLASSIFICATION
                size: 28
                isdigest: false
                iszer: false
                ismubi: false
                iskeymgr_creator: false
                iskeymgr_owner: false
                inv_default: 0
                offset: 812
              }
              {
                name: OWNER_SW_CFG_ROM_ALERT_ACCUM_THRESH
                size: 16
                isdigest: false
                iszer: false
                ismubi: false
                iskeymgr_creator: false
                iskeymgr_owner: false
                inv_default: 0
                offset: 840
              }
              {
                name: OWNER_SW_CFG_ROM_ALERT_TIMEOUT_CYCLES
                size: 16
                isdigest: false
                iszer: false
                ismubi: false
                iskeymgr_creator: false
                iskeymgr_owner: false
                inv_default: 0
                offset: 856
              }
              {
                name: OWNER_SW_CFG_ROM_ALERT_PHASE_CYCLES
                size: 64
                isdigest: false
                iszer: false
                ismubi: false
                iskeymgr_creator: false
                iskeymgr_owner: false
                inv_default: 0
                offset: 872
              }
              {
                name: OWNER_SW_CFG_ROM_ALERT_DIGEST_PROD
                size: 4
                isdigest: false
                iszer: false
                ismubi: false
                iskeymgr_creator: false
                iskeymgr_owner: false
                inv_default: 0
                offset: 936
              }
              {
                name: OWNER_SW_CFG_ROM_ALERT_DIGEST_PROD_END
                size: 4
                isdigest: false
                iszer: false
                ismubi: false
                iskeymgr_creator: false
                iskeymgr_owner: false
                inv_default: 0
                offset: 940
              }
              {
                name: OWNER_SW_CFG_ROM_ALERT_DIGEST_DEV
                size: 4
                isdigest: false
                iszer: false
                ismubi: false
                iskeymgr_creator: false
                iskeymgr_owner: false
                inv_default: 0
                offset: 944
              }
              {
                name: OWNER_SW_CFG_ROM_ALERT_DIGEST_RMA
                size: 4
                isdigest: false
                iszer: false
                ismubi: false
                iskeymgr_creator: false
                iskeymgr_owner: false
                inv_default: 0
                offset: 948
              }
              {
                name: OWNER_SW_CFG_ROM_WATCHDOG_BITE_THRESHOLD_CYCLES
                size: 4
                isdigest: false
                iszer: false
                ismubi: false
                iskeymgr_creator: false
                iskeymgr_owner: false
                inv_default: 0
                offset: 952
              }
              {
                name: OWNER_SW_CFG_ROM_KEYMGR_ROM_EXT_MEAS_EN
                size: 4
                isdigest: false
                iszer: false
                ismubi: false
                iskeymgr_creator: false
                iskeymgr_owner: false
                inv_default: 0
                offset: 956
              }
              {
                name: OWNER_SW_CFG_MANUF_STATE
                size: 4
                isdigest: false
                iszer: false
                ismubi: false
                iskeymgr_creator: false
                iskeymgr_owner: false
                inv_default: 0
                offset: 960
              }
              {
                name: OWNER_SW_CFG_ROM_RSTMGR_INFO_EN
                size: 4
                isdigest: false
                iszer: false
                ismubi: false
                iskeymgr_creator: false
                iskeymgr_owner: false
                inv_default: 0
                offset: 964
              }
              {
                name: OWNER_SW_CFG_DIGEST
                size: 8
                offset: 968
                ismubi: false
                isdigest: true
                iszer: false
                inv_default: 3036799796741757437
                iskeymgr_creator: false
                iskeymgr_owner: false
              }
            ]
            desc:
              '''
              Software configuration partition.
              This contains data that changes software behavior in the ROM, for
              example enabling defensive features in ROM or selecting failure
              modes if verification fails.
              '''
            iskeymgr_creator: false
            iskeymgr_owner: false
            ignore_read_lock_in_rma: false
            size: 600
            offset: 376
          }
          {
            name: OWNERSHIP_SLOT_STATE
            variant: Unbuffered
            absorb: false
            secret: false
            sw_digest: false
            hw_digest: false
            write_lock: None
            read_lock: CSR
            key_sel: NoKey
            integrity: true
            bkout_type: false
            zeroizable: false
            items:
            [
              {
                name: OWNERSHIP_SLOT_STATE_ROT_OWNER_AUTH
                size: 16
                desc:
                  '''
                  Creator Ownership transfer state management
                  OWNERSHIP_ST_RAW:       ownership not yet claimed (factory default)
                  OWNERSHIP_ST_LOCKED0:   first ownership slot claimed
                  OWNERSHIP_ST_RELEASED0: first ownership slot released (assets have been cleared, ready to xfer)
                  OWNERSHIP_ST_LOCKED1:   second ownership slot claimed
                  OWNERSHIP_ST_SCRAPPED:  scrap state - terminal
                  '''
                isdigest: false
                iszer: false
                ismubi: false
                iskeymgr_creator: false
                iskeymgr_owner: false
                inv_default: 0
                offset: 976
              }
              {
                name: OWNERSHIP_SLOT_STATE_PLAT_INTEG_AUTH
                size: 16
                desc:
                  '''
                  Creator Ownership transfer state management
                  OWNERSHIP_ST_RAW:       ownership not yet claimed (factory default)
                  OWNERSHIP_ST_LOCKED0:   first ownership slot claimed
                  OWNERSHIP_ST_RELEASED0: first ownership slot released (assets have been cleared, ready to xfer)
                  OWNERSHIP_ST_LOCKED1:   second ownership slot claimed
                  OWNERSHIP_ST_SCRAPPED:  scrap state - terminal
                  '''
                isdigest: false
                iszer: false
                ismubi: false
                iskeymgr_creator: false
                iskeymgr_owner: false
                inv_default: 0
                offset: 992
              }
              {
                name: OWNERSHIP_SLOT_STATE_PLAT_OWNER_AUTH
                size: 16
                desc:
                  '''
                  Creator Ownership transfer state management
                  OWNERSHIP_ST_RAW:       ownership not yet claimed (factory default)
                  OWNERSHIP_ST_LOCKED0:   first ownership slot claimed
                  OWNERSHIP_ST_RELEASED0: first ownership slot released (assets have been cleared, ready to xfer)
                  OWNERSHIP_ST_LOCKED1:   second ownership slot claimed
                  OWNERSHIP_ST_RELEASED1: second ownership slot released (assets have been cleared, ready to xfer)
                  OWNERSHIP_ST_LOCKED2:   third ownership slot claimed
                  OWNERSHIP_ST_RELEASED2: third ownership slot released (assets have been cleared, ready to xfer)
                  OWNERSHIP_ST_LOCKED3:   fourth ownership slot claimed
                  OWNERSHIP_ST_SCRAPPED:  scrap state - terminal
                  '''
                isdigest: false
                iszer: false
                ismubi: false
                iskeymgr_creator: false
                iskeymgr_owner: false
                inv_default: 0
                offset: 1008
              }
            ]
            desc:
              '''
              SW managed asset ownership states partition.

              Multibit enable value for the tracking the asset ownership states.
              Note that the states can be written multiple times in a device lifetime.
              The values to be written are engineered in the same way as the LC_CTRL
              state encoding words so that the ECC encoding remains valid even after
              updating the values.

              The constants can be found in the lc_ctrl_state_pkg.sv package.

              The programming order has to adhere to:

              OWNERSHIP_ST_RAW (factory all-zero state) ->
              OWNERSHIP_ST_LOCKED0 ->
              OWNERSHIP_ST_RELEASED0 ->
              ...
              OWNERSHIP_ST_SCRAPPED

              Note that if there are less than 4 slots available the higher slot states
              become logically equivalent to OWNERSHIP_SCRAPPED (firmware has to handle
              this correctly).
              '''
            iskeymgr_creator: false
            iskeymgr_owner: false
            ignore_read_lock_in_rma: false
            size: 48
            offset: 976
          }
          {
            name: ROT_CREATOR_AUTH
            variant: Unbuffered
            absorb: false
            secret: false
            sw_digest: true
            hw_digest: false
            write_lock: Digest
            read_lock: CSR
            key_sel: NoKey
            integrity: true
            bkout_type: false
            zeroizable: false
            items:
            [
              {
                name: ROT_CREATOR_AUTH_NON_RAW_MFW_CODESIGN_KEY
                size: 160
                desc:
                  '''
                  Pub Key used to verify the manufacturing provisioning Software container
                  160B = Custom Cert --> {PubKey:48, Signature:48, Device ID:32, metadata:16}
                  It is expected to be provisioned at Chip Probe stage when LC = TEST
                  i.e. provisioning protected under proper lifecycle logistics / secure supplychain management
                  '''
                isdigest: false
                iszer: false
                ismubi: false
                iskeymgr_creator: false
                iskeymgr_owner: false
                inv_default: 0
                offset: 1024
              }
              {
                name: ROT_CREATOR_AUTH_OWNERSHIP_STATE
                size: 4
                desc:
                  '''
                  Creator Ownership transfer state management
                  UNLOCKED - ownership of ROT not yet claimed
                  LOCKED   - ownership claimed and
                  RELEASED - Release ownership (assets have been cleared, ready to xfer)
                  '''
                isdigest: false
                iszer: false
                ismubi: false
                iskeymgr_creator: false
                iskeymgr_owner: false
                inv_default: 0
                offset: 1184
              }
              {
                name: ROT_CREATOR_AUTH_ROM2_PATCH_SIGVERIFY_KEY
                size: 160
                desc:
                  '''
                  Pub Key used to verify the ROM2 OTP based patch
                  160B = Custom Cert --> {PubKey:48, Signature:48, Device ID:32, metadata:16}
                  It is expected to be provisioned at Chip Probe stage when LC = TEST
                  i.e. provisioning protected under proper lifecycle logistics / secure supplychain management
                    OTP based key (instead of ROM) facilitates easy key rotation
                  '''
                isdigest: false
                iszer: false
                ismubi: false
                iskeymgr_creator: false
                iskeymgr_owner: false
                inv_default: 0
                offset: 1188
              }
              {
                name: ROT_CREATOR_AUTH_KEYMANIFEST_KEY
                size: 160
                desc:
                  '''
                  Pub Key used to verify the ROT CREATOR KEY MANIFEST.
                  KM is used to provisioning additional keys in (external) flash
                  160B = Custom Cert --> {PubKey:48, Signature:48, Device ID:32, metadata:16}
                  It is expected to be provisioned at Chip Probe stage when LC = TEST
                  i.e. provisioning protected under proper lifecycle logistics / secure supplychain management
                  '''
                isdigest: false
                iszer: false
                ismubi: false
                iskeymgr_creator: false
                iskeymgr_owner: false
                inv_default: 0
                offset: 1348
              }
              {
                name: ROT_CREATOR_AUTH_UNLOCK4XFER_KEY
                size: 160
                desc:
                  '''
                  Pub Key used to verify the ROT CREATOR KEY MANIFEST.
                  Used to authenticate the Unlock Ownership payload. Key Type: ECC NIST-P384 Curve.
                  160B = Custom Cert --> {PubKey:48, Signature:48, Device ID:32, metadata:16}
                  Can be made part bound i.e. unique per part key cert
                  i.e. provisioning protected under proper lifecycle logistics / secure supplychain management
                  '''
                isdigest: false
                iszer: false
                ismubi: false
                iskeymgr_creator: false
                iskeymgr_owner: false
                inv_default: 0
                offset: 1508
              }
              {
                name: ROT_CREATOR_AUTH_IDENTITY_CERT
                size: 768
                desc: ROT Device Identity Certificate endorsed by Silicon Creator stable off device PKI
                isdigest: false
                iszer: false
                ismubi: false
                iskeymgr_creator: false
                iskeymgr_owner: false
                inv_default: 0
                offset: 1668
              }
              {
                name: ROT_CREATOR_AUTH_DIGEST
                size: 8
                offset: 2440
                ismubi: false
                isdigest: true
                iszer: false
                inv_default: 13936327800626111575
                iskeymgr_creator: false
                iskeymgr_owner: false
              }
            ]
            desc: Software managed creator partition.
            iskeymgr_creator: false
            iskeymgr_owner: false
            ignore_read_lock_in_rma: false
            size: 1424
            offset: 1024
          }
          {
            name: ROT_OWNER_AUTH_SLOT0
            variant: Unbuffered
            absorb: false
            secret: false
            sw_digest: true
            hw_digest: false
            write_lock: Digest
            read_lock: CSR
            key_sel: NoKey
            integrity: true
            bkout_type: false
            zeroizable: false
            items:
            [
              {
                name: ROT_OWNER_AUTH_SLOT0_KEYMANIFEST_KEY
                size: 160
                desc:
                  '''
                  Pub Key used to verify the ROT OWNER KEY MANIFEST.
                  KM is used to provisioning additional keys in (external) flash
                  160B = Custom Cert --> {PubKey:48, Signature:48, Device ID:32, metadata:16}
                  It is expected to be provisioned at Chip Probe stage when LC = TEST
                  i.e. provisioning protected under proper lifecycle logistics / secure supplychain management
                  '''
                isdigest: false
                iszer: false
                ismubi: false
                iskeymgr_creator: false
                iskeymgr_owner: false
                inv_default: 0
                offset: 2448
              }
              {
                name: ROT_OWNER_AUTH_SLOT0_UNLOCK4XFER_KEY
                size: 160
                desc:
                  '''
                  Pub Key used to verify the ROT OWNER KEY MANIFEST.
                  Used to authenticate the Unlock Ownership payload. Key Type: ECC NIST-P384 Curve.
                  160B = Custom Cert --> {PubKey:48, Signature:48, Device ID:32, metadata:16}
                  Can be made part bound i.e. unique per part key cert
                  i.e. provisioning protected under proper lifecycle logistics / secure supplychain management
                  '''
                isdigest: false
                iszer: false
                ismubi: false
                iskeymgr_creator: false
                iskeymgr_owner: false
                inv_default: 0
                offset: 2608
              }
              {
                name: ROT_OWNER_AUTH_SLOT0_DIGEST
                size: 8
                offset: 2768
                ismubi: false
                isdigest: true
                iszer: false
                inv_default: 18001735645508761512
                iskeymgr_creator: false
                iskeymgr_owner: false
              }
            ]
            desc: Software managed owner slot 0 partition.
            iskeymgr_creator: false
            iskeymgr_owner: false
            ignore_read_lock_in_rma: false
            size: 328
            offset: 2448
          }
          {
            name: ROT_OWNER_AUTH_SLOT1
            variant: Unbuffered
            absorb: false
            secret: false
            sw_digest: true
            hw_digest: false
            write_lock: Digest
            read_lock: CSR
            key_sel: NoKey
            integrity: true
            bkout_type: false
            zeroizable: false
            items:
            [
              {
                name: ROT_OWNER_AUTH_SLOT1_KEYMANIFEST_KEY
                size: 160
                desc:
                  '''
                  Pub Key used to verify the ROT OWNER KEY MANIFEST.
                  KM is used to provisioning additional keys in (external) flash
                  160B = Custom Cert --> {PubKey:48, Signature:48, Device ID:32, metadata:16}
                  It is expected to be provisioned at Chip Probe stage when LC = TEST
                  i.e. provisioning protected under proper lifecycle logistics / secure supplychain management
                  '''
                isdigest: false
                iszer: false
                ismubi: false
                iskeymgr_creator: false
                iskeymgr_owner: false
                inv_default: 0
                offset: 2776
              }
              {
                name: ROT_OWNER_AUTH_SLOT1_UNLOCK4XFER_KEY
                size: 160
                desc:
                  '''
                  Pub Key used to verify the ROT OWNER KEY MANIFEST.
                  Used to authenticate the Unlock Ownership payload. Key Type: ECC NIST-P384 Curve.
                  160B = Custom Cert --> {PubKey:48, Signature:48, Device ID:32, metadata:16}
                  Can be made part bound i.e. unique per part key cert
                  i.e. provisioning protected under proper lifecycle logistics / secure supplychain management
                  '''
                isdigest: false
                iszer: false
                ismubi: false
                iskeymgr_creator: false
                iskeymgr_owner: false
                inv_default: 0
                offset: 2936
              }
              {
                name: ROT_OWNER_AUTH_SLOT1_DIGEST
                size: 8
                offset: 3096
                ismubi: false
                isdigest: true
                iszer: false
                inv_default: 5471265045120329804
                iskeymgr_creator: false
                iskeymgr_owner: false
              }
            ]
            desc: Software managed owner slot 1 partition.
            iskeymgr_creator: false
            iskeymgr_owner: false
            ignore_read_lock_in_rma: false
            size: 328
            offset: 2776
          }
          {
            name: PLAT_INTEG_AUTH_SLOT0
            variant: Unbuffered
            absorb: false
            secret: false
            sw_digest: true
            hw_digest: false
            write_lock: Digest
            read_lock: CSR
            key_sel: NoKey
            integrity: true
            bkout_type: false
            zeroizable: false
            items:
            [
              {
                name: PLAT_INTEG_AUTH_SLOT0_KEYMANIFEST_KEY
                size: 160
                desc:
                  '''
                  Pub Key used to verify the ROT OWNER KEY MANIFEST.
                  KM is used to provisioning additional keys in (external) flash
                  160B = Custom Cert --> {PubKey:48, Signature:48, Device ID:32, metadata:16}
                  It is expected to be provisioned at Chip Probe stage when LC = TEST
                  i.e. provisioning protected under proper lifecycle logistics / secure supplychain management
                  '''
                isdigest: false
                iszer: false
                ismubi: false
                iskeymgr_creator: false
                iskeymgr_owner: false
                inv_default: 0
                offset: 3104
              }
              {
                name: PLAT_INTEG_AUTH_SLOT0_UNLOCK4XFER_KEY
                size: 160
                desc:
                  '''
                  Pub Key used to verify the ROT OWNER KEY MANIFEST.
                  Used to authenticate the Unlock Ownership payload. Key Type: ECC NIST-P384 Curve.
                  160B = Custom Cert --> {PubKey:48, Signature:48, Device ID:32, metadata:16}
                  Can be made part bound i.e. unique per part key cert
                  i.e. provisioning protected under proper lifecycle logistics / secure supplychain management
                  '''
                isdigest: false
                iszer: false
                ismubi: false
                iskeymgr_creator: false
                iskeymgr_owner: false
                inv_default: 0
                offset: 3264
              }
              {
                name: PLAT_INTEG_AUTH_SLOT0_DIGEST
                size: 8
                offset: 3424
                ismubi: false
                isdigest: true
                iszer: false
                inv_default: 18297828617386945793
                iskeymgr_creator: false
                iskeymgr_owner: false
              }
            ]
            desc: Software managed platform integrator slot 0 partition.
            iskeymgr_creator: false
            iskeymgr_owner: false
            ignore_read_lock_in_rma: false
            size: 328
            offset: 3104
          }
          {
            name: PLAT_INTEG_AUTH_SLOT1
            variant: Unbuffered
            absorb: false
            secret: false
            sw_digest: true
            hw_digest: false
            write_lock: Digest
            read_lock: CSR
            key_sel: NoKey
            integrity: true
            bkout_type: false
            zeroizable: false
            items:
            [
              {
                name: PLAT_INTEG_AUTH_SLOT1_KEYMANIFEST_KEY
                size: 160
                desc:
                  '''
                  Pub Key used to verify the ROT OWNER KEY MANIFEST.
                  KM is used to provisioning additional keys in (external) flash
                  160B = Custom Cert --> {PubKey:48, Signature:48, Device ID:32, metadata:16}
                  It is expected to be provisioned at Chip Probe stage when LC = TEST
                  i.e. provisioning protected under proper lifecycle logistics / secure supplychain management
                  '''
                isdigest: false
                iszer: false
                ismubi: false
                iskeymgr_creator: false
                iskeymgr_owner: false
                inv_default: 0
                offset: 3432
              }
              {
                name: PLAT_INTEG_AUTH_SLOT1_UNLOCK4XFER_KEY
                size: 160
                desc:
                  '''
                  Pub Key used to verify the ROT OWNER KEY MANIFEST.
                  Used to authenticate the Unlock Ownership payload. Key Type: ECC NIST-P384 Curve.
                  160B = Custom Cert --> {PubKey:48, Signature:48, Device ID:32, metadata:16}
                  Can be made part bound i.e. unique per part key cert
                  i.e. provisioning protected under proper lifecycle logistics / secure supplychain management
                  '''
                isdigest: false
                iszer: false
                ismubi: false
                iskeymgr_creator: false
                iskeymgr_owner: false
                inv_default: 0
                offset: 3592
              }
              {
                name: PLAT_INTEG_AUTH_SLOT1_DIGEST
                size: 8
                offset: 3752
                ismubi: false
                isdigest: true
                iszer: false
                inv_default: 13047861355720130167
                iskeymgr_creator: false
                iskeymgr_owner: false
              }
            ]
            desc: Software managed platform integrator slot 1 partition.
            iskeymgr_creator: false
            iskeymgr_owner: false
            ignore_read_lock_in_rma: false
            size: 328
            offset: 3432
          }
          {
            name: PLAT_OWNER_AUTH_SLOT0
            variant: Unbuffered
            absorb: false
            secret: false
            sw_digest: true
            hw_digest: false
            write_lock: Digest
            read_lock: CSR
            key_sel: NoKey
            integrity: true
            bkout_type: false
            zeroizable: false
            items:
            [
              {
                name: PLAT_OWNER_AUTH_SLOT0_KEYMANIFEST_KEY
                size: 160
                desc:
                  '''
                  Pub Key used to verify the ROT OWNER KEY MANIFEST.
                  KM is used to provisioning additional keys in (external) flash
                  160B = Custom Cert --> {PubKey:48, Signature:48, Device ID:32, metadata:16}
                  It is expected to be provisioned at Chip Probe stage when LC = TEST
                  i.e. provisioning protected under proper lifecycle logistics / secure supplychain management
                  '''
                isdigest: false
                iszer: false
                ismubi: false
                iskeymgr_creator: false
                iskeymgr_owner: false
                inv_default: 0
                offset: 3760
              }
              {
                name: PLAT_OWNER_AUTH_SLOT0_UNLOCK4XFER_KEY
                size: 160
                desc:
                  '''
                  Pub Key used to verify the ROT OWNER KEY MANIFEST.
                  Used to authenticate the Unlock Ownership payload. Key Type: ECC NIST-P384 Curve.
                  160B = Custom Cert --> {PubKey:48, Signature:48, Device ID:32, metadata:16}
                  Can be made part bound i.e. unique per part key cert
                  i.e. provisioning protected under proper lifecycle logistics / secure supplychain management
                  '''
                isdigest: false
                iszer: false
                ismubi: false
                iskeymgr_creator: false
                iskeymgr_owner: false
                inv_default: 0
                offset: 3920
              }
              {
                name: PLAT_OWNER_AUTH_SLOT0_DIGEST
                size: 8
                offset: 4080
                ismubi: false
                isdigest: true
                iszer: false
                inv_default: 13089428196878425884
                iskeymgr_creator: false
                iskeymgr_owner: false
              }
            ]
            desc: Software managed platform owner slot 0 partition.
            iskeymgr_creator: false
            iskeymgr_owner: false
            ignore_read_lock_in_rma: false
            size: 328
            offset: 3760
          }
          {
            name: PLAT_OWNER_AUTH_SLOT1
            variant: Unbuffered
            absorb: false
            secret: false
            sw_digest: true
            hw_digest: false
            write_lock: Digest
            read_lock: CSR
            key_sel: NoKey
            integrity: true
            bkout_type: false
            zeroizable: false
            items:
            [
              {
                name: PLAT_OWNER_AUTH_SLOT1_KEYMANIFEST_KEY
                size: 160
                desc:
                  '''
                  Pub Key used to verify the ROT OWNER KEY MANIFEST.
                  KM is used to provisioning additional keys in (external) flash
                  160B = Custom Cert --> {PubKey:48, Signature:48, Device ID:32, metadata:16}
                  It is expected to be provisioned at Chip Probe stage when LC = TEST
                  i.e. provisioning protected under proper lifecycle logistics / secure supplychain management
                  '''
                isdigest: false
                iszer: false
                ismubi: false
                iskeymgr_creator: false
                iskeymgr_owner: false
                inv_default: 0
                offset: 4088
              }
              {
                name: PLAT_OWNER_AUTH_SLOT1_UNLOCK4XFER_KEY
                size: 160
                desc:
                  '''
                  Pub Key used to verify the ROT OWNER KEY MANIFEST.
                  Used to authenticate the Unlock Ownership payload. Key Type: ECC NIST-P384 Curve.
                  160B = Custom Cert --> {PubKey:48, Signature:48, Device ID:32, metadata:16}
                  Can be made part bound i.e. unique per part key cert
                  i.e. provisioning protected under proper lifecycle logistics / secure supplychain management
                  '''
                isdigest: false
                iszer: false
                ismubi: false
                iskeymgr_creator: false
                iskeymgr_owner: false
                inv_default: 0
                offset: 4248
              }
              {
                name: PLAT_OWNER_AUTH_SLOT1_DIGEST
                size: 8
                offset: 4408
                ismubi: false
                isdigest: true
                iszer: false
                inv_default: 9966431396093675977
                iskeymgr_creator: false
                iskeymgr_owner: false
              }
            ]
            desc: Software managed platform owner slot 1 partition.
            iskeymgr_creator: false
            iskeymgr_owner: false
            ignore_read_lock_in_rma: false
            size: 328
            offset: 4088
          }
          {
            name: PLAT_OWNER_AUTH_SLOT2
            variant: Unbuffered
            absorb: false
            secret: false
            sw_digest: true
            hw_digest: false
            write_lock: Digest
            read_lock: CSR
            key_sel: NoKey
            integrity: true
            bkout_type: false
            zeroizable: false
            items:
            [
              {
                name: PLAT_OWNER_AUTH_SLOT2_KEYMANIFEST_KEY
                size: 160
                desc:
                  '''
                  Pub Key used to verify the ROT OWNER KEY MANIFEST.
                  KM is used to provisioning additional keys in (external) flash
                  160B = Custom Cert --> {PubKey:48, Signature:48, Device ID:32, metadata:16}
                  It is expected to be provisioned at Chip Probe stage when LC = TEST
                  i.e. provisioning protected under proper lifecycle logistics / secure supplychain management
                  '''
                isdigest: false
                iszer: false
                ismubi: false
                iskeymgr_creator: false
                iskeymgr_owner: false
                inv_default: 0
                offset: 4416
              }
              {
                name: PLAT_OWNER_AUTH_SLOT2_UNLOCK4XFER_KEY
                size: 160
                desc:
                  '''
                  Pub Key used to verify the ROT OWNER KEY MANIFEST.
                  Used to authenticate the Unlock Ownership payload. Key Type: ECC NIST-P384 Curve.
                  160B = Custom Cert --> {PubKey:48, Signature:48, Device ID:32, metadata:16}
                  Can be made part bound i.e. unique per part key cert
                  i.e. provisioning protected under proper lifecycle logistics / secure supplychain management
                  '''
                isdigest: false
                iszer: false
                ismubi: false
                iskeymgr_creator: false
                iskeymgr_owner: false
                inv_default: 0
                offset: 4576
              }
              {
                name: PLAT_OWNER_AUTH_SLOT2_DIGEST
                size: 8
                offset: 4736
                ismubi: false
                isdigest: true
                iszer: false
                inv_default: 16981414814768445627
                iskeymgr_creator: false
                iskeymgr_owner: false
              }
            ]
            desc: Software managed platform owner slot 2 partition.
            iskeymgr_creator: false
            iskeymgr_owner: false
            ignore_read_lock_in_rma: false
            size: 328
            offset: 4416
          }
          {
            name: PLAT_OWNER_AUTH_SLOT3
            variant: Unbuffered
            absorb: false
            secret: false
            sw_digest: true
            hw_digest: false
            write_lock: Digest
            read_lock: CSR
            key_sel: NoKey
            integrity: true
            bkout_type: false
            zeroizable: false
            items:
            [
              {
                name: PLAT_OWNER_AUTH_SLOT3_KEYMANIFEST_KEY
                size: 160
                desc:
                  '''
                  Pub Key used to verify the ROT OWNER KEY MANIFEST.
                  KM is used to provisioning additional keys in (external) flash
                  160B = Custom Cert --> {PubKey:48, Signature:48, Device ID:32, metadata:16}
                  It is expected to be provisioned at Chip Probe stage when LC = TEST
                  i.e. provisioning protected under proper lifecycle logistics / secure supplychain management
                  '''
                isdigest: false
                iszer: false
                ismubi: false
                iskeymgr_creator: false
                iskeymgr_owner: false
                inv_default: 0
                offset: 4744
              }
              {
                name: PLAT_OWNER_AUTH_SLOT3_UNLOCK4XFER_KEY
                size: 160
                desc:
                  '''
                  Pub Key used to verify the ROT OWNER KEY MANIFEST.
                  Used to authenticate the Unlock Ownership payload. Key Type: ECC NIST-P384 Curve.
                  160B = Custom Cert --> {PubKey:48, Signature:48, Device ID:32, metadata:16}
                  Can be made part bound i.e. unique per part key cert
                  i.e. provisioning protected under proper lifecycle logistics / secure supplychain management
                  '''
                isdigest: false
                iszer: false
                ismubi: false
                iskeymgr_creator: false
                iskeymgr_owner: false
                inv_default: 0
                offset: 4904
              }
              {
                name: PLAT_OWNER_AUTH_SLOT3_DIGEST
                size: 8
                offset: 5064
                ismubi: false
                isdigest: true
                iszer: false
                inv_default: 2932316366930412108
                iskeymgr_creator: false
                iskeymgr_owner: false
              }
            ]
            desc: Software managed platform owner slot 3 partition.
            iskeymgr_creator: false
            iskeymgr_owner: false
            ignore_read_lock_in_rma: false
            size: 328
            offset: 4744
          }
          {
            name: EXT_NVM
            variant: Unbuffered
            absorb: false
            secret: false
            sw_digest: false
            hw_digest: false
            write_lock: None
            read_lock: CSR
            key_sel: NoKey
            integrity: false
            bkout_type: false
            zeroizable: false
            items:
            [
              {
                name: EXT_NVM_ANTIREPLAY_FRESHNESS_CNT
                size: 1024
                desc:
                  '''
                  Fully SW managed partition
                  1 bit (double bit allocated for redundancy - i.e. 2 physical bits for every logical bit) per day
                  assuming 10 year product lifecycle, allocating 8192 bits of freshness protection.
                  Implemented as thermometer encoding. Redundant bit programming & logical OR-ing managed by
                  software. Cannot be ECC protected since different bits in a fuse row are programmed at different times.
                  '''
                isdigest: false
                iszer: false
                ismubi: false
                iskeymgr_creator: false
                iskeymgr_owner: false
                inv_default: 0
                offset: 5072
              }
            ]
            desc: Anti-replay protection Strike Counters partition.
            iskeymgr_creator: false
            iskeymgr_owner: false
            ignore_read_lock_in_rma: false
            size: 1024
            offset: 5072
          }
          {
            name: ROM_PATCH
            variant: Unbuffered
            absorb: true
            secret: false
            sw_digest: true
            hw_digest: false
            write_lock: Digest
            read_lock: CSR
            key_sel: NoKey
            integrity: true
            bkout_type: false
            zeroizable: false
            items:
            [
              {
                name: ROM_PATCH_DATA
                size: 9192
                desc:
                  '''
                  Fully SW managed partition
                  ROM patch section
                  signed patch(es)
                  Each patch Contains header, signature, patch match/redirect configuration and patch code
                  Please refer to the ROM boot & patching specification for Integrated OT for more details
                  '''
                isdigest: false
                iszer: false
                ismubi: false
                iskeymgr_creator: false
                iskeymgr_owner: false
                inv_default: 0
                offset: 6096
              }
              {
                name: ROM_PATCH_DIGEST
                size: 8
                offset: 15944
                ismubi: false
                isdigest: true
                iszer: false
                inv_default: 14592557388175589354
                iskeymgr_creator: false
                iskeymgr_owner: false
              }
            ]
            desc: ROM Patch Code section. May contain multiple signed ROM2 patches.
            iskeymgr_creator: false
            iskeymgr_owner: false
            ignore_read_lock_in_rma: false
            size: 9856
            offset: 6096
          }
          {
            name: HW_CFG0
            variant: Buffered
            secret: false
            sw_digest: false
            hw_digest: true
            write_lock: Digest
            read_lock: None
            key_sel: NoKey
            integrity: true
            bkout_type: true
            zeroizable: false
            skip_sw_header: true
            items:
            [
              {
                name: DEVICE_ID
                size: 32
                inv_default: 40117173308102545085356168480633505499540504862520500713288653871548071919464
                isdigest: false
                iszer: false
                ismubi: false
                iskeymgr_creator: false
                iskeymgr_owner: false
                offset: 15952
              }
              {
                name: MANUF_STATE
                size: 32
                inv_default: 104735823630885006896435419055152518946049592294862500793111622154345667968901
                isdigest: false
                iszer: false
                ismubi: false
                iskeymgr_creator: false
                iskeymgr_owner: false
                offset: 15984
              }
              {
                name: HW_CFG0_DIGEST
                size: 8
                offset: 16016
                ismubi: false
                isdigest: true
                iszer: false
                inv_default: 8050338520295093693
                iskeymgr_creator: false
                iskeymgr_owner: false
              }
            ]
            desc:
              '''
              Hardware configuration 0 partition.
              This contains
              - DEVICE_ID: Unique device identifier.
              - MANUF_STATE: Vector for capturing the manufacturing status.
              '''
            absorb: false
            iskeymgr_creator: false
            iskeymgr_owner: false
            ignore_read_lock_in_rma: false
            size: 72
            offset: 15952
          }
          {
            name: HW_CFG1
            variant: Buffered
            secret: false
            sw_digest: false
            hw_digest: true
            write_lock: Digest
            read_lock: None
            key_sel: NoKey
            integrity: true
            bkout_type: true
            zeroizable: false
            skip_sw_header: true
            items:
            [
              {
                name: SOC_DBG_STATE
                size: 4
                inv_default: 0
                desc:
                  '''
                  Multibit enable value for the SOC debug authorization.
                  Encoding:
                  SOC_DBG_RAW: this value is all-zeroes and will be the NOP state;
                  the LC controller will take precedence.
                  SOC_DBG_PRE_PROD: this is where the ROT will be in PROD state
                  but SOC will be in the pre-production unlock state
                  SOC_DBG_PROD: this is the state where the SOC moves to production,
                  and the challenge-response based authentication protocol is
                  required to unlock SOC debug features
                  '''
                isdigest: false
                iszer: false
                ismubi: false
                iskeymgr_creator: false
                iskeymgr_owner: false
                offset: 16024
              }
              {
                name: EN_CSRNG_SW_APP_READ
                size: 1
                ismubi: true
                inv_default: 105
                desc:
                  '''
                  Enablement of CSRNG software application interface. A
                  kMultiBitBool8True value enables, while all other values
                  disable. Enablement is required to extract output from
                  CSRNG via software.
                  '''
                isdigest: false
                iszer: false
                iskeymgr_creator: false
                iskeymgr_owner: false
                offset: 16028
              }
              {
                name: EN_SRAM_IFETCH
                size: 1
                ismubi: true
                inv_default: 105
                isdigest: false
                iszer: false
                iskeymgr_creator: false
                iskeymgr_owner: false
                offset: 16029
              }
              {
                name: HW_CFG1_DIGEST
                size: 8
                offset: 16032
                ismubi: false
                isdigest: true
                iszer: false
                inv_default: 2245725931179433842
                iskeymgr_creator: false
                iskeymgr_owner: false
              }
            ]
            desc:
              '''
              Hardware configuration 1 partition.
              This contains
              EN_SRAM_IFETCH: Enable / disable execute from SRAM CSR switch.
              SOC_DBG_STATE: Multibit enable value for the SOC debug authorization.
              Note SOC_DBG_STATE will be written twice in a device lifetime. The
              values to be written are engineered in the same way as the LC_CTRL
              state encoding words: the ECC encoding remains valid even after
              writing the second value on top of the first.

              The constants can be found in the lc_ctrl_state_pkg.sv package.

              The programming order has to adhere to:

              SOC_DBG_RAW -> SOC_DBG_PRE_PROD -> SOC_DBG_PROD.
              '''
            absorb: false
            iskeymgr_creator: false
            iskeymgr_owner: false
            ignore_read_lock_in_rma: false
            size: 16
            offset: 16024
          }
          {
            name: SECRET0
            variant: Buffered
            secret: true
            sw_digest: false
            hw_digest: true
            write_lock: Digest
            read_lock: Digest
            ignore_read_lock_in_rma: true
            key_sel: Secret0Key
            integrity: true
            bkout_type: false
            zeroizable: true
            skip_sw_header: true
            items:
            [
              {
                name: TEST_UNLOCK_TOKEN
                inv_default: 42146219275086284332081154515457931983
                size: 16
                isdigest: false
                iszer: false
                ismubi: false
                iskeymgr_creator: false
                iskeymgr_owner: false
                offset: 16040
              }
              {
                name: TEST_EXIT_TOKEN
                inv_default: 241193388044955693821746483131132302114
                size: 16
                isdigest: false
                iszer: false
                ismubi: false
                iskeymgr_creator: false
                iskeymgr_owner: false
                offset: 16056
              }
              {
                name: SECRET0_DIGEST
                size: 8
                offset: 16072
                ismubi: false
                isdigest: true
                iszer: false
                inv_default: 15994060125354592494
                iskeymgr_creator: false
                iskeymgr_owner: false
              }
              {
                name: SECRET0_ZER
                size: 8
                offset: 16080
                ismubi: false
                isdigest: false
                iszer: true
                inv_default: 0
                iskeymgr_creator: false
                iskeymgr_owner: false
              }
            ]
            desc:
              '''
              Secret partition 0.
              This contains TEST lifecycle unlock tokens.
              '''
            absorb: false
            iskeymgr_creator: false
            iskeymgr_owner: false
            size: 48
            offset: 16040
          }
          {
            name: SECRET1
            variant: Buffered
            secret: true
            sw_digest: false
            hw_digest: true
            write_lock: Digest
            read_lock: Digest
            ignore_read_lock_in_rma: true
            key_sel: Secret1Key
            integrity: true
            bkout_type: false
            zeroizable: true
            skip_sw_header: true
            items:
            [
              {
                name: SRAM_DATA_KEY_SEED
                inv_default: 49610584572420053792236730456054518552
                size: 16
                isdigest: false
                iszer: false
                ismubi: false
                iskeymgr_creator: false
                iskeymgr_owner: false
                offset: 16088
              }
              {
                name: SECRET1_DIGEST
                size: 8
                offset: 16104
                ismubi: false
                isdigest: true
                iszer: false
                inv_default: 9694113004490520906
                iskeymgr_creator: false
                iskeymgr_owner: false
              }
              {
                name: SECRET1_ZER
                size: 8
                offset: 16112
                ismubi: false
                isdigest: false
                iszer: true
                inv_default: 0
                iskeymgr_creator: false
                iskeymgr_owner: false
              }
            ]
            desc:
              '''
              Secret partition 1.
              This contains the SRAM scrambling key seed.
              '''
            absorb: false
            iskeymgr_creator: false
            iskeymgr_owner: false
            size: 32
            offset: 16088
          }
          {
            name: SECRET2
            variant: Buffered
            secret: true
            sw_digest: false
            hw_digest: true
            write_lock: Digest
            read_lock: Digest
            ignore_read_lock_in_rma: true
            key_sel: Secret2Key
            integrity: true
            bkout_type: false
            zeroizable: true
            skip_sw_header: true
            items:
            [
              {
                name: RMA_TOKEN
                inv_default: 318948098383762964490193881142352172697
                size: 16
                isdigest: false
                iszer: false
                ismubi: false
                iskeymgr_creator: false
                iskeymgr_owner: false
                offset: 16120
              }
              {
                name: CREATOR_ROOT_KEY_SHARE0
                inv_default: 34629914360704372211018394036838819133727768471239971144446686782216090585462
                size: 32
                iskeymgr_creator: true
                isdigest: false
                iszer: false
                ismubi: false
                iskeymgr_owner: false
                offset: 16136
              }
              {
                name: CREATOR_ROOT_KEY_SHARE1
                inv_default: 1304928998077618167994330237584170289335028615580548538480488972898025704836
                size: 32
                iskeymgr_creator: true
                isdigest: false
                iszer: false
                ismubi: false
                iskeymgr_owner: false
                offset: 16168
              }
              {
                name: CREATOR_SEED
                inv_default: 17833865895625802678504757898438306129490488436729400947978243968268591742052
                size: 32
                iskeymgr_creator: true
                isdigest: false
                iszer: false
                ismubi: false
                iskeymgr_owner: false
                offset: 16200
              }
              {
                name: SECRET2_DIGEST
                size: 8
                offset: 16232
                ismubi: false
                isdigest: true
                iszer: false
                inv_default: 6520999107440904866
                iskeymgr_creator: false
                iskeymgr_owner: false
              }
              {
                name: SECRET2_ZER
                size: 8
                offset: 16240
                ismubi: false
                isdigest: false
                iszer: true
                inv_default: 0
                iskeymgr_creator: false
                iskeymgr_owner: false
              }
            ]
            desc:
              '''
              Secret partition 2.
              This contains RMA unlock token, creator root key, and creator seed.
              '''
            absorb: false
            iskeymgr_creator: true
            iskeymgr_owner: false
            size: 128
            offset: 16120
          }
          {
            name: SECRET3
            variant: Buffered
            secret: true
            sw_digest: false
            hw_digest: true
            write_lock: Digest
            read_lock: Digest
            key_sel: Secret3Key
            integrity: true
            bkout_type: false
            zeroizable: true
            skip_sw_header: true
            items:
            [
              {
                name: OWNER_SEED
                inv_default: 70686486377297932620694155829978992075095653265301635643322899792586608109306
                size: 32
                iskeymgr_owner: true
                isdigest: false
                iszer: false
                ismubi: false
                iskeymgr_creator: false
                offset: 16248
              }
              {
                name: SECRET3_DIGEST
                size: 8
                offset: 16280
                ismubi: false
                isdigest: true
                iszer: false
                inv_default: 13418438502867544032
                iskeymgr_creator: false
                iskeymgr_owner: false
              }
              {
                name: SECRET3_ZER
                size: 8
                offset: 16288
                ismubi: false
                isdigest: false
                iszer: true
                inv_default: 0
                iskeymgr_creator: false
                iskeymgr_owner: false
              }
            ]
            desc:
              '''
              Secret partition 3.
              This contains the owner seed.
              '''
            absorb: false
            iskeymgr_creator: false
            iskeymgr_owner: true
            ignore_read_lock_in_rma: false
            size: 48
            offset: 16248
          }
          {
            name: LIFE_CYCLE
            variant: LifeCycle
            secret: false
            sw_digest: false
            hw_digest: false
            write_lock: None
            read_lock: None
            key_sel: NoKey
            integrity: true
            bkout_type: false
            skip_sw_header: true
            items:
            [
              {
                name: LC_TRANSITION_CNT
                inv_default: 14973992796729436808066378999705846639531905052544376352002892737561959261552710366946253675634166805643724298065935
                size: 48
                isdigest: false
                iszer: false
                ismubi: false
                iskeymgr_creator: false
                iskeymgr_owner: false
                offset: 16296
              }
              {
                name: LC_STATE
                inv_default: 1740163610035578858103898302773429044443128827890610586479008287934284440493394280935669489663884
                size: 40
                isdigest: false
                iszer: false
                ismubi: false
                iskeymgr_creator: false
                iskeymgr_owner: false
                offset: 16344
              }
            ]
            desc:
              '''
              Lifecycle partition.
              This contains lifecycle transition count and state. This partition
              cannot be locked since the life cycle state needs to advance to RMA
              in-field. Note that while this partition is not marked secret, it
              is not readable nor writeable via the DAI. Only the LC controller
              can access this partition, and even via the LC controller it is not
              possible to read the raw manufacturing life cycle state in encoded
              form, since that encoding is considered a netlist secret. The LC
              controller only exposes a decoded version of this state.
              '''
            absorb: false
            iskeymgr_creator: false
            iskeymgr_owner: false
            zeroizable: false
            ignore_read_lock_in_rma: false
            size: 88
            offset: 16296
          }
        ]
      }
    }
    {
      name: lc_ctrl
      type: lc_ctrl
      base_addrs:
      {
        regs:
        {
          hart: 0x30150000
        }
        dmi:
        {
          soc_dbg: 0x3000
        }
      }
      memory: {}
      param_list:
      [
        {
          name: RndCnstLcKeymgrDivInvalid
          desc: Diversification value used for all invalid life cycle states.
          type: lc_ctrl_pkg::lc_keymgr_div_t
          randcount: 128
          randtype: data
          name_top: RndCnstLcCtrlLcKeymgrDivInvalid
          default: 0x739dc155fec8b9a9ca90afaa4655965a
          randwidth: 128
        }
        {
          name: RndCnstLcKeymgrDivTestUnlocked
          desc: Diversification value used for the TEST_UNLOCKED* life cycle states.
          type: lc_ctrl_pkg::lc_keymgr_div_t
          randcount: 128
          randtype: data
          name_top: RndCnstLcCtrlLcKeymgrDivTestUnlocked
          default: 0x49d16ac35f3d22f5ca036e029dfe3e01
          randwidth: 128
        }
        {
          name: RndCnstLcKeymgrDivDev
          desc: Diversification value used for the DEV life cycle state.
          type: lc_ctrl_pkg::lc_keymgr_div_t
          randcount: 128
          randtype: data
          name_top: RndCnstLcCtrlLcKeymgrDivDev
          default: 0x3f88514b08e645bba939b14566456ba4
          randwidth: 128
        }
        {
          name: RndCnstLcKeymgrDivProduction
          desc: Diversification value used for the PROD/PROD_END life cycle states.
          type: lc_ctrl_pkg::lc_keymgr_div_t
          randcount: 128
          randtype: data
          name_top: RndCnstLcCtrlLcKeymgrDivProduction
          default: 0x39fb382d362730aca45340f2b0ee60f2
          randwidth: 128
        }
        {
          name: RndCnstLcKeymgrDivRma
          desc: Diversification value used for the RMA life cycle state.
          type: lc_ctrl_pkg::lc_keymgr_div_t
          randcount: 128
          randtype: data
          name_top: RndCnstLcCtrlLcKeymgrDivRma
          default: 0x5e2cee80a251609d5dda4a4ad8c83d39
          randwidth: 128
        }
        {
          name: RndCnstInvalidTokens
          desc: Compile-time random bits used for invalid tokens in the token mux
          type: lc_ctrl_pkg::lc_token_mux_t
          randcount: 1024
          randtype: data
          name_top: RndCnstLcCtrlInvalidTokens
          default: 0x7d1f83d0345aedbbb4d7aa719297d83ae6df7ca62c4b0bd6ee484a7eafe9079b80932f7d9ef197ba49ceebede8f7a26b19372684cdc4422c133b9d9a6699b6c77a29761f9598107c33b11ac5761c14981aeac9e28f9d016c02b80b1581ba47b081edad7956485909768ef3dba808cbc6d57fe7489f41549870395c90d9abf4e0
          randwidth: 1024
        }
      ]
    }
    {
      name: alert_handler
      type: alert_handler
      base_addrs:
      {
        null:
        {
          hart: 0x30160000
        }
      }
      memory: {}
      param_list:
      [
        {
          name: RndCnstLfsrSeed
          desc: Compile-time random bits for initial LFSR seed
          type: alert_handler_pkg::lfsr_seed_t
          randcount: 32
          randtype: data
          name_top: RndCnstAlertHandlerLfsrSeed
          default: 0xf5ed5ba0
          randwidth: 32
        }
        {
          name: RndCnstLfsrPerm
          desc: Compile-time random permutation for LFSR output
          type: alert_handler_pkg::lfsr_perm_t
          randcount: 32
          randtype: perm
          name_top: RndCnstAlertHandlerLfsrPerm
          default: 0xd076da98488bfa9f11d35fe902e19c50c193ded2
          randwidth: 160
        }
      ]
      template_type: alert_handler
    }
    {
      name: sram_ctrl_ret
      type: sram_ctrl
      base_addrs:
      {
        regs:
        {
          hart: 0x30500000
        }
        ram:
        {
          hart: 0x30600000
        }
      }
      memory:
      {
        ram:
        {
          label: ram_ret_aon
          swaccess: rw
          data_intg_passthru: "true"
          exec: True
          byte_write: True
          size: 0x1000
        }
      }
      param_list:
      [
        {
          name: RndCnstSramKey
          desc: Compile-time random reset value for SRAM scrambling key.
          type: otp_ctrl_pkg::sram_key_t
          randcount: 128
          randtype: data
          name_top: RndCnstSramCtrlRetSramKey
          default: 0xc90d110075ff2d26986fc60147eb6d22
          randwidth: 128
        }
        {
          name: RndCnstSramNonce
          desc: Compile-time random reset value for SRAM scrambling nonce.
          type: otp_ctrl_pkg::sram_nonce_t
          randcount: 128
          randtype: data
          name_top: RndCnstSramCtrlRetSramNonce
          default: 0x83f7501a7dafe49bf7a167ad28ab0988
          randwidth: 128
        }
        {
          name: RndCnstLfsrSeed
          desc: Compile-time random bits for initial LFSR seed
          type: sram_ctrl_pkg::lfsr_seed_t
          randcount: 64
          randtype: data
          name_top: RndCnstSramCtrlRetLfsrSeed
          default: 0x33dc1fbb0bac70b2
          randwidth: 64
        }
        {
          name: RndCnstLfsrPerm
          desc: Compile-time random permutation for LFSR output
          type: sram_ctrl_pkg::lfsr_perm_t
          randcount: 64
          randtype: perm
          name_top: RndCnstSramCtrlRetLfsrPerm
          default: 0x3fdc0414e0da5cceb706fd7f44d7a94f649bc8089d6717d5e1cad0ed6e4b825627cec9aaf0693ed2da022a18c8b87509
          randwidth: 384
        }
      ]
    }
    {
      name: aes
      type: aes
      base_addrs:
      {
        null:
        {
          hart: 0x21100000
        }
      }
      memory: {}
      param_list:
      [
        {
          name: RndCnstClearingLfsrSeed
          desc: Default seed of the PRNG used for register clearing.
          type: aes_pkg::clearing_lfsr_seed_t
          randcount: 64
          randtype: data
          name_top: RndCnstAesClearingLfsrSeed
          default: 0xaade3abc18d04239
          randwidth: 64
        }
        {
          name: RndCnstClearingLfsrPerm
          desc: Permutation applied to the LFSR of the PRNG used for clearing.
          type: aes_pkg::clearing_lfsr_perm_t
          randcount: 64
          randtype: perm
          name_top: RndCnstAesClearingLfsrPerm
          default: 0x6a018965817076f2f2993bbaa73b3d7fe2a55eadb5a34e3b3231c356b41c5a2f216d406744fdc803fe4d904092c5eb4e
          randwidth: 384
        }
        {
          name: RndCnstClearingSharePerm
          desc: Permutation applied to the clearing PRNG output for clearing the second share of registers.
          type: aes_pkg::clearing_lfsr_perm_t
          randcount: 64
          randtype: perm
          name_top: RndCnstAesClearingSharePerm
          default: 0xea6bbc7b14b8d5d19561bfb738344cc08cece408cd696109be20593c2968fe07d7da74c52d0aa1d07a72edcad492df4a
          randwidth: 384
        }
        {
          name: RndCnstMaskingLfsrSeed
          desc: Default seed of the PRNG used for masking.
          type: aes_pkg::masking_lfsr_seed_t
          randcount: 288
          randtype: data
          name_top: RndCnstAesMaskingLfsrSeed
          default: 0x6c33a6513d818939d376b89bebbd85950d65ccb853536d9bb0a37927e69ed89bab42e6f6
          randwidth: 288
        }
        {
          name: RndCnstMaskingLfsrPerm
          desc: Permutation applied to the output of the PRNG used for masking.
          type: aes_pkg::masking_lfsr_perm_t
          randcount: 160
          randtype: perm
          name_top: RndCnstAesMaskingLfsrPerm
          default: 0x1c454251463499026d07704788664c49835c72543b9e742f353668166232853d224f768b8f0c2c2a01774b03048973651e987a007c2e7d28300b41591d0f1f6b2b8c783a0e408d29060a4e057b123184442508817186180d8e539757509021102d1575381b24269c693f95557e4d135a5696198782095d9a1a178a27604394376a93522339805f485b6120793c6e674a589d6f3e926c9f639111647f33149b5e
          randwidth: 1280
        }
      ]
    }
    {
      name: kmac
      type: kmac
      base_addrs:
      {
        null:
        {
          hart: 0x21120000
        }
      }
      memory: {}
      param_list:
      [
        {
          name: RndCnstLfsrSeed
          desc: Compile-time random data for PRNG default seed
          type: kmac_pkg::lfsr_seed_t
          randcount: 288
          randtype: data
          name_top: RndCnstKmacLfsrSeed
          default: 0x5555960bb2129844d6433fdaf01dbd728448e76202bb67b66be08307b7e7c0aa9010a8d8
          randwidth: 288
        }
        {
          name: RndCnstLfsrPerm
          desc: Compile-time random permutation for PRNG output
          type: kmac_pkg::lfsr_perm_t
          randcount: 800
          randtype: perm
          name_top: RndCnstKmacLfsrPerm
          default: 0x72a18a1d596b1125b88419d6c3d404c322326b052a1e2064282c20e19589548a30a5828f25c2d6754013709a984c8ec17c3136dc0458056aa61be4df678664610f91a8a72d8aafd58ae18eb0eb2a91b0ae9bc2b639171fd4e92010ac038d83bf5a1c61a8ada6d024e05a69d1b22d7ded65927e180d4950fe74e624bd5d81e302364a2a9ab1041d02c448ba9a1ce81c7a3714ede80d3c15011c7d13a10c17bc12c08a21b89da36dcc25788ce3f6060590ae1580e4a9ebd3eab1442d01ac52c753bc51c30d961a00698d49794d639f2d5b9d49bbd04b4c3b8e88c6cd50294f62b14fbb54e9dd5aad00cb36ce14092841daa42199aa8c069f40b6db6ec487ed6274a2988a5a63d730de6e376f89e16d348e505e926ba4134d2e65dc43155c300729ad7791d1971e11c5ccb781db8091f1f2f3320561ddb939f03b94887e14db1eea1149bb3e9318ec15ea635f0c30e02f23cfd73b1916c34021c5259e67b41f354eb696209ee0a262d109586551510d52a8b1961faaa2166f926bb1ee65b7533475848ee582067235d6b976667ae0f7cc18085110aeb34ad42081099a2f634613138bb429e74e59889d41ab987671033a16f579bd039d8636a03cda654cf9aa2d8c3dde6470a2900a1d273649d714502b5d9b5d8e148d4b4c30eab29c133063bcb4a3d0c7baa53b5fa155a706cbc1c3152e85d2189e050b27c61218936366cc85a2b6c8332f4cd404c6c2f1c740710006163106bac57a50fc08e565c68bc69d91e9e83625572459c58e9559248f9f64a11586c82c1ea6451ad13cf0ae54a1aa1da56e9892c45aa4f9c0759d23146d991a03d9e84d872967544a00ed2a38161fe6c0ba5f64245ad69e31dba6d125299b6735d4949f20892221dd1b7d5b4362f776ff7e4f41bdff1f5652fd743422627d1ab64b12e2fc2e4b7a224024e175f575415c233e1f8525951eb09a478b09a3c499520283b80b36def49d89459e0c77f048a95f3c6895e6578e0f782c1e8a0a9a089c85632b981062eda8d876c464dc003a41c154f99f691934c568a7d2950e51bb1ccc21e1168a03330d4988e65172b21af510dcb2ac5a465025600602f7979beb1af0834ae810b629ef2072065c31378e098200d9fd5512e977f225485f59f699a8eabbeaa9a85b1532609217e0e406389f02659a689ec224ca11cc97709151aa2bd43e5fefb1240fba0584e08bb2e0155dd66d43071a856a41322ae36757bbb94592c437f8c43c9343392cabcbe721ea9e43c190ff704fb0c8abab4c2599e44f5bf8d2640b2e43aa3d3b9b809d0899d8539ad4b27102bcf80fc6d4790e178d66813549e215229b50243284904b53f93abe00879c058886917bc6bc01de991046a1ab7378da101cf42e4cc6e1ebfae296d1c20de59c4240042a
          randwidth: 8000
        }
        {
          name: RndCnstBufferLfsrSeed
          desc: Compile-time random data for PRNG buffer default seed
          type: kmac_pkg::buffer_lfsr_seed_t
          randcount: 800
          randtype: data
          name_top: RndCnstKmacBufferLfsrSeed
          default: 0x27843ea2a0163efeda5b24d93f97d62d99c960542f4a1f2595192e9a969a885419a9d57e36519fa42d20efa348cb77f5089a8381b62d9717b3647e5ce0796ca68aa29523d3f94f27c74acae76b3e145326741f804e3c3a3451469c6118fa23bc32e428ad
          randwidth: 800
        }
        {
          name: RndCnstMsgPerm
          desc: Compile-time random permutation for LFSR Message output
          type: kmac_pkg::msg_perm_t
          randcount: 64
          randtype: perm
          name_top: RndCnstKmacMsgPerm
          default: 0x36556e7848a16cfedf50e16ffadc7323da7cd280a42f062344681a01766c772e769ff701243acc4379aa1d2d7a4d6e0a
          randwidth: 384
        }
      ]
    }
    {
      name: otbn
      type: otbn
      base_addrs:
      {
        null:
        {
          hart: 0x21130000
        }
      }
      memory: {}
      param_list:
      [
        {
          name: RndCnstUrndPrngSeed
          desc: Default seed of the PRNG used for URND.
          type: otbn_pkg::urnd_prng_seed_t
          randcount: 288
          randtype: data
          name_top: RndCnstOtbnUrndPrngSeed
          default: 0x469d8be58d526100d826ebf4137728e993b979b05bddc26ccb34aab93413f8b7dc7cc8c4
          randwidth: 288
        }
        {
          name: RndCnstBnMacUrndPerm
          desc: Compile-time random permutation for URND permutation in BN MAC.
          type: otbn_pkg::bn_mac_urnd_perm_t
          randcount: 256
          randtype: perm
          name_top: RndCnstOtbnBnMacUrndPerm
          default: 0xa5894b3249675262b30896289f5b5522c7e760a1f4993113e19cdc9b7436983c7b3ac16c78047c25fe5ae06f0a37ba85d063e8f8d8dfd74a5035f26aad640f157fb48d65ac0b1210d4ef5e9d3ffbbb940cfa42768fcc845d215466339305af3da4a8b001a2f747567e1e2dabbd3077ca8a3bf1ced38cc4401f41e486d5b72057c52679ec0951d24ffc6d3e2b43cfc058f9daeeeb4cd6072c757db9e518be7344b153112382ffa09019a7d1fded2e278bc2b202bc70c66b1692cbb588d9340e87065c911c14f04872cd8e7145c36e1df5e6f680b81746e2591b2aaa8324005fc868971a389ec9e3a3957add692f81a929dea64eb6f3ea61ae0d9ae9034d39dbbf
          randwidth: 2048
        }
        {
          name: RndCnstOtbnKey
          desc: Compile-time random reset value for IMem/DMem scrambling key.
          type: otp_ctrl_pkg::otbn_key_t
          randcount: 128
          randtype: data
          name_top: RndCnstOtbnOtbnKey
          default: 0xde05cfb093c70d4b54dc8afd1f075326
          randwidth: 128
        }
        {
          name: RndCnstOtbnNonce
          desc: Compile-time random reset value for IMem/DMem scrambling nonce.
          type: otp_ctrl_pkg::otbn_nonce_t
          randcount: 64
          randtype: data
          name_top: RndCnstOtbnOtbnNonce
          default: 0x71eb83c820e1f1ea
          randwidth: 64
        }
      ]
    }
    {
      name: keymgr_dpe
      type: keymgr_dpe
      base_addrs:
      {
        null:
        {
          hart: 0x21140000
        }
      }
      memory: {}
      param_list:
      [
        {
          name: RndCnstLfsrSeed
          desc: Compile-time random bits for initial LFSR seed
          type: keymgr_dpe_pkg::lfsr_seed_t
          randcount: 64
          randtype: data
          name_top: RndCnstKeymgrDpeLfsrSeed
          default: 0xa3a18ad34d471b19
          randwidth: 64
        }
        {
          name: RndCnstLfsrPerm
          desc: Compile-time random permutation for LFSR output
          type: keymgr_dpe_pkg::lfsr_perm_t
          randcount: 64
          randtype: perm
          name_top: RndCnstKeymgrDpeLfsrPerm
          default: 0xed00162a53aaa26e1d23467d25516b2e03474938bf8c4fba6c331fcb7ceee5af1e864506d570b147006d636be93ec727
          randwidth: 384
        }
        {
          name: RndCnstRandPerm
          desc: Compile-time random permutation for entropy used in share overriding
          type: keymgr_dpe_pkg::rand_perm_t
          randcount: 32
          randtype: perm
          name_top: RndCnstKeymgrDpeRandPerm
          default: 0xcb34036eca2e29d9b56f71fd0ba464e4bf50c448
          randwidth: 160
        }
        {
          name: RndCnstRevisionSeed
          desc: Compile-time random bits for revision seed
          type: keymgr_dpe_pkg::seed_t
          randcount: 256
          randtype: data
          name_top: RndCnstKeymgrDpeRevisionSeed
          default: 0x105d80c00220f1da1d3249b8b27f540d01c6126736232f991343079175c6a3f3
          randwidth: 256
        }
        {
          name: RndCnstSoftOutputSeed
          desc: Compile-time random bits for software generation seed
          type: keymgr_dpe_pkg::seed_t
          randcount: 256
          randtype: data
          name_top: RndCnstKeymgrDpeSoftOutputSeed
          default: 0x6d389bd5d0a06e314f7e0efdc7b7970a3ea735116a0c6b28f2300df47ac9287a
          randwidth: 256
        }
        {
          name: RndCnstHardOutputSeed
          desc: Compile-time random bits for hardware generation seed
          type: keymgr_dpe_pkg::seed_t
          randcount: 256
          randtype: data
          name_top: RndCnstKeymgrDpeHardOutputSeed
          default: 0x219e00bb035f64c94def907a59c5b475db2d4ddee65528dfb5418d8791a40518
          randwidth: 256
        }
        {
          name: RndCnstAesSeed
          desc: Compile-time random bits for generation seed when aes destination selected
          type: keymgr_dpe_pkg::seed_t
          randcount: 256
          randtype: data
          name_top: RndCnstKeymgrDpeAesSeed
          default: 0x626bff091f1bd0fbae67415fdca0e74227478f3a0d0e78f4f82ae004fb322a9d
          randwidth: 256
        }
        {
          name: RndCnstKmacSeed
          desc: Compile-time random bits for generation seed when kmac destination selected
          type: keymgr_dpe_pkg::seed_t
          randcount: 256
          randtype: data
          name_top: RndCnstKeymgrDpeKmacSeed
          default: 0x35fffae30fc86d8ea37bb7bff6c6653cda8e066b989fb2bd83beadcf1ab87127
          randwidth: 256
        }
        {
          name: RndCnstOtbnSeed
          desc: Compile-time random bits for generation seed when otbn destination selected
          type: keymgr_dpe_pkg::seed_t
          randcount: 256
          randtype: data
          name_top: RndCnstKeymgrDpeOtbnSeed
          default: 0xcc1e537545255eef8bbc56b206e008162473ae6cbd4926f66adeab5dacecede
          randwidth: 256
        }
        {
          name: RndCnstHmacSeed
          desc: Compile-time random bits for generation seed when hmac destination selected
          type: keymgr_dpe_pkg::seed_t
          randcount: 256
          randtype: data
          name_top: RndCnstKeymgrDpeHmacSeed
          default: 0x39f5ad96335c4709f70e3460d37113edddaf0d2fee3dfde1d0669984352ff4e1
          randwidth: 256
        }
        {
          name: RndCnstNoneSeed
          desc: Compile-time random bits for generation seed when no destination selected
          type: keymgr_dpe_pkg::seed_t
          randcount: 256
          randtype: data
          name_top: RndCnstKeymgrDpeNoneSeed
          default: 0x3b0ca88b5a2ea38da2b1b9d78968bbcc29d9a9b33196d98b9ea0dd8511d5894d
          randwidth: 256
        }
      ]
    }
    {
      name: csrng
      type: csrng
      base_addrs:
      {
        null:
        {
          hart: 0x21150000
        }
      }
      memory: {}
      param_list:
      [
        {
          name: RndCnstCsKeymgrDivNonProduction
          desc: Compile-time random bits for csrng state group diversification value
          type: csrng_pkg::cs_keymgr_div_t
          randcount: 384
          randtype: data
          name_top: RndCnstCsrngCsKeymgrDivNonProduction
          default: 0x8150641f408227e59f67b6dc36409d3cd85feb1ee319926be21c682953b498f0978818db9932d6137cb3fbd79c1473b0
          randwidth: 384
        }
        {
          name: RndCnstCsKeymgrDivProduction
          desc: Compile-time random bits for csrng state group diversification value
          type: csrng_pkg::cs_keymgr_div_t
          randcount: 384
          randtype: data
          name_top: RndCnstCsrngCsKeymgrDivProduction
          default: 0x6b9f20a29eabfcbbc16b35164d75ebc2e3b50aefa1cdc5b560546374109c213a079701c3aa6613cd1583914d8107f533
          randwidth: 384
        }
      ]
    }
    {
      name: sram_ctrl_main
      type: sram_ctrl
      base_addrs:
      {
        regs:
        {
          hart: 0x211c0000
        }
        ram:
        {
          hart: 0x10000000
        }
      }
      memory:
      {
        ram:
        {
          label: ram_main
          swaccess: rw
          data_intg_passthru: "true"
          exec: True
          byte_write: True
          size: 0x10000
        }
      }
      param_list:
      [
        {
          name: RndCnstSramKey
          desc: Compile-time random reset value for SRAM scrambling key.
          type: otp_ctrl_pkg::sram_key_t
          randcount: 128
          randtype: data
          name_top: RndCnstSramCtrlMainSramKey
          default: 0xf051de95eface9a3f55549a9b7b0ac9a
          randwidth: 128
        }
        {
          name: RndCnstSramNonce
          desc: Compile-time random reset value for SRAM scrambling nonce.
          type: otp_ctrl_pkg::sram_nonce_t
          randcount: 128
          randtype: data
          name_top: RndCnstSramCtrlMainSramNonce
          default: 0x3ac6d3c5d2386e063e354feb30b31b7e
          randwidth: 128
        }
        {
          name: RndCnstLfsrSeed
          desc: Compile-time random bits for initial LFSR seed
          type: sram_ctrl_pkg::lfsr_seed_t
          randcount: 64
          randtype: data
          name_top: RndCnstSramCtrlMainLfsrSeed
          default: 0x7ecfae01577c7fc1
          randwidth: 64
        }
        {
          name: RndCnstLfsrPerm
          desc: Compile-time random permutation for LFSR output
          type: sram_ctrl_pkg::lfsr_perm_t
          randcount: 64
          randtype: perm
          name_top: RndCnstSramCtrlMainLfsrPerm
          default: 0xf7536c98a2ea6bee08f2b89e8d21f35f1b9c1680797c96fba6755dd25932b6fd8e5184d1004086fc358cdd03e0870e99
          randwidth: 384
        }
      ]
    }
    {
      name: sram_ctrl_mbox
      type: sram_ctrl
      base_addrs:
      {
        regs:
        {
          hart: 0x211d0000
        }
        ram:
        {
          hart: 0x11000000
        }
      }
      memory:
      {
        ram:
        {
          label: ram_mbox
          swaccess: rw
          data_intg_passthru: "true"
          exec: False
          byte_write: True
          size: 0x1000
        }
      }
      param_list:
      [
        {
          name: RndCnstSramKey
          desc: Compile-time random reset value for SRAM scrambling key.
          type: otp_ctrl_pkg::sram_key_t
          randcount: 128
          randtype: data
          name_top: RndCnstSramCtrlMboxSramKey
          default: 0xdbd995dc1c58f0cdf7fd1d96cd7fdbe4
          randwidth: 128
        }
        {
          name: RndCnstSramNonce
          desc: Compile-time random reset value for SRAM scrambling nonce.
          type: otp_ctrl_pkg::sram_nonce_t
          randcount: 128
          randtype: data
          name_top: RndCnstSramCtrlMboxSramNonce
          default: 0xe4c189454cebf75d37f28396b53d310d
          randwidth: 128
        }
        {
          name: RndCnstLfsrSeed
          desc: Compile-time random bits for initial LFSR seed
          type: sram_ctrl_pkg::lfsr_seed_t
          randcount: 64
          randtype: data
          name_top: RndCnstSramCtrlMboxLfsrSeed
          default: 0x4457746bff3406c1
          randwidth: 64
        }
        {
          name: RndCnstLfsrPerm
          desc: Compile-time random permutation for LFSR output
          type: sram_ctrl_pkg::lfsr_perm_t
          randcount: 64
          randtype: perm
          name_top: RndCnstSramCtrlMboxLfsrPerm
          default: 0xe27ee984e36bcbc22c78af405cb59c49bc424ee107a3969025488663e46f95ffccd43dc177a3c58d5674c2ace09b6b64
          randwidth: 384
        }
      ]
    }
    {
      name: rom_ctrl0
      type: rom_ctrl
      base_addrs:
      {
        rom:
        {
          hart: 0x00008000
        }
        regs:
        {
          hart: 0x211e0000
        }
      }
      memory:
      {
        rom:
        {
          label: rom0
          swaccess: ro
          data_intg_passthru: True
          exec: True
          byte_write: False
          size: 0x8000
        }
      }
      param_list:
      [
        {
          name: RndCnstScrNonce
          desc: Fixed nonce used for address / data scrambling
          type: bit [63:0]
          randcount: 64
          randtype: data
          name_top: RndCnstRomCtrl0ScrNonce
          default: 0x710745c8e815d38e
          randwidth: 64
        }
        {
          name: RndCnstScrKey
          desc: Randomised constant used as a scrambling key for ROM data
          type: bit [127:0]
          randcount: 128
          randtype: data
          name_top: RndCnstRomCtrl0ScrKey
          default: 0x66a9aff8260edcef146342614f489df2
          randwidth: 128
        }
      ]
    }
    {
      name: rom_ctrl1
      type: rom_ctrl
      base_addrs:
      {
        rom:
        {
          hart: 0x00020000
        }
        regs:
        {
          hart: 0x211e1000
        }
      }
      memory:
      {
        rom:
        {
          label: rom1
          swaccess: ro
          data_intg_passthru: True
          exec: True
          byte_write: False
          size: 0x10000
        }
      }
      param_list:
      [
        {
          name: RndCnstScrNonce
          desc: Fixed nonce used for address / data scrambling
          type: bit [63:0]
          randcount: 64
          randtype: data
          name_top: RndCnstRomCtrl1ScrNonce
          default: 0xa995c61caafb48c1
          randwidth: 64
        }
        {
          name: RndCnstScrKey
          desc: Randomised constant used as a scrambling key for ROM data
          type: bit [127:0]
          randcount: 128
          randtype: data
          name_top: RndCnstRomCtrl1ScrKey
          default: 0x8fbf2519367cc435373d323c968f2690
          randwidth: 128
        }
      ]
    }
    {
      name: rv_core_ibex
      type: rv_core_ibex
      base_addrs:
      {
        cfg:
        {
          hart: 0x211f0000
        }
      }
      memory: {}
      param_list:
      [
        {
          name: RndCnstLfsrSeed
          desc: Default seed of the PRNG used for random instructions.
          type: ibex_pkg::lfsr_seed_t
          randcount: 32
          randtype: data
          name_top: RndCnstRvCoreIbexLfsrSeed
          default: 0xbb99efa4
          randwidth: 32
        }
        {
          name: RndCnstLfsrPerm
          desc: Permutation applied to the LFSR of the PRNG used for random instructions.
          type: ibex_pkg::lfsr_perm_t
          randcount: 32
          randtype: perm
          name_top: RndCnstRvCoreIbexLfsrPerm
          default: 0x9c764a7d80e22e356a07b35e9ce022315deecaab
          randwidth: 160
        }
        {
          name: RndCnstIbexKey
          desc: Default icache scrambling key
          type: logic [ibex_pkg::SCRAMBLE_KEY_W-1:0]
          randcount: 128
          randtype: data
          name_top: RndCnstRvCoreIbexIbexKey
          default: 0xd9518fd802ed5b546c9882d78b7218b3
          randwidth: 128
        }
        {
          name: RndCnstIbexNonce
          desc: Default icache scrambling nonce
          type: logic [ibex_pkg::SCRAMBLE_NONCE_W-1:0]
          randcount: 64
          randtype: data
          name_top: RndCnstRvCoreIbexIbexNonce
          default: 0x66aaae3cae1655c
          randwidth: 64
        }
      ]
      template_type: rv_core_ibex
    }
  ]
}
