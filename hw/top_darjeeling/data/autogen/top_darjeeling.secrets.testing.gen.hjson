// Copyright lowRISC contributors (OpenTitan project).
// Licensed under the Apache License, Version 2.0, see LICENSE for details.
// SPDX-License-Identifier: Apache-2.0
//
// ------------------- W A R N I N G: A U T O - G E N E R A T E D   C O D E !! -------------------//
// PLEASE DO NOT HAND-EDIT THIS FILE. IT HAS BEEN AUTO-GENERATED WITH THE FOLLOWING COMMAND:
// util/topgen.py -t hw/top_darjeeling/data/top_darjeeling.hjson
//                -o hw/top_darjeeling/
{
  seed:
  {
    topgen_seed:
    {
      seed_mode: testing
      value: 30303603493614338660957087945302489777030192937656386903877022866265637632015
    }
    otp_img_seed:
    {
      seed_mode: testing
      value: 85452983286950371191603618368782861611109037138182535346147818831008789508651
    }
    lc_ctrl_seed:
    {
      seed_mode: testing
      value: 73183785937994765942105269559576336430731269166614113490738802526276329963158
    }
  }
  module:
  [
    {
      name: otp_ctrl
      type: otp_ctrl
      base_addrs:
      {
        core:
        {
          hart: 0x30130000
        }
      }
      memory: {}
      param_list:
      [
        {
          name: RndCnstLfsrSeed
          desc: Compile-time random bits for initial LFSR seed
          type: otp_ctrl_top_specific_pkg::lfsr_seed_t
          randcount: 40
          randtype: data
          name_top: RndCnstOtpCtrlLfsrSeed
          default: 0xae71a7671b
          randwidth: 40
        }
        {
          name: RndCnstLfsrPerm
          desc: Compile-time random permutation for LFSR output
          type: otp_ctrl_top_specific_pkg::lfsr_perm_t
          randcount: 40
          randtype: perm
          name_top: RndCnstOtpCtrlLfsrPerm
          default: 0x8260063d350b5c535164774e0e590a6a15a20a705b78956361c4847d020c
          randwidth: 240
        }
        {
          name: RndCnstScrmblKeyInit
          desc: Compile-time random permutation for scrambling key/nonce register reset value
          type: otp_ctrl_top_specific_pkg::scrmbl_key_init_t
          randcount: 256
          randtype: data
          name_top: RndCnstOtpCtrlScrmblKeyInit
          default: 0xa077bab40282517993cbd11b5411de0c14f56dceb007f41613a7c433535d032e
          randwidth: 256
        }
        {
          name: RndCnstScrmblKey0
          desc: Compile-time scrambling key
          type: otp_ctrl_top_specific_pkg::key_t
          randcount: 128
          randtype: extdata
          name_top: RndCnstOtpCtrlScrmblKey0
          default: 0x688a9a20b68e0d35660e593f560f6866
          randwidth: 128
        }
        {
          name: RndCnstScrmblKey1
          desc: Compile-time scrambling key
          type: otp_ctrl_top_specific_pkg::key_t
          randcount: 128
          randtype: extdata
          name_top: RndCnstOtpCtrlScrmblKey1
          default: 0xa1ad90a50942397740ab78c5737a2379
          randwidth: 128
        }
        {
          name: RndCnstScrmblKey2
          desc: Compile-time scrambling key
          type: otp_ctrl_top_specific_pkg::key_t
          randcount: 128
          randtype: extdata
          name_top: RndCnstOtpCtrlScrmblKey2
          default: 0xc2ede5b25ec5514b680ccaab361c3f85
          randwidth: 128
        }
        {
          name: RndCnstScrmblKey3
          desc: Compile-time scrambling key
          type: otp_ctrl_top_specific_pkg::key_t
          randcount: 128
          randtype: extdata
          name_top: RndCnstOtpCtrlScrmblKey3
          default: 0x8e1c5cccc121a2c95d21294d190ab75c
          randwidth: 128
        }
        {
          name: RndCnstDigestConst0
          desc: Compile-time digest const
          type: otp_ctrl_top_specific_pkg::digest_const_t
          randcount: 128
          randtype: extdata
          name_top: RndCnstOtpCtrlDigestConst0
          default: 0x9c87e42745452d8a010a9f0ef3221d5
          randwidth: 128
        }
        {
          name: RndCnstDigestConst1
          desc: Compile-time digest const
          type: otp_ctrl_top_specific_pkg::digest_const_t
          randcount: 128
          randtype: extdata
          name_top: RndCnstOtpCtrlDigestConst1
          default: 0x4dcba329ff2f7d4b8a3acdb325087fab
          randwidth: 128
        }
        {
          name: RndCnstDigestIV0
          desc: Compile-time digest initial vector
          type: otp_ctrl_top_specific_pkg::digest_iv_t
          randcount: 64
          randtype: extdata
          name_top: RndCnstOtpCtrlDigestIV0
          default: 0xa0806e02a1fba55b
          randwidth: 64
        }
        {
          name: RndCnstDigestIV1
          desc: Compile-time digest initial vector
          type: otp_ctrl_top_specific_pkg::digest_iv_t
          randcount: 64
          randtype: extdata
          name_top: RndCnstOtpCtrlDigestIV1
          default: 0x9bd623e40aec9b61
          randwidth: 64
        }
        {
          name: RndCnstPartInvDefault
          desc: OTP invalid partition default for buffered partitions
          type: logic [131071:0]
          randcount: 131072
          randtype: extdata
          name_top: RndCnstOtpCtrlPartInvDefault
          default:
          [
            {
              size: 704
              items:
              [
                {
                  size: 320
                  inv_default: 1740163610035578858103898302773429044443128827890610586479008287934284440493394280935669489663884
                }
                {
                  size: 384
                  inv_default: 14973992796729436808066378999705846639531905052544376352002892737561959261552710366946253675634166805643724298065935
                }
              ]
            }
            {
              size: 384
              items:
              [
                {
                  size: 64
                  inv_default: 0
                }
                {
                  size: 64
                  inv_default: 13418438502867544032
                }
                {
                  size: 256
                  inv_default: 70686486377297932620694155829978992075095653265301635643322899792586608109306
                }
              ]
            }
            {
              size: 1024
              items:
              [
                {
                  size: 64
                  inv_default: 0
                }
                {
                  size: 64
                  inv_default: 6520999107440904866
                }
                {
                  size: 256
                  inv_default: 17833865895625802678504757898438306129490488436729400947978243968268591742052
                }
                {
                  size: 256
                  inv_default: 1304928998077618167994330237584170289335028615580548538480488972898025704836
                }
                {
                  size: 256
                  inv_default: 34629914360704372211018394036838819133727768471239971144446686782216090585462
                }
                {
                  size: 128
                  inv_default: 318948098383762964490193881142352172697
                }
              ]
            }
            {
              size: 256
              items:
              [
                {
                  size: 64
                  inv_default: 0
                }
                {
                  size: 64
                  inv_default: 9694113004490520906
                }
                {
                  size: 128
                  inv_default: 49610584572420053792236730456054518552
                }
              ]
            }
            {
              size: 384
              items:
              [
                {
                  size: 64
                  inv_default: 0
                }
                {
                  size: 64
                  inv_default: 15994060125354592494
                }
                {
                  size: 128
                  inv_default: 241193388044955693821746483131132302114
                }
                {
                  size: 128
                  inv_default: 42146219275086284332081154515457931983
                }
              ]
            }
            {
              size: 128
              items:
              [
                {
                  size: 64
                  inv_default: 2245725931179433842
                }
                {
                  comment: unallocated space
                  size: 16
                  inv_default: 0
                }
                {
                  size: 8
                  inv_default: 105
                }
                {
                  size: 8
                  inv_default: 105
                }
                {
                  size: 32
                  inv_default: 0
                }
              ]
            }
            {
              size: 576
              items:
              [
                {
                  size: 64
                  inv_default: 8050338520295093693
                }
                {
                  size: 256
                  inv_default: 104735823630885006896435419055152518946049592294862500793111622154345667968901
                }
                {
                  size: 256
                  inv_default: 40117173308102545085356168480633505499540504862520500713288653871548071919464
                }
              ]
            }
            {
              size: 78848
              items:
              [
                {
                  size: 64
                  inv_default: 14592557388175589354
                }
                {
                  comment: unallocated space
                  size: 5248
                  inv_default: 0
                }
                {
                  size: 73536
                  inv_default: 0
                }
              ]
            }
            {
              size: 8192
              items:
              [
                {
                  size: 8192
                  inv_default: 0
                }
              ]
            }
            {
              size: 2624
              items:
              [
                {
                  size: 64
                  inv_default: 2932316366930412108
                }
                {
                  size: 1280
                  inv_default: 0
                }
                {
                  size: 1280
                  inv_default: 0
                }
              ]
            }
            {
              size: 2624
              items:
              [
                {
                  size: 64
                  inv_default: 16981414814768445627
                }
                {
                  size: 1280
                  inv_default: 0
                }
                {
                  size: 1280
                  inv_default: 0
                }
              ]
            }
            {
              size: 2624
              items:
              [
                {
                  size: 64
                  inv_default: 9966431396093675977
                }
                {
                  size: 1280
                  inv_default: 0
                }
                {
                  size: 1280
                  inv_default: 0
                }
              ]
            }
            {
              size: 2624
              items:
              [
                {
                  size: 64
                  inv_default: 13089428196878425884
                }
                {
                  size: 1280
                  inv_default: 0
                }
                {
                  size: 1280
                  inv_default: 0
                }
              ]
            }
            {
              size: 2624
              items:
              [
                {
                  size: 64
                  inv_default: 13047861355720130167
                }
                {
                  size: 1280
                  inv_default: 0
                }
                {
                  size: 1280
                  inv_default: 0
                }
              ]
            }
            {
              size: 2624
              items:
              [
                {
                  size: 64
                  inv_default: 18297828617386945793
                }
                {
                  size: 1280
                  inv_default: 0
                }
                {
                  size: 1280
                  inv_default: 0
                }
              ]
            }
            {
              size: 2624
              items:
              [
                {
                  size: 64
                  inv_default: 5471265045120329804
                }
                {
                  size: 1280
                  inv_default: 0
                }
                {
                  size: 1280
                  inv_default: 0
                }
              ]
            }
            {
              size: 2624
              items:
              [
                {
                  size: 64
                  inv_default: 18001735645508761512
                }
                {
                  size: 1280
                  inv_default: 0
                }
                {
                  size: 1280
                  inv_default: 0
                }
              ]
            }
            {
              size: 11392
              items:
              [
                {
                  size: 64
                  inv_default: 13936327800626111575
                }
                {
                  comment: unallocated space
                  size: 32
                  inv_default: 0
                }
                {
                  size: 6144
                  inv_default: 0
                }
                {
                  size: 1280
                  inv_default: 0
                }
                {
                  size: 1280
                  inv_default: 0
                }
                {
                  size: 1280
                  inv_default: 0
                }
                {
                  size: 32
                  inv_default: 0
                }
                {
                  size: 1280
                  inv_default: 0
                }
              ]
            }
            {
              size: 384
              items:
              [
                {
                  size: 128
                  inv_default: 0
                }
                {
                  size: 128
                  inv_default: 0
                }
                {
                  size: 128
                  inv_default: 0
                }
              ]
            }
            {
              size: 4800
              items:
              [
                {
                  size: 64
                  inv_default: 3036799796741757437
                }
                {
                  size: 32
                  inv_default: 0
                }
                {
                  size: 32
                  inv_default: 0
                }
                {
                  size: 32
                  inv_default: 0
                }
                {
                  size: 32
                  inv_default: 0
                }
                {
                  size: 32
                  inv_default: 0
                }
                {
                  size: 32
                  inv_default: 0
                }
                {
                  size: 32
                  inv_default: 0
                }
                {
                  size: 32
                  inv_default: 0
                }
                {
                  size: 512
                  inv_default: 0
                }
                {
                  size: 128
                  inv_default: 0
                }
                {
                  size: 128
                  inv_default: 0
                }
                {
                  size: 224
                  inv_default: 0
                }
                {
                  size: 3360
                  inv_default: 0
                }
                {
                  size: 32
                  inv_default: 0
                }
                {
                  size: 32
                  inv_default: 0
                }
                {
                  size: 32
                  inv_default: 0
                }
                {
                  size: 32
                  inv_default: 0
                }
              ]
            }
            {
              size: 2496
              items:
              [
                {
                  size: 64
                  inv_default: 10745993536467849044
                }
                {
                  comment: unallocated space
                  size: 32
                  inv_default: 0
                }
                {
                  size: 32
                  inv_default: 0
                }
                {
                  size: 32
                  inv_default: 0
                }
                {
                  size: 32
                  inv_default: 0
                }
                {
                  size: 32
                  inv_default: 0
                }
                {
                  size: 32
                  inv_default: 0
                }
                {
                  size: 32
                  inv_default: 0
                }
                {
                  size: 32
                  inv_default: 0
                }
                {
                  size: 32
                  inv_default: 0
                }
                {
                  size: 32
                  inv_default: 0
                }
                {
                  size: 32
                  inv_default: 0
                }
                {
                  size: 32
                  inv_default: 0
                }
                {
                  size: 32
                  inv_default: 0
                }
                {
                  size: 32
                  inv_default: 0
                }
                {
                  size: 32
                  inv_default: 0
                }
                {
                  size: 32
                  inv_default: 0
                }
                {
                  size: 32
                  inv_default: 0
                }
                {
                  size: 32
                  inv_default: 0
                }
                {
                  size: 32
                  inv_default: 0
                }
                {
                  size: 32
                  inv_default: 0
                }
                {
                  size: 32
                  inv_default: 0
                }
                {
                  size: 32
                  inv_default: 0
                }
                {
                  size: 32
                  inv_default: 0
                }
                {
                  size: 32
                  inv_default: 0
                }
                {
                  size: 32
                  inv_default: 0
                }
                {
                  size: 32
                  inv_default: 0
                }
                {
                  size: 32
                  inv_default: 0
                }
                {
                  size: 32
                  inv_default: 0
                }
                {
                  size: 32
                  inv_default: 0
                }
                {
                  size: 64
                  inv_default: 0
                }
                {
                  size: 32
                  inv_default: 0
                }
                {
                  size: 64
                  inv_default: 0
                }
                {
                  size: 32
                  inv_default: 0
                }
                {
                  size: 32
                  inv_default: 0
                }
                {
                  size: 256
                  inv_default: 0
                }
                {
                  size: 32
                  inv_default: 0
                }
                {
                  size: 992
                  inv_default: 0
                }
              ]
            }
            {
              size: 512
              items:
              [
                {
                  size: 64
                  inv_default: 312179291205032755
                }
                {
                  size: 448
                  inv_default: 0
                }
              ]
            }
          ]
          randwidth: 131072
        }
      ]
      template_type: otp_ctrl
      otp_mmap:
      {
        otp:
        {
          width: 2
          depth: 8192
          size: 16384
          addr_width: 13
          byte_addr_width: 14
        }
        scrambling:
        {
          key_size: 16
          iv_size: 8
          cnst_size: 16
          keys:
          [
            {
              name: Secret0Key
              value: 138959374610987221438102940065509369958
            }
            {
              name: Secret1Key
              value: 214906908420393146978604154423181190009
            }
            {
              name: Secret2Key
              value: 259105464341488730475238499589165956997
            }
            {
              name: Secret3Key
              value: 188897641917496988174986683742771918684
            }
          ]
          digests:
          [
            {
              name: CnstyDigest
              iv_value: 11565364800674047323
              cnst_value: 13004072182442196571965938888816599509
            }
            {
              name: SramDataKey
              iv_value: 11229202183237704545
              cnst_value: 103407901297817239236543323158765666219
            }
          ]
          num_keys: 4
          num_digests: 2
        }
        partitions:
        [
          {
            name: VENDOR_TEST
            variant: Unbuffered
            absorb: false
            secret: false
            sw_digest: true
            hw_digest: false
            write_lock: Digest
            read_lock: CSR
            key_sel: NoKey
            integrity: false
            bkout_type: false
            zeroizable: false
            skip_sw_header: true
            items:
            [
              {
                name: SCRATCH
                size: 56
                isdigest: false
                iszer: false
                ismubi: false
                iskeymgr_creator: false
                iskeymgr_owner: false
                inv_default: 0
                offset: 0
              }
              {
                name: VENDOR_TEST_DIGEST
                size: 8
                offset: 56
                ismubi: false
                isdigest: true
                iszer: false
                inv_default: 312179291205032755
                iskeymgr_creator: false
                iskeymgr_owner: false
              }
            ]
            desc:
              '''
              Vendor test partition.
              This is reserved for manufacturing smoke checks. The OTP wrapper
              control logic inside prim_otp is allowed to read/write to this
              region. ECC uncorrectable errors seen on the functional prim_otp
              interface will not lead to an alert for this partition.
              Instead, such errors will be reported as correctable ECC errors.
              '''
            iskeymgr_creator: false
            iskeymgr_owner: false
            ignore_read_lock_in_rma: false
            size: 64
            offset: 0
          }
          {
            name: CREATOR_SW_CFG
            variant: Unbuffered
            absorb: false
            secret: false
            sw_digest: true
            hw_digest: false
            write_lock: Digest
            read_lock: CSR
            key_sel: NoKey
            integrity: true
            bkout_type: false
            zeroizable: false
            items:
            [
              {
                name: CREATOR_SW_CFG_AST_CFG
                size: 124
                isdigest: false
                iszer: false
                ismubi: false
                iskeymgr_creator: false
                iskeymgr_owner: false
                inv_default: 0
                offset: 64
              }
              {
                name: CREATOR_SW_CFG_AST_INIT_EN
                size: 4
                isdigest: false
                iszer: false
                ismubi: false
                iskeymgr_creator: false
                iskeymgr_owner: false
                inv_default: 0
                offset: 188
              }
              {
                name: CREATOR_SW_CFG_OVERRIDES
                size: 32
                isdigest: false
                iszer: false
                ismubi: false
                iskeymgr_creator: false
                iskeymgr_owner: false
                inv_default: 0
                offset: 192
              }
              {
                name: CREATOR_SW_CFG_ROM_EXT_SKU
                size: 4
                isdigest: false
                iszer: false
                ismubi: false
                iskeymgr_creator: false
                iskeymgr_owner: false
                inv_default: 0
                offset: 224
              }
              {
                name: CREATOR_SW_CFG_SIGVERIFY_RSA_MOD_EXP_IBEX_EN
                size: 4
                isdigest: false
                iszer: false
                ismubi: false
                iskeymgr_creator: false
                iskeymgr_owner: false
                inv_default: 0
                offset: 228
              }
              {
                name: CREATOR_SW_CFG_SIGVERIFY_RSA_KEY_EN
                size: 8
                isdigest: false
                iszer: false
                ismubi: false
                iskeymgr_creator: false
                iskeymgr_owner: false
                inv_default: 0
                offset: 232
              }
              {
                name: CREATOR_SW_CFG_SIGVERIFY_SPX_EN
                size: 4
                isdigest: false
                iszer: false
                ismubi: false
                iskeymgr_creator: false
                iskeymgr_owner: false
                inv_default: 0
                offset: 240
              }
              {
                name: CREATOR_SW_CFG_SIGVERIFY_SPX_KEY_EN
                size: 8
                isdigest: false
                iszer: false
                ismubi: false
                iskeymgr_creator: false
                iskeymgr_owner: false
                inv_default: 0
                offset: 244
              }
              {
                name: CREATOR_SW_CFG_NVM_DATA_DEFAULT_CFG
                size: 4
                isdigest: false
                iszer: false
                ismubi: false
                iskeymgr_creator: false
                iskeymgr_owner: false
                inv_default: 0
                offset: 252
              }
              {
                name: CREATOR_SW_CFG_NVM_INFO_BOOT_DATA_CFG
                size: 4
                isdigest: false
                iszer: false
                ismubi: false
                iskeymgr_creator: false
                iskeymgr_owner: false
                inv_default: 0
                offset: 256
              }
              {
                name: CREATOR_SW_CFG_NVM_HW_INFO_CFG_OVERRIDE
                size: 4
                isdigest: false
                iszer: false
                ismubi: false
                iskeymgr_creator: false
                iskeymgr_owner: false
                inv_default: 0
                offset: 260
              }
              {
                name: CREATOR_SW_CFG_RNG_EN
                size: 4
                isdigest: false
                iszer: false
                ismubi: false
                iskeymgr_creator: false
                iskeymgr_owner: false
                inv_default: 0
                offset: 264
              }
              {
                name: CREATOR_SW_CFG_JITTER_EN
                size: 4
                isdigest: false
                iszer: false
                ismubi: false
                iskeymgr_creator: false
                iskeymgr_owner: false
                inv_default: 0
                offset: 268
              }
              {
                name: CREATOR_SW_CFG_RET_RAM_RESET_MASK
                size: 4
                isdigest: false
                iszer: false
                ismubi: false
                iskeymgr_creator: false
                iskeymgr_owner: false
                inv_default: 0
                offset: 272
              }
              {
                name: CREATOR_SW_CFG_MANUF_STATE
                size: 4
                isdigest: false
                iszer: false
                ismubi: false
                iskeymgr_creator: false
                iskeymgr_owner: false
                inv_default: 0
                offset: 276
              }
              {
                name: CREATOR_SW_CFG_ROM_EXEC_EN
                size: 4
                isdigest: false
                iszer: false
                ismubi: false
                iskeymgr_creator: false
                iskeymgr_owner: false
                inv_default: 0
                offset: 280
              }
              {
                name: CREATOR_SW_CFG_CPUCTRL
                size: 4
                isdigest: false
                iszer: false
                ismubi: false
                iskeymgr_creator: false
                iskeymgr_owner: false
                inv_default: 0
                offset: 284
              }
              {
                name: CREATOR_SW_CFG_MIN_SEC_VER_ROM_EXT
                size: 4
                isdigest: false
                iszer: false
                ismubi: false
                iskeymgr_creator: false
                iskeymgr_owner: false
                inv_default: 0
                offset: 288
              }
              {
                name: CREATOR_SW_CFG_MIN_SEC_VER_BL0
                size: 4
                isdigest: false
                iszer: false
                ismubi: false
                iskeymgr_creator: false
                iskeymgr_owner: false
                inv_default: 0
                offset: 292
              }
              {
                name: CREATOR_SW_CFG_DEFAULT_BOOT_DATA_IN_PROD_EN
                size: 4
                isdigest: false
                iszer: false
                ismubi: false
                iskeymgr_creator: false
                iskeymgr_owner: false
                inv_default: 0
                offset: 296
              }
              {
                name: CREATOR_SW_CFG_RMA_SPIN_EN
                size: 4
                isdigest: false
                iszer: false
                ismubi: false
                iskeymgr_creator: false
                iskeymgr_owner: false
                inv_default: 0
                offset: 300
              }
              {
                name: CREATOR_SW_CFG_RMA_SPIN_CYCLES
                size: 4
                isdigest: false
                iszer: false
                ismubi: false
                iskeymgr_creator: false
                iskeymgr_owner: false
                inv_default: 0
                offset: 304
              }
              {
                name: CREATOR_SW_CFG_RNG_REPCNT_THRESHOLDS
                size: 4
                isdigest: false
                iszer: false
                ismubi: false
                iskeymgr_creator: false
                iskeymgr_owner: false
                inv_default: 0
                offset: 308
              }
              {
                name: CREATOR_SW_CFG_RNG_REPCNTS_THRESHOLDS
                size: 4
                isdigest: false
                iszer: false
                ismubi: false
                iskeymgr_creator: false
                iskeymgr_owner: false
                inv_default: 0
                offset: 312
              }
              {
                name: CREATOR_SW_CFG_RNG_ADAPTP_HI_THRESHOLDS
                size: 4
                isdigest: false
                iszer: false
                ismubi: false
                iskeymgr_creator: false
                iskeymgr_owner: false
                inv_default: 0
                offset: 316
              }
              {
                name: CREATOR_SW_CFG_RNG_ADAPTP_LO_THRESHOLDS
                size: 4
                isdigest: false
                iszer: false
                ismubi: false
                iskeymgr_creator: false
                iskeymgr_owner: false
                inv_default: 0
                offset: 320
              }
              {
                name: CREATOR_SW_CFG_RNG_BUCKET_THRESHOLDS
                size: 4
                isdigest: false
                iszer: false
                ismubi: false
                iskeymgr_creator: false
                iskeymgr_owner: false
                inv_default: 0
                offset: 324
              }
              {
                name: CREATOR_SW_CFG_RNG_MARKOV_HI_THRESHOLDS
                size: 4
                isdigest: false
                iszer: false
                ismubi: false
                iskeymgr_creator: false
                iskeymgr_owner: false
                inv_default: 0
                offset: 328
              }
              {
                name: CREATOR_SW_CFG_RNG_MARKOV_LO_THRESHOLDS
                size: 4
                isdigest: false
                iszer: false
                ismubi: false
                iskeymgr_creator: false
                iskeymgr_owner: false
                inv_default: 0
                offset: 332
              }
              {
                name: CREATOR_SW_CFG_RNG_EXTHT_HI_THRESHOLDS
                size: 4
                isdigest: false
                iszer: false
                ismubi: false
                iskeymgr_creator: false
                iskeymgr_owner: false
                inv_default: 0
                offset: 336
              }
              {
                name: CREATOR_SW_CFG_RNG_EXTHT_LO_THRESHOLDS
                size: 4
                isdigest: false
                iszer: false
                ismubi: false
                iskeymgr_creator: false
                iskeymgr_owner: false
                inv_default: 0
                offset: 340
              }
              {
                name: CREATOR_SW_CFG_RNG_BOOT_ALERT_THRESHOLD
                size: 4
                isdigest: false
                iszer: false
                ismubi: false
                iskeymgr_creator: false
                iskeymgr_owner: false
                inv_default: 0
                offset: 344
              }
              {
                name: CREATOR_SW_CFG_RNG_FIPS_ALERT_THRESHOLD
                size: 4
                isdigest: false
                iszer: false
                ismubi: false
                iskeymgr_creator: false
                iskeymgr_owner: false
                inv_default: 0
                offset: 348
              }
              {
                name: CREATOR_SW_CFG_RNG_BOOT_CONFIG_DIGEST
                size: 4
                isdigest: false
                iszer: false
                ismubi: false
                iskeymgr_creator: false
                iskeymgr_owner: false
                inv_default: 0
                offset: 352
              }
              {
                name: CREATOR_SW_CFG_RNG_FIPS_CONFIG_DIGEST
                size: 4
                isdigest: false
                iszer: false
                ismubi: false
                iskeymgr_creator: false
                iskeymgr_owner: false
                inv_default: 0
                offset: 356
              }
              {
                name: CREATOR_SW_CFG_SRAM_KEY_RENEW_AND_INIT_EN
                size: 4
                isdigest: false
                iszer: false
                ismubi: false
                iskeymgr_creator: false
                iskeymgr_owner: false
                inv_default: 0
                offset: 360
              }
              {
                name: CREATOR_SW_CFG_DIGEST
                size: 8
                offset: 368
                ismubi: false
                isdigest: true
                iszer: false
                inv_default: 10745993536467849044
                iskeymgr_creator: false
                iskeymgr_owner: false
              }
            ]
            desc:
              '''
              Software configuration partition.
              This is for device-specific calibration data. For example, clock,
              LDO, RNG.
              '''
            iskeymgr_creator: false
            iskeymgr_owner: false
            ignore_read_lock_in_rma: false
            size: 312
            offset: 64
          }
          {
            name: OWNER_SW_CFG
            variant: Unbuffered
            absorb: false
            secret: false
            sw_digest: true
            hw_digest: false
            write_lock: Digest
            read_lock: CSR
            key_sel: NoKey
            integrity: true
            bkout_type: false
            zeroizable: false
            items:
            [
              {
                name: OWNER_SW_CFG_ROM_ERROR_REPORTING
                size: 4
                isdigest: false
                iszer: false
                ismubi: false
                iskeymgr_creator: false
                iskeymgr_owner: false
                inv_default: 0
                offset: 376
              }
              {
                name: OWNER_SW_CFG_ROM_BOOTSTRAP_DIS
                size: 4
                isdigest: false
                iszer: false
                ismubi: false
                iskeymgr_creator: false
                iskeymgr_owner: false
                inv_default: 0
                offset: 380
              }
              {
                name: OWNER_SW_CFG_ROM_ALERT_CLASS_EN
                size: 4
                isdigest: false
                iszer: false
                ismubi: false
                iskeymgr_creator: false
                iskeymgr_owner: false
                inv_default: 0
                offset: 384
              }
              {
                name: OWNER_SW_CFG_ROM_ALERT_ESCALATION
                size: 4
                isdigest: false
                iszer: false
                ismubi: false
                iskeymgr_creator: false
                iskeymgr_owner: false
                inv_default: 0
                offset: 388
              }
              {
                name: OWNER_SW_CFG_ROM_ALERT_CLASSIFICATION
                size: 420
                isdigest: false
                iszer: false
                ismubi: false
                iskeymgr_creator: false
                iskeymgr_owner: false
                inv_default: 0
                offset: 392
              }
              {
                name: OWNER_SW_CFG_ROM_LOCAL_ALERT_CLASSIFICATION
                size: 28
                isdigest: false
                iszer: false
                ismubi: false
                iskeymgr_creator: false
                iskeymgr_owner: false
                inv_default: 0
                offset: 812
              }
              {
                name: OWNER_SW_CFG_ROM_ALERT_ACCUM_THRESH
                size: 16
                isdigest: false
                iszer: false
                ismubi: false
                iskeymgr_creator: false
                iskeymgr_owner: false
                inv_default: 0
                offset: 840
              }
              {
                name: OWNER_SW_CFG_ROM_ALERT_TIMEOUT_CYCLES
                size: 16
                isdigest: false
                iszer: false
                ismubi: false
                iskeymgr_creator: false
                iskeymgr_owner: false
                inv_default: 0
                offset: 856
              }
              {
                name: OWNER_SW_CFG_ROM_ALERT_PHASE_CYCLES
                size: 64
                isdigest: false
                iszer: false
                ismubi: false
                iskeymgr_creator: false
                iskeymgr_owner: false
                inv_default: 0
                offset: 872
              }
              {
                name: OWNER_SW_CFG_ROM_ALERT_DIGEST_PROD
                size: 4
                isdigest: false
                iszer: false
                ismubi: false
                iskeymgr_creator: false
                iskeymgr_owner: false
                inv_default: 0
                offset: 936
              }
              {
                name: OWNER_SW_CFG_ROM_ALERT_DIGEST_PROD_END
                size: 4
                isdigest: false
                iszer: false
                ismubi: false
                iskeymgr_creator: false
                iskeymgr_owner: false
                inv_default: 0
                offset: 940
              }
              {
                name: OWNER_SW_CFG_ROM_ALERT_DIGEST_DEV
                size: 4
                isdigest: false
                iszer: false
                ismubi: false
                iskeymgr_creator: false
                iskeymgr_owner: false
                inv_default: 0
                offset: 944
              }
              {
                name: OWNER_SW_CFG_ROM_ALERT_DIGEST_RMA
                size: 4
                isdigest: false
                iszer: false
                ismubi: false
                iskeymgr_creator: false
                iskeymgr_owner: false
                inv_default: 0
                offset: 948
              }
              {
                name: OWNER_SW_CFG_ROM_WATCHDOG_BITE_THRESHOLD_CYCLES
                size: 4
                isdigest: false
                iszer: false
                ismubi: false
                iskeymgr_creator: false
                iskeymgr_owner: false
                inv_default: 0
                offset: 952
              }
              {
                name: OWNER_SW_CFG_ROM_KEYMGR_ROM_EXT_MEAS_EN
                size: 4
                isdigest: false
                iszer: false
                ismubi: false
                iskeymgr_creator: false
                iskeymgr_owner: false
                inv_default: 0
                offset: 956
              }
              {
                name: OWNER_SW_CFG_MANUF_STATE
                size: 4
                isdigest: false
                iszer: false
                ismubi: false
                iskeymgr_creator: false
                iskeymgr_owner: false
                inv_default: 0
                offset: 960
              }
              {
                name: OWNER_SW_CFG_ROM_RSTMGR_INFO_EN
                size: 4
                isdigest: false
                iszer: false
                ismubi: false
                iskeymgr_creator: false
                iskeymgr_owner: false
                inv_default: 0
                offset: 964
              }
              {
                name: OWNER_SW_CFG_DIGEST
                size: 8
                offset: 968
                ismubi: false
                isdigest: true
                iszer: false
                inv_default: 3036799796741757437
                iskeymgr_creator: false
                iskeymgr_owner: false
              }
            ]
            desc:
              '''
              Software configuration partition.
              This contains data that changes software behavior in the ROM, for
              example enabling defensive features in ROM or selecting failure
              modes if verification fails.
              '''
            iskeymgr_creator: false
            iskeymgr_owner: false
            ignore_read_lock_in_rma: false
            size: 600
            offset: 376
          }
          {
            name: OWNERSHIP_SLOT_STATE
            variant: Unbuffered
            absorb: false
            secret: false
            sw_digest: false
            hw_digest: false
            write_lock: None
            read_lock: CSR
            key_sel: NoKey
            integrity: true
            bkout_type: false
            zeroizable: false
            items:
            [
              {
                name: OWNERSHIP_SLOT_STATE_ROT_OWNER_AUTH
                size: 16
                desc:
                  '''
                  Creator Ownership transfer state management
                  OWNERSHIP_ST_RAW:       ownership not yet claimed (factory default)
                  OWNERSHIP_ST_LOCKED0:   first ownership slot claimed
                  OWNERSHIP_ST_RELEASED0: first ownership slot released (assets have been cleared, ready to xfer)
                  OWNERSHIP_ST_LOCKED1:   second ownership slot claimed
                  OWNERSHIP_ST_SCRAPPED:  scrap state - terminal
                  '''
                isdigest: false
                iszer: false
                ismubi: false
                iskeymgr_creator: false
                iskeymgr_owner: false
                inv_default: 0
                offset: 976
              }
              {
                name: OWNERSHIP_SLOT_STATE_PLAT_INTEG_AUTH
                size: 16
                desc:
                  '''
                  Creator Ownership transfer state management
                  OWNERSHIP_ST_RAW:       ownership not yet claimed (factory default)
                  OWNERSHIP_ST_LOCKED0:   first ownership slot claimed
                  OWNERSHIP_ST_RELEASED0: first ownership slot released (assets have been cleared, ready to xfer)
                  OWNERSHIP_ST_LOCKED1:   second ownership slot claimed
                  OWNERSHIP_ST_SCRAPPED:  scrap state - terminal
                  '''
                isdigest: false
                iszer: false
                ismubi: false
                iskeymgr_creator: false
                iskeymgr_owner: false
                inv_default: 0
                offset: 992
              }
              {
                name: OWNERSHIP_SLOT_STATE_PLAT_OWNER_AUTH
                size: 16
                desc:
                  '''
                  Creator Ownership transfer state management
                  OWNERSHIP_ST_RAW:       ownership not yet claimed (factory default)
                  OWNERSHIP_ST_LOCKED0:   first ownership slot claimed
                  OWNERSHIP_ST_RELEASED0: first ownership slot released (assets have been cleared, ready to xfer)
                  OWNERSHIP_ST_LOCKED1:   second ownership slot claimed
                  OWNERSHIP_ST_RELEASED1: second ownership slot released (assets have been cleared, ready to xfer)
                  OWNERSHIP_ST_LOCKED2:   third ownership slot claimed
                  OWNERSHIP_ST_RELEASED2: third ownership slot released (assets have been cleared, ready to xfer)
                  OWNERSHIP_ST_LOCKED3:   fourth ownership slot claimed
                  OWNERSHIP_ST_SCRAPPED:  scrap state - terminal
                  '''
                isdigest: false
                iszer: false
                ismubi: false
                iskeymgr_creator: false
                iskeymgr_owner: false
                inv_default: 0
                offset: 1008
              }
            ]
            desc:
              '''
              SW managed asset ownership states partition.

              Multibit enable value for the tracking the asset ownership states.
              Note that the states can be written multiple times in a device lifetime.
              The values to be written are engineered in the same way as the LC_CTRL
              state encoding words so that the ECC encoding remains valid even after
              updating the values.

              The constants can be found in the lc_ctrl_state_pkg.sv package.

              The programming order has to adhere to:

              OWNERSHIP_ST_RAW (factory all-zero state) ->
              OWNERSHIP_ST_LOCKED0 ->
              OWNERSHIP_ST_RELEASED0 ->
              ...
              OWNERSHIP_ST_SCRAPPED

              Note that if there are less than 4 slots available the higher slot states
              become logically equivalent to OWNERSHIP_SCRAPPED (firmware has to handle
              this correctly).
              '''
            iskeymgr_creator: false
            iskeymgr_owner: false
            ignore_read_lock_in_rma: false
            size: 48
            offset: 976
          }
          {
            name: ROT_CREATOR_AUTH
            variant: Unbuffered
            absorb: false
            secret: false
            sw_digest: true
            hw_digest: false
            write_lock: Digest
            read_lock: CSR
            key_sel: NoKey
            integrity: true
            bkout_type: false
            zeroizable: false
            items:
            [
              {
                name: ROT_CREATOR_AUTH_NON_RAW_MFW_CODESIGN_KEY
                size: 160
                desc:
                  '''
                  Pub Key used to verify the manufacturing provisioning Software container
                  160B = Custom Cert --> {PubKey:48, Signature:48, Device ID:32, metadata:16}
                  It is expected to be provisioned at Chip Probe stage when LC = TEST
                  i.e. provisioning protected under proper lifecycle logistics / secure supplychain management
                  '''
                isdigest: false
                iszer: false
                ismubi: false
                iskeymgr_creator: false
                iskeymgr_owner: false
                inv_default: 0
                offset: 1024
              }
              {
                name: ROT_CREATOR_AUTH_OWNERSHIP_STATE
                size: 4
                desc:
                  '''
                  Creator Ownership transfer state management
                  UNLOCKED - ownership of ROT not yet claimed
                  LOCKED   - ownership claimed and
                  RELEASED - Release ownership (assets have been cleared, ready to xfer)
                  '''
                isdigest: false
                iszer: false
                ismubi: false
                iskeymgr_creator: false
                iskeymgr_owner: false
                inv_default: 0
                offset: 1184
              }
              {
                name: ROT_CREATOR_AUTH_ROM2_PATCH_SIGVERIFY_KEY
                size: 160
                desc:
                  '''
                  Pub Key used to verify the ROM2 OTP based patch
                  160B = Custom Cert --> {PubKey:48, Signature:48, Device ID:32, metadata:16}
                  It is expected to be provisioned at Chip Probe stage when LC = TEST
                  i.e. provisioning protected under proper lifecycle logistics / secure supplychain management
                    OTP based key (instead of ROM) facilitates easy key rotation
                  '''
                isdigest: false
                iszer: false
                ismubi: false
                iskeymgr_creator: false
                iskeymgr_owner: false
                inv_default: 0
                offset: 1188
              }
              {
                name: ROT_CREATOR_AUTH_KEYMANIFEST_KEY
                size: 160
                desc:
                  '''
                  Pub Key used to verify the ROT CREATOR KEY MANIFEST.
                  KM is used to provisioning additional keys in (external) flash
                  160B = Custom Cert --> {PubKey:48, Signature:48, Device ID:32, metadata:16}
                  It is expected to be provisioned at Chip Probe stage when LC = TEST
                  i.e. provisioning protected under proper lifecycle logistics / secure supplychain management
                  '''
                isdigest: false
                iszer: false
                ismubi: false
                iskeymgr_creator: false
                iskeymgr_owner: false
                inv_default: 0
                offset: 1348
              }
              {
                name: ROT_CREATOR_AUTH_UNLOCK4XFER_KEY
                size: 160
                desc:
                  '''
                  Pub Key used to verify the ROT CREATOR KEY MANIFEST.
                  Used to authenticate the Unlock Ownership payload. Key Type: ECC NIST-P384 Curve.
                  160B = Custom Cert --> {PubKey:48, Signature:48, Device ID:32, metadata:16}
                  Can be made part bound i.e. unique per part key cert
                  i.e. provisioning protected under proper lifecycle logistics / secure supplychain management
                  '''
                isdigest: false
                iszer: false
                ismubi: false
                iskeymgr_creator: false
                iskeymgr_owner: false
                inv_default: 0
                offset: 1508
              }
              {
                name: ROT_CREATOR_AUTH_IDENTITY_CERT
                size: 768
                desc: ROT Device Identity Certificate endorsed by Silicon Creator stable off device PKI
                isdigest: false
                iszer: false
                ismubi: false
                iskeymgr_creator: false
                iskeymgr_owner: false
                inv_default: 0
                offset: 1668
              }
              {
                name: ROT_CREATOR_AUTH_DIGEST
                size: 8
                offset: 2440
                ismubi: false
                isdigest: true
                iszer: false
                inv_default: 13936327800626111575
                iskeymgr_creator: false
                iskeymgr_owner: false
              }
            ]
            desc: Software managed creator partition.
            iskeymgr_creator: false
            iskeymgr_owner: false
            ignore_read_lock_in_rma: false
            size: 1424
            offset: 1024
          }
          {
            name: ROT_OWNER_AUTH_SLOT0
            variant: Unbuffered
            absorb: false
            secret: false
            sw_digest: true
            hw_digest: false
            write_lock: Digest
            read_lock: CSR
            key_sel: NoKey
            integrity: true
            bkout_type: false
            zeroizable: false
            items:
            [
              {
                name: ROT_OWNER_AUTH_SLOT0_KEYMANIFEST_KEY
                size: 160
                desc:
                  '''
                  Pub Key used to verify the ROT OWNER KEY MANIFEST.
                  KM is used to provisioning additional keys in (external) flash
                  160B = Custom Cert --> {PubKey:48, Signature:48, Device ID:32, metadata:16}
                  It is expected to be provisioned at Chip Probe stage when LC = TEST
                  i.e. provisioning protected under proper lifecycle logistics / secure supplychain management
                  '''
                isdigest: false
                iszer: false
                ismubi: false
                iskeymgr_creator: false
                iskeymgr_owner: false
                inv_default: 0
                offset: 2448
              }
              {
                name: ROT_OWNER_AUTH_SLOT0_UNLOCK4XFER_KEY
                size: 160
                desc:
                  '''
                  Pub Key used to verify the ROT OWNER KEY MANIFEST.
                  Used to authenticate the Unlock Ownership payload. Key Type: ECC NIST-P384 Curve.
                  160B = Custom Cert --> {PubKey:48, Signature:48, Device ID:32, metadata:16}
                  Can be made part bound i.e. unique per part key cert
                  i.e. provisioning protected under proper lifecycle logistics / secure supplychain management
                  '''
                isdigest: false
                iszer: false
                ismubi: false
                iskeymgr_creator: false
                iskeymgr_owner: false
                inv_default: 0
                offset: 2608
              }
              {
                name: ROT_OWNER_AUTH_SLOT0_DIGEST
                size: 8
                offset: 2768
                ismubi: false
                isdigest: true
                iszer: false
                inv_default: 18001735645508761512
                iskeymgr_creator: false
                iskeymgr_owner: false
              }
            ]
            desc: Software managed owner slot 0 partition.
            iskeymgr_creator: false
            iskeymgr_owner: false
            ignore_read_lock_in_rma: false
            size: 328
            offset: 2448
          }
          {
            name: ROT_OWNER_AUTH_SLOT1
            variant: Unbuffered
            absorb: false
            secret: false
            sw_digest: true
            hw_digest: false
            write_lock: Digest
            read_lock: CSR
            key_sel: NoKey
            integrity: true
            bkout_type: false
            zeroizable: false
            items:
            [
              {
                name: ROT_OWNER_AUTH_SLOT1_KEYMANIFEST_KEY
                size: 160
                desc:
                  '''
                  Pub Key used to verify the ROT OWNER KEY MANIFEST.
                  KM is used to provisioning additional keys in (external) flash
                  160B = Custom Cert --> {PubKey:48, Signature:48, Device ID:32, metadata:16}
                  It is expected to be provisioned at Chip Probe stage when LC = TEST
                  i.e. provisioning protected under proper lifecycle logistics / secure supplychain management
                  '''
                isdigest: false
                iszer: false
                ismubi: false
                iskeymgr_creator: false
                iskeymgr_owner: false
                inv_default: 0
                offset: 2776
              }
              {
                name: ROT_OWNER_AUTH_SLOT1_UNLOCK4XFER_KEY
                size: 160
                desc:
                  '''
                  Pub Key used to verify the ROT OWNER KEY MANIFEST.
                  Used to authenticate the Unlock Ownership payload. Key Type: ECC NIST-P384 Curve.
                  160B = Custom Cert --> {PubKey:48, Signature:48, Device ID:32, metadata:16}
                  Can be made part bound i.e. unique per part key cert
                  i.e. provisioning protected under proper lifecycle logistics / secure supplychain management
                  '''
                isdigest: false
                iszer: false
                ismubi: false
                iskeymgr_creator: false
                iskeymgr_owner: false
                inv_default: 0
                offset: 2936
              }
              {
                name: ROT_OWNER_AUTH_SLOT1_DIGEST
                size: 8
                offset: 3096
                ismubi: false
                isdigest: true
                iszer: false
                inv_default: 5471265045120329804
                iskeymgr_creator: false
                iskeymgr_owner: false
              }
            ]
            desc: Software managed owner slot 1 partition.
            iskeymgr_creator: false
            iskeymgr_owner: false
            ignore_read_lock_in_rma: false
            size: 328
            offset: 2776
          }
          {
            name: PLAT_INTEG_AUTH_SLOT0
            variant: Unbuffered
            absorb: false
            secret: false
            sw_digest: true
            hw_digest: false
            write_lock: Digest
            read_lock: CSR
            key_sel: NoKey
            integrity: true
            bkout_type: false
            zeroizable: false
            items:
            [
              {
                name: PLAT_INTEG_AUTH_SLOT0_KEYMANIFEST_KEY
                size: 160
                desc:
                  '''
                  Pub Key used to verify the ROT OWNER KEY MANIFEST.
                  KM is used to provisioning additional keys in (external) flash
                  160B = Custom Cert --> {PubKey:48, Signature:48, Device ID:32, metadata:16}
                  It is expected to be provisioned at Chip Probe stage when LC = TEST
                  i.e. provisioning protected under proper lifecycle logistics / secure supplychain management
                  '''
                isdigest: false
                iszer: false
                ismubi: false
                iskeymgr_creator: false
                iskeymgr_owner: false
                inv_default: 0
                offset: 3104
              }
              {
                name: PLAT_INTEG_AUTH_SLOT0_UNLOCK4XFER_KEY
                size: 160
                desc:
                  '''
                  Pub Key used to verify the ROT OWNER KEY MANIFEST.
                  Used to authenticate the Unlock Ownership payload. Key Type: ECC NIST-P384 Curve.
                  160B = Custom Cert --> {PubKey:48, Signature:48, Device ID:32, metadata:16}
                  Can be made part bound i.e. unique per part key cert
                  i.e. provisioning protected under proper lifecycle logistics / secure supplychain management
                  '''
                isdigest: false
                iszer: false
                ismubi: false
                iskeymgr_creator: false
                iskeymgr_owner: false
                inv_default: 0
                offset: 3264
              }
              {
                name: PLAT_INTEG_AUTH_SLOT0_DIGEST
                size: 8
                offset: 3424
                ismubi: false
                isdigest: true
                iszer: false
                inv_default: 18297828617386945793
                iskeymgr_creator: false
                iskeymgr_owner: false
              }
            ]
            desc: Software managed platform integrator slot 0 partition.
            iskeymgr_creator: false
            iskeymgr_owner: false
            ignore_read_lock_in_rma: false
            size: 328
            offset: 3104
          }
          {
            name: PLAT_INTEG_AUTH_SLOT1
            variant: Unbuffered
            absorb: false
            secret: false
            sw_digest: true
            hw_digest: false
            write_lock: Digest
            read_lock: CSR
            key_sel: NoKey
            integrity: true
            bkout_type: false
            zeroizable: false
            items:
            [
              {
                name: PLAT_INTEG_AUTH_SLOT1_KEYMANIFEST_KEY
                size: 160
                desc:
                  '''
                  Pub Key used to verify the ROT OWNER KEY MANIFEST.
                  KM is used to provisioning additional keys in (external) flash
                  160B = Custom Cert --> {PubKey:48, Signature:48, Device ID:32, metadata:16}
                  It is expected to be provisioned at Chip Probe stage when LC = TEST
                  i.e. provisioning protected under proper lifecycle logistics / secure supplychain management
                  '''
                isdigest: false
                iszer: false
                ismubi: false
                iskeymgr_creator: false
                iskeymgr_owner: false
                inv_default: 0
                offset: 3432
              }
              {
                name: PLAT_INTEG_AUTH_SLOT1_UNLOCK4XFER_KEY
                size: 160
                desc:
                  '''
                  Pub Key used to verify the ROT OWNER KEY MANIFEST.
                  Used to authenticate the Unlock Ownership payload. Key Type: ECC NIST-P384 Curve.
                  160B = Custom Cert --> {PubKey:48, Signature:48, Device ID:32, metadata:16}
                  Can be made part bound i.e. unique per part key cert
                  i.e. provisioning protected under proper lifecycle logistics / secure supplychain management
                  '''
                isdigest: false
                iszer: false
                ismubi: false
                iskeymgr_creator: false
                iskeymgr_owner: false
                inv_default: 0
                offset: 3592
              }
              {
                name: PLAT_INTEG_AUTH_SLOT1_DIGEST
                size: 8
                offset: 3752
                ismubi: false
                isdigest: true
                iszer: false
                inv_default: 13047861355720130167
                iskeymgr_creator: false
                iskeymgr_owner: false
              }
            ]
            desc: Software managed platform integrator slot 1 partition.
            iskeymgr_creator: false
            iskeymgr_owner: false
            ignore_read_lock_in_rma: false
            size: 328
            offset: 3432
          }
          {
            name: PLAT_OWNER_AUTH_SLOT0
            variant: Unbuffered
            absorb: false
            secret: false
            sw_digest: true
            hw_digest: false
            write_lock: Digest
            read_lock: CSR
            key_sel: NoKey
            integrity: true
            bkout_type: false
            zeroizable: false
            items:
            [
              {
                name: PLAT_OWNER_AUTH_SLOT0_KEYMANIFEST_KEY
                size: 160
                desc:
                  '''
                  Pub Key used to verify the ROT OWNER KEY MANIFEST.
                  KM is used to provisioning additional keys in (external) flash
                  160B = Custom Cert --> {PubKey:48, Signature:48, Device ID:32, metadata:16}
                  It is expected to be provisioned at Chip Probe stage when LC = TEST
                  i.e. provisioning protected under proper lifecycle logistics / secure supplychain management
                  '''
                isdigest: false
                iszer: false
                ismubi: false
                iskeymgr_creator: false
                iskeymgr_owner: false
                inv_default: 0
                offset: 3760
              }
              {
                name: PLAT_OWNER_AUTH_SLOT0_UNLOCK4XFER_KEY
                size: 160
                desc:
                  '''
                  Pub Key used to verify the ROT OWNER KEY MANIFEST.
                  Used to authenticate the Unlock Ownership payload. Key Type: ECC NIST-P384 Curve.
                  160B = Custom Cert --> {PubKey:48, Signature:48, Device ID:32, metadata:16}
                  Can be made part bound i.e. unique per part key cert
                  i.e. provisioning protected under proper lifecycle logistics / secure supplychain management
                  '''
                isdigest: false
                iszer: false
                ismubi: false
                iskeymgr_creator: false
                iskeymgr_owner: false
                inv_default: 0
                offset: 3920
              }
              {
                name: PLAT_OWNER_AUTH_SLOT0_DIGEST
                size: 8
                offset: 4080
                ismubi: false
                isdigest: true
                iszer: false
                inv_default: 13089428196878425884
                iskeymgr_creator: false
                iskeymgr_owner: false
              }
            ]
            desc: Software managed platform owner slot 0 partition.
            iskeymgr_creator: false
            iskeymgr_owner: false
            ignore_read_lock_in_rma: false
            size: 328
            offset: 3760
          }
          {
            name: PLAT_OWNER_AUTH_SLOT1
            variant: Unbuffered
            absorb: false
            secret: false
            sw_digest: true
            hw_digest: false
            write_lock: Digest
            read_lock: CSR
            key_sel: NoKey
            integrity: true
            bkout_type: false
            zeroizable: false
            items:
            [
              {
                name: PLAT_OWNER_AUTH_SLOT1_KEYMANIFEST_KEY
                size: 160
                desc:
                  '''
                  Pub Key used to verify the ROT OWNER KEY MANIFEST.
                  KM is used to provisioning additional keys in (external) flash
                  160B = Custom Cert --> {PubKey:48, Signature:48, Device ID:32, metadata:16}
                  It is expected to be provisioned at Chip Probe stage when LC = TEST
                  i.e. provisioning protected under proper lifecycle logistics / secure supplychain management
                  '''
                isdigest: false
                iszer: false
                ismubi: false
                iskeymgr_creator: false
                iskeymgr_owner: false
                inv_default: 0
                offset: 4088
              }
              {
                name: PLAT_OWNER_AUTH_SLOT1_UNLOCK4XFER_KEY
                size: 160
                desc:
                  '''
                  Pub Key used to verify the ROT OWNER KEY MANIFEST.
                  Used to authenticate the Unlock Ownership payload. Key Type: ECC NIST-P384 Curve.
                  160B = Custom Cert --> {PubKey:48, Signature:48, Device ID:32, metadata:16}
                  Can be made part bound i.e. unique per part key cert
                  i.e. provisioning protected under proper lifecycle logistics / secure supplychain management
                  '''
                isdigest: false
                iszer: false
                ismubi: false
                iskeymgr_creator: false
                iskeymgr_owner: false
                inv_default: 0
                offset: 4248
              }
              {
                name: PLAT_OWNER_AUTH_SLOT1_DIGEST
                size: 8
                offset: 4408
                ismubi: false
                isdigest: true
                iszer: false
                inv_default: 9966431396093675977
                iskeymgr_creator: false
                iskeymgr_owner: false
              }
            ]
            desc: Software managed platform owner slot 1 partition.
            iskeymgr_creator: false
            iskeymgr_owner: false
            ignore_read_lock_in_rma: false
            size: 328
            offset: 4088
          }
          {
            name: PLAT_OWNER_AUTH_SLOT2
            variant: Unbuffered
            absorb: false
            secret: false
            sw_digest: true
            hw_digest: false
            write_lock: Digest
            read_lock: CSR
            key_sel: NoKey
            integrity: true
            bkout_type: false
            zeroizable: false
            items:
            [
              {
                name: PLAT_OWNER_AUTH_SLOT2_KEYMANIFEST_KEY
                size: 160
                desc:
                  '''
                  Pub Key used to verify the ROT OWNER KEY MANIFEST.
                  KM is used to provisioning additional keys in (external) flash
                  160B = Custom Cert --> {PubKey:48, Signature:48, Device ID:32, metadata:16}
                  It is expected to be provisioned at Chip Probe stage when LC = TEST
                  i.e. provisioning protected under proper lifecycle logistics / secure supplychain management
                  '''
                isdigest: false
                iszer: false
                ismubi: false
                iskeymgr_creator: false
                iskeymgr_owner: false
                inv_default: 0
                offset: 4416
              }
              {
                name: PLAT_OWNER_AUTH_SLOT2_UNLOCK4XFER_KEY
                size: 160
                desc:
                  '''
                  Pub Key used to verify the ROT OWNER KEY MANIFEST.
                  Used to authenticate the Unlock Ownership payload. Key Type: ECC NIST-P384 Curve.
                  160B = Custom Cert --> {PubKey:48, Signature:48, Device ID:32, metadata:16}
                  Can be made part bound i.e. unique per part key cert
                  i.e. provisioning protected under proper lifecycle logistics / secure supplychain management
                  '''
                isdigest: false
                iszer: false
                ismubi: false
                iskeymgr_creator: false
                iskeymgr_owner: false
                inv_default: 0
                offset: 4576
              }
              {
                name: PLAT_OWNER_AUTH_SLOT2_DIGEST
                size: 8
                offset: 4736
                ismubi: false
                isdigest: true
                iszer: false
                inv_default: 16981414814768445627
                iskeymgr_creator: false
                iskeymgr_owner: false
              }
            ]
            desc: Software managed platform owner slot 2 partition.
            iskeymgr_creator: false
            iskeymgr_owner: false
            ignore_read_lock_in_rma: false
            size: 328
            offset: 4416
          }
          {
            name: PLAT_OWNER_AUTH_SLOT3
            variant: Unbuffered
            absorb: false
            secret: false
            sw_digest: true
            hw_digest: false
            write_lock: Digest
            read_lock: CSR
            key_sel: NoKey
            integrity: true
            bkout_type: false
            zeroizable: false
            items:
            [
              {
                name: PLAT_OWNER_AUTH_SLOT3_KEYMANIFEST_KEY
                size: 160
                desc:
                  '''
                  Pub Key used to verify the ROT OWNER KEY MANIFEST.
                  KM is used to provisioning additional keys in (external) flash
                  160B = Custom Cert --> {PubKey:48, Signature:48, Device ID:32, metadata:16}
                  It is expected to be provisioned at Chip Probe stage when LC = TEST
                  i.e. provisioning protected under proper lifecycle logistics / secure supplychain management
                  '''
                isdigest: false
                iszer: false
                ismubi: false
                iskeymgr_creator: false
                iskeymgr_owner: false
                inv_default: 0
                offset: 4744
              }
              {
                name: PLAT_OWNER_AUTH_SLOT3_UNLOCK4XFER_KEY
                size: 160
                desc:
                  '''
                  Pub Key used to verify the ROT OWNER KEY MANIFEST.
                  Used to authenticate the Unlock Ownership payload. Key Type: ECC NIST-P384 Curve.
                  160B = Custom Cert --> {PubKey:48, Signature:48, Device ID:32, metadata:16}
                  Can be made part bound i.e. unique per part key cert
                  i.e. provisioning protected under proper lifecycle logistics / secure supplychain management
                  '''
                isdigest: false
                iszer: false
                ismubi: false
                iskeymgr_creator: false
                iskeymgr_owner: false
                inv_default: 0
                offset: 4904
              }
              {
                name: PLAT_OWNER_AUTH_SLOT3_DIGEST
                size: 8
                offset: 5064
                ismubi: false
                isdigest: true
                iszer: false
                inv_default: 2932316366930412108
                iskeymgr_creator: false
                iskeymgr_owner: false
              }
            ]
            desc: Software managed platform owner slot 3 partition.
            iskeymgr_creator: false
            iskeymgr_owner: false
            ignore_read_lock_in_rma: false
            size: 328
            offset: 4744
          }
          {
            name: EXT_NVM
            variant: Unbuffered
            absorb: false
            secret: false
            sw_digest: false
            hw_digest: false
            write_lock: None
            read_lock: CSR
            key_sel: NoKey
            integrity: false
            bkout_type: false
            zeroizable: false
            items:
            [
              {
                name: EXT_NVM_ANTIREPLAY_FRESHNESS_CNT
                size: 1024
                desc:
                  '''
                  Fully SW managed partition
                  1 bit (double bit allocated for redundancy - i.e. 2 physical bits for every logical bit) per day
                  assuming 10 year product lifecycle, allocating 8192 bits of freshness protection.
                  Implemented as thermometer encoding. Redundant bit programming & logical OR-ing managed by
                  software. Cannot be ECC protected since different bits in a fuse row are programmed at different times.
                  '''
                isdigest: false
                iszer: false
                ismubi: false
                iskeymgr_creator: false
                iskeymgr_owner: false
                inv_default: 0
                offset: 5072
              }
            ]
            desc: Anti-replay protection Strike Counters partition.
            iskeymgr_creator: false
            iskeymgr_owner: false
            ignore_read_lock_in_rma: false
            size: 1024
            offset: 5072
          }
          {
            name: ROM_PATCH
            variant: Unbuffered
            absorb: true
            secret: false
            sw_digest: true
            hw_digest: false
            write_lock: Digest
            read_lock: CSR
            key_sel: NoKey
            integrity: true
            bkout_type: false
            zeroizable: false
            items:
            [
              {
                name: ROM_PATCH_DATA
                size: 9192
                desc:
                  '''
                  Fully SW managed partition
                  ROM patch section
                  signed patch(es)
                  Each patch Contains header, signature, patch match/redirect configuration and patch code
                  Please refer to the ROM boot & patching specification for Integrated OT for more details
                  '''
                isdigest: false
                iszer: false
                ismubi: false
                iskeymgr_creator: false
                iskeymgr_owner: false
                inv_default: 0
                offset: 6096
              }
              {
                name: ROM_PATCH_DIGEST
                size: 8
                offset: 15944
                ismubi: false
                isdigest: true
                iszer: false
                inv_default: 14592557388175589354
                iskeymgr_creator: false
                iskeymgr_owner: false
              }
            ]
            desc: ROM Patch Code section. May contain multiple signed ROM2 patches.
            iskeymgr_creator: false
            iskeymgr_owner: false
            ignore_read_lock_in_rma: false
            size: 9856
            offset: 6096
          }
          {
            name: HW_CFG0
            variant: Buffered
            secret: false
            sw_digest: false
            hw_digest: true
            write_lock: Digest
            read_lock: None
            key_sel: NoKey
            integrity: true
            bkout_type: true
            zeroizable: false
            skip_sw_header: true
            items:
            [
              {
                name: DEVICE_ID
                size: 32
                inv_default: 40117173308102545085356168480633505499540504862520500713288653871548071919464
                isdigest: false
                iszer: false
                ismubi: false
                iskeymgr_creator: false
                iskeymgr_owner: false
                offset: 15952
              }
              {
                name: MANUF_STATE
                size: 32
                inv_default: 104735823630885006896435419055152518946049592294862500793111622154345667968901
                isdigest: false
                iszer: false
                ismubi: false
                iskeymgr_creator: false
                iskeymgr_owner: false
                offset: 15984
              }
              {
                name: HW_CFG0_DIGEST
                size: 8
                offset: 16016
                ismubi: false
                isdigest: true
                iszer: false
                inv_default: 8050338520295093693
                iskeymgr_creator: false
                iskeymgr_owner: false
              }
            ]
            desc:
              '''
              Hardware configuration 0 partition.
              This contains
              - DEVICE_ID: Unique device identifier.
              - MANUF_STATE: Vector for capturing the manufacturing status.
              '''
            absorb: false
            iskeymgr_creator: false
            iskeymgr_owner: false
            ignore_read_lock_in_rma: false
            size: 72
            offset: 15952
          }
          {
            name: HW_CFG1
            variant: Buffered
            secret: false
            sw_digest: false
            hw_digest: true
            write_lock: Digest
            read_lock: None
            key_sel: NoKey
            integrity: true
            bkout_type: true
            zeroizable: false
            skip_sw_header: true
            items:
            [
              {
                name: SOC_DBG_STATE
                size: 4
                inv_default: 0
                desc:
                  '''
                  Multibit enable value for the SOC debug authorization.
                  Encoding:
                  SOC_DBG_RAW: this value is all-zeroes and will be the NOP state;
                  the LC controller will take precedence.
                  SOC_DBG_PRE_PROD: this is where the ROT will be in PROD state
                  but SOC will be in the pre-production unlock state
                  SOC_DBG_PROD: this is the state where the SOC moves to production,
                  and the challenge-response based authentication protocol is
                  required to unlock SOC debug features
                  '''
                isdigest: false
                iszer: false
                ismubi: false
                iskeymgr_creator: false
                iskeymgr_owner: false
                offset: 16024
              }
              {
                name: EN_CSRNG_SW_APP_READ
                size: 1
                ismubi: true
                inv_default: 105
                desc:
                  '''
                  Enablement of CSRNG software application interface. A
                  kMultiBitBool8True value enables, while all other values
                  disable. Enablement is required to extract output from
                  CSRNG via software.
                  '''
                isdigest: false
                iszer: false
                iskeymgr_creator: false
                iskeymgr_owner: false
                offset: 16028
              }
              {
                name: EN_SRAM_IFETCH
                size: 1
                ismubi: true
                inv_default: 105
                isdigest: false
                iszer: false
                iskeymgr_creator: false
                iskeymgr_owner: false
                offset: 16029
              }
              {
                name: HW_CFG1_DIGEST
                size: 8
                offset: 16032
                ismubi: false
                isdigest: true
                iszer: false
                inv_default: 2245725931179433842
                iskeymgr_creator: false
                iskeymgr_owner: false
              }
            ]
            desc:
              '''
              Hardware configuration 1 partition.
              This contains
              EN_SRAM_IFETCH: Enable / disable execute from SRAM CSR switch.
              SOC_DBG_STATE: Multibit enable value for the SOC debug authorization.
              Note SOC_DBG_STATE will be written twice in a device lifetime. The
              values to be written are engineered in the same way as the LC_CTRL
              state encoding words: the ECC encoding remains valid even after
              writing the second value on top of the first.

              The constants can be found in the lc_ctrl_state_pkg.sv package.

              The programming order has to adhere to:

              SOC_DBG_RAW -> SOC_DBG_PRE_PROD -> SOC_DBG_PROD.
              '''
            absorb: false
            iskeymgr_creator: false
            iskeymgr_owner: false
            ignore_read_lock_in_rma: false
            size: 16
            offset: 16024
          }
          {
            name: SECRET0
            variant: Buffered
            secret: true
            sw_digest: false
            hw_digest: true
            write_lock: Digest
            read_lock: Digest
            ignore_read_lock_in_rma: true
            key_sel: Secret0Key
            integrity: true
            bkout_type: false
            zeroizable: true
            skip_sw_header: true
            items:
            [
              {
                name: TEST_UNLOCK_TOKEN
                inv_default: 42146219275086284332081154515457931983
                size: 16
                isdigest: false
                iszer: false
                ismubi: false
                iskeymgr_creator: false
                iskeymgr_owner: false
                offset: 16040
              }
              {
                name: TEST_EXIT_TOKEN
                inv_default: 241193388044955693821746483131132302114
                size: 16
                isdigest: false
                iszer: false
                ismubi: false
                iskeymgr_creator: false
                iskeymgr_owner: false
                offset: 16056
              }
              {
                name: SECRET0_DIGEST
                size: 8
                offset: 16072
                ismubi: false
                isdigest: true
                iszer: false
                inv_default: 15994060125354592494
                iskeymgr_creator: false
                iskeymgr_owner: false
              }
              {
                name: SECRET0_ZER
                size: 8
                offset: 16080
                ismubi: false
                isdigest: false
                iszer: true
                inv_default: 0
                iskeymgr_creator: false
                iskeymgr_owner: false
              }
            ]
            desc:
              '''
              Secret partition 0.
              This contains TEST lifecycle unlock tokens.
              '''
            absorb: false
            iskeymgr_creator: false
            iskeymgr_owner: false
            size: 48
            offset: 16040
          }
          {
            name: SECRET1
            variant: Buffered
            secret: true
            sw_digest: false
            hw_digest: true
            write_lock: Digest
            read_lock: Digest
            ignore_read_lock_in_rma: true
            key_sel: Secret1Key
            integrity: true
            bkout_type: false
            zeroizable: true
            skip_sw_header: true
            items:
            [
              {
                name: SRAM_DATA_KEY_SEED
                inv_default: 49610584572420053792236730456054518552
                size: 16
                isdigest: false
                iszer: false
                ismubi: false
                iskeymgr_creator: false
                iskeymgr_owner: false
                offset: 16088
              }
              {
                name: SECRET1_DIGEST
                size: 8
                offset: 16104
                ismubi: false
                isdigest: true
                iszer: false
                inv_default: 9694113004490520906
                iskeymgr_creator: false
                iskeymgr_owner: false
              }
              {
                name: SECRET1_ZER
                size: 8
                offset: 16112
                ismubi: false
                isdigest: false
                iszer: true
                inv_default: 0
                iskeymgr_creator: false
                iskeymgr_owner: false
              }
            ]
            desc:
              '''
              Secret partition 1.
              This contains the SRAM scrambling key seed.
              '''
            absorb: false
            iskeymgr_creator: false
            iskeymgr_owner: false
            size: 32
            offset: 16088
          }
          {
            name: SECRET2
            variant: Buffered
            secret: true
            sw_digest: false
            hw_digest: true
            write_lock: Digest
            read_lock: Digest
            ignore_read_lock_in_rma: true
            key_sel: Secret2Key
            integrity: true
            bkout_type: false
            zeroizable: true
            skip_sw_header: true
            items:
            [
              {
                name: RMA_TOKEN
                inv_default: 318948098383762964490193881142352172697
                size: 16
                isdigest: false
                iszer: false
                ismubi: false
                iskeymgr_creator: false
                iskeymgr_owner: false
                offset: 16120
              }
              {
                name: CREATOR_ROOT_KEY_SHARE0
                inv_default: 34629914360704372211018394036838819133727768471239971144446686782216090585462
                size: 32
                iskeymgr_creator: true
                isdigest: false
                iszer: false
                ismubi: false
                iskeymgr_owner: false
                offset: 16136
              }
              {
                name: CREATOR_ROOT_KEY_SHARE1
                inv_default: 1304928998077618167994330237584170289335028615580548538480488972898025704836
                size: 32
                iskeymgr_creator: true
                isdigest: false
                iszer: false
                ismubi: false
                iskeymgr_owner: false
                offset: 16168
              }
              {
                name: CREATOR_SEED
                inv_default: 17833865895625802678504757898438306129490488436729400947978243968268591742052
                size: 32
                iskeymgr_creator: true
                isdigest: false
                iszer: false
                ismubi: false
                iskeymgr_owner: false
                offset: 16200
              }
              {
                name: SECRET2_DIGEST
                size: 8
                offset: 16232
                ismubi: false
                isdigest: true
                iszer: false
                inv_default: 6520999107440904866
                iskeymgr_creator: false
                iskeymgr_owner: false
              }
              {
                name: SECRET2_ZER
                size: 8
                offset: 16240
                ismubi: false
                isdigest: false
                iszer: true
                inv_default: 0
                iskeymgr_creator: false
                iskeymgr_owner: false
              }
            ]
            desc:
              '''
              Secret partition 2.
              This contains RMA unlock token, creator root key, and creator seed.
              '''
            absorb: false
            iskeymgr_creator: true
            iskeymgr_owner: false
            size: 128
            offset: 16120
          }
          {
            name: SECRET3
            variant: Buffered
            secret: true
            sw_digest: false
            hw_digest: true
            write_lock: Digest
            read_lock: Digest
            key_sel: Secret3Key
            integrity: true
            bkout_type: false
            zeroizable: true
            skip_sw_header: true
            items:
            [
              {
                name: OWNER_SEED
                inv_default: 70686486377297932620694155829978992075095653265301635643322899792586608109306
                size: 32
                iskeymgr_owner: true
                isdigest: false
                iszer: false
                ismubi: false
                iskeymgr_creator: false
                offset: 16248
              }
              {
                name: SECRET3_DIGEST
                size: 8
                offset: 16280
                ismubi: false
                isdigest: true
                iszer: false
                inv_default: 13418438502867544032
                iskeymgr_creator: false
                iskeymgr_owner: false
              }
              {
                name: SECRET3_ZER
                size: 8
                offset: 16288
                ismubi: false
                isdigest: false
                iszer: true
                inv_default: 0
                iskeymgr_creator: false
                iskeymgr_owner: false
              }
            ]
            desc:
              '''
              Secret partition 3.
              This contains the owner seed.
              '''
            absorb: false
            iskeymgr_creator: false
            iskeymgr_owner: true
            ignore_read_lock_in_rma: false
            size: 48
            offset: 16248
          }
          {
            name: LIFE_CYCLE
            variant: LifeCycle
            secret: false
            sw_digest: false
            hw_digest: false
            write_lock: None
            read_lock: None
            key_sel: NoKey
            integrity: true
            bkout_type: false
            skip_sw_header: true
            items:
            [
              {
                name: LC_TRANSITION_CNT
                inv_default: 14973992796729436808066378999705846639531905052544376352002892737561959261552710366946253675634166805643724298065935
                size: 48
                isdigest: false
                iszer: false
                ismubi: false
                iskeymgr_creator: false
                iskeymgr_owner: false
                offset: 16296
              }
              {
                name: LC_STATE
                inv_default: 1740163610035578858103898302773429044443128827890610586479008287934284440493394280935669489663884
                size: 40
                isdigest: false
                iszer: false
                ismubi: false
                iskeymgr_creator: false
                iskeymgr_owner: false
                offset: 16344
              }
            ]
            desc:
              '''
              Lifecycle partition.
              This contains lifecycle transition count and state. This partition
              cannot be locked since the life cycle state needs to advance to RMA
              in-field. Note that while this partition is not marked secret, it
              is not readable nor writeable via the DAI. Only the LC controller
              can access this partition, and even via the LC controller it is not
              possible to read the raw manufacturing life cycle state in encoded
              form, since that encoding is considered a netlist secret. The LC
              controller only exposes a decoded version of this state.
              '''
            absorb: false
            iskeymgr_creator: false
            iskeymgr_owner: false
            zeroizable: false
            ignore_read_lock_in_rma: false
            size: 88
            offset: 16296
          }
        ]
      }
    }
    {
      name: lc_ctrl
      type: lc_ctrl
      base_addrs:
      {
        regs:
        {
          hart: 0x30150000
        }
        dmi:
        {
          soc_dbg: 0x3000
        }
      }
      memory: {}
      param_list:
      [
        {
          name: RndCnstLcKeymgrDivInvalid
          desc: Diversification value used for all invalid life cycle states.
          type: lc_ctrl_pkg::lc_keymgr_div_t
          randcount: 128
          randtype: data
          name_top: RndCnstLcCtrlLcKeymgrDivInvalid
          default: 0x27af6004db2850037a5dd4609c57f5f
          randwidth: 128
        }
        {
          name: RndCnstLcKeymgrDivTestUnlocked
          desc: Diversification value used for the TEST_UNLOCKED* life cycle states.
          type: lc_ctrl_pkg::lc_keymgr_div_t
          randcount: 128
          randtype: data
          name_top: RndCnstLcCtrlLcKeymgrDivTestUnlocked
          default: 0xcdbe03717cac554e43806e74ae0341a4
          randwidth: 128
        }
        {
          name: RndCnstLcKeymgrDivDev
          desc: Diversification value used for the DEV life cycle state.
          type: lc_ctrl_pkg::lc_keymgr_div_t
          randcount: 128
          randtype: data
          name_top: RndCnstLcCtrlLcKeymgrDivDev
          default: 0xe42fa9091a42185555960bb2129844d6
          randwidth: 128
        }
        {
          name: RndCnstLcKeymgrDivProduction
          desc: Diversification value used for the PROD/PROD_END life cycle states.
          type: lc_ctrl_pkg::lc_keymgr_div_t
          randcount: 128
          randtype: data
          name_top: RndCnstLcCtrlLcKeymgrDivProduction
          default: 0x433fdaf01dbd728448e76202bb67b66b
          randwidth: 128
        }
        {
          name: RndCnstLcKeymgrDivRma
          desc: Diversification value used for the RMA life cycle state.
          type: lc_ctrl_pkg::lc_keymgr_div_t
          randcount: 128
          randtype: data
          name_top: RndCnstLcCtrlLcKeymgrDivRma
          default: 0xe08307b7e7c0aa9010a8d80aad006409
          randwidth: 128
        }
        {
          name: RndCnstInvalidTokens
          desc: Compile-time random bits used for invalid tokens in the token mux
          type: lc_ctrl_pkg::lc_token_mux_t
          randcount: 1024
          randtype: data
          name_top: RndCnstLcCtrlInvalidTokens
          default: 0xf9c78797720f7eec7473e96fdb885bf8187957949933042dc73f91010fb5136ac37bcadefd6e2d48ca18fd691119991097a5c01c5af19eedebc4ee396e076f9ca45de869e6208c0511e4a008ff9b0afbd938a4fc64b63243e286f90f55031a6f3f5c5df91521ff989f25f884b49f44d62680135a217b743b2fc93ea0047b31b
          randwidth: 1024
        }
      ]
    }
    {
      name: alert_handler
      type: alert_handler
      base_addrs:
      {
        null:
        {
          hart: 0x30160000
        }
      }
      memory: {}
      param_list:
      [
        {
          name: RndCnstLfsrSeed
          desc: Compile-time random bits for initial LFSR seed
          type: alert_handler_pkg::lfsr_seed_t
          randcount: 32
          randtype: data
          name_top: RndCnstAlertHandlerLfsrSeed
          default: 0x4bf0c90f
          randwidth: 32
        }
        {
          name: RndCnstLfsrPerm
          desc: Compile-time random permutation for LFSR output
          type: alert_handler_pkg::lfsr_perm_t
          randcount: 32
          randtype: perm
          name_top: RndCnstAlertHandlerLfsrPerm
          default: 0xd29b3251d28786bb1a2043fbc0b2fb2a7e23d738
          randwidth: 160
        }
      ]
      template_type: alert_handler
    }
    {
      name: sram_ctrl_ret
      type: sram_ctrl
      base_addrs:
      {
        regs:
        {
          hart: 0x30500000
        }
        ram:
        {
          hart: 0x30600000
        }
      }
      memory:
      {
        ram:
        {
          label: ram_ret_aon
          swaccess: rw
          data_intg_passthru: "true"
          exec: True
          byte_write: True
          size: 0x1000
        }
      }
      param_list:
      [
        {
          name: RndCnstSramKey
          desc: Compile-time random reset value for SRAM scrambling key.
          type: otp_ctrl_pkg::sram_key_t
          randcount: 128
          randtype: data
          name_top: RndCnstSramCtrlRetSramKey
          default: 0xe319f05b9901b7368d256fc6fe10ec51
          randwidth: 128
        }
        {
          name: RndCnstSramNonce
          desc: Compile-time random reset value for SRAM scrambling nonce.
          type: otp_ctrl_pkg::sram_nonce_t
          randcount: 128
          randtype: data
          name_top: RndCnstSramCtrlRetSramNonce
          default: 0x4f44793e59b5eec53085ab552ac40cb2
          randwidth: 128
        }
        {
          name: RndCnstLfsrSeed
          desc: Compile-time random bits for initial LFSR seed
          type: sram_ctrl_pkg::lfsr_seed_t
          randcount: 64
          randtype: data
          name_top: RndCnstSramCtrlRetLfsrSeed
          default: 0xc1003ed0fc3b704c
          randwidth: 64
        }
        {
          name: RndCnstLfsrPerm
          desc: Compile-time random permutation for LFSR output
          type: sram_ctrl_pkg::lfsr_perm_t
          randcount: 64
          randtype: perm
          name_top: RndCnstSramCtrlRetLfsrPerm
          default: 0x8456295d5c42d1a5bd910d8939b9abebe463825e7567288806cc3cb9f74ab7fe0d4cc1d2aafccb7287bb527003106dcf
          randwidth: 384
        }
      ]
    }
    {
      name: aes
      type: aes
      base_addrs:
      {
        null:
        {
          hart: 0x21100000
        }
      }
      memory: {}
      param_list:
      [
        {
          name: RndCnstClearingLfsrSeed
          desc: Default seed of the PRNG used for register clearing.
          type: aes_pkg::clearing_lfsr_seed_t
          randcount: 64
          randtype: data
          name_top: RndCnstAesClearingLfsrSeed
          default: 0x2bd4647a8422cf4e
          randwidth: 64
        }
        {
          name: RndCnstClearingLfsrPerm
          desc: Permutation applied to the LFSR of the PRNG used for clearing.
          type: aes_pkg::clearing_lfsr_perm_t
          randcount: 64
          randtype: perm
          name_top: RndCnstAesClearingLfsrPerm
          default: 0xd39cce6dcb2bfeedca6bcf867ba919b588218d0c1336807d7c897554c1ddbf6ed4466a968a70f15f82521320292cf142
          randwidth: 384
        }
        {
          name: RndCnstClearingSharePerm
          desc: Permutation applied to the clearing PRNG output for clearing the second share of registers.
          type: aes_pkg::clearing_lfsr_perm_t
          randcount: 64
          randtype: perm
          name_top: RndCnstAesClearingSharePerm
          default: 0x7033bf90fef9505c26bb21f5f860503632f7231129817bfdea15658ad4a8b1a9c27def0064ad897513136d6ab8cebd18
          randwidth: 384
        }
        {
          name: RndCnstMaskingLfsrSeed
          desc: Default seed of the PRNG used for masking.
          type: aes_pkg::masking_lfsr_seed_t
          randcount: 288
          randtype: data
          name_top: RndCnstAesMaskingLfsrSeed
          default: 0x29fade5b2d8781232bad834cd6d217bb338ccc726fb9979fe548668c6039803ad1482548
          randwidth: 288
        }
        {
          name: RndCnstMaskingLfsrPerm
          desc: Permutation applied to the output of the PRNG used for masking.
          type: aes_pkg::masking_lfsr_perm_t
          randcount: 160
          randtype: perm
          name_top: RndCnstAesMaskingLfsrPerm
          default: 0x9716421729569a7a630d6e3587866876031d9059849f4c4711057d690c741b105d893b7b738f0a784b6d091236212e1f2a853a462b602f8b1c9606432c5f993e835713400e9c6f4f777e9d20248e939b4e27827c0f8a5a808d9832022d7161672519305e665552283d4a53549e0864796a457f581a3962813891500b1e14418c3100330149951504655c344488225b926b3c70185123374826723f4d756c0794
          randwidth: 1280
        }
      ]
    }
    {
      name: kmac
      type: kmac
      base_addrs:
      {
        null:
        {
          hart: 0x21120000
        }
      }
      memory: {}
      param_list:
      [
        {
          name: RndCnstLfsrSeed
          desc: Compile-time random data for PRNG default seed
          type: kmac_pkg::lfsr_seed_t
          randcount: 288
          randtype: data
          name_top: RndCnstKmacLfsrSeed
          default: 0x77d0831159f3250b813449c66dcbb021f7a92cf5c0c6ae053b995562d7fcaf6ddca62003
          randwidth: 288
        }
        {
          name: RndCnstLfsrPerm
          desc: Compile-time random permutation for PRNG output
          type: kmac_pkg::lfsr_perm_t
          randcount: 800
          randtype: perm
          name_top: RndCnstKmacLfsrPerm
          default: 0x796de8e1609e8c92b49e190111a8e50eacabf4797751b2f64f2856eb44c669c0b8c6423555987862328a7b5c344eb104448ea3f1f81155bd8082d0246d27e6595db813e456e7086c17356b464520ad17b50468be57882099e4171d2a83381e1286e069fd82eaa53dc32198e2259b6d82e4a6535f9913e2d38fe70672f7681405c26e18d14bd25e9554ba10de20df3160dfc46ce246763b539abc50145f557e1c32c71b10cd01e779329e62950062e92c0e26840983c8896097459c789182315243318b971363c1d95b5836f8c0a280e75c6c4b8128989686640b6aff0a6a44194e7c4d29ae8c1b415ba9927500f9b29071142154e1a7d0aa1d56a4816094207d13215e664887eb5a416a680436d87183b21693546a38230404d9710a612a56aa706789586acdfcb3d57a5ead6e80208eb43ae692b04091b0d4629898abebe9eba865d4c5c9130f37a573768dbbcc0c4760e73ecb96c1c39efc5126f9c6e11c9a5011990b5b75790e69839c04e447212375a4c529a2c854124be99dc04ad0214e59c641b798f98d069364ee135d064dc15ca308a4b508a2b4cd5c652bf602edb4830ae8d7016646a2e64ee8e138825bc3fb099f626a288dc5ae673299d22544fae181534f2c08c8ac9eec6a5a51a54520a3c56ec5f28d4d4328cad56e05b78cb6b66e2421586149a7a084b0dce270a53b2ab304336cec7aa5677ecafa46e8b92003d9ed4250081dcaad5df7540300227c01713a6c6b7d881da519a9455e42fc77131724dbfaa02a1614a00a8f87544233c4954784d8995dc064488b19056adb1664b7221aa2d1e1f2395a104292eba0a35842c07d93d58e03a25bd5d92f0dab07b256c245fb2077611d8a158d528ef884da5b092c60a0495ab6ec901ee010d45a3592322cd33981f3720a72d38599efa9696c5cfd56ef022937c70fb31c879fe78261871c05e47dfa85e2ec0c680422d4b2dc9f43e6a9d63083d5fd3f4c1f712caa6b9ad1ae3c3ea993f306c7aef0aa113deae6e6458ee880f07f40d9d6be7250513b303110e2215a361061309da29ec9d5de15b770c97e0d5ee06746759a045074d12ec8f79ef87ca836d6cd59149050e82f29b28a053fe9dadb0f91e606f308265ac77969482186c12776d532aea70dd78383052e90c4f028bd69590cc49b5b22324eac4665e99a8098c236bc38c0130e0c7c0aeb25f811e86b8d07b40f56c652b14b39f1d3ab249406e59422a1830e3c6eebede009a9435081859e4660ea5899e8def91e83826d261cc940186550c2c3f92a1740d788614498f9294c98c449110f54ab786e3d7e6748a0f41be487fc7daf5652fe1d5d0d02009f46abb6fcb12e12d2e4b74870b24f0a5f61f5d707a06f2415c233f1b851cc51e3a7a9341e2a6bc7167f9a342d95
          randwidth: 8000
        }
        {
          name: RndCnstBufferLfsrSeed
          desc: Compile-time random data for PRNG buffer default seed
          type: kmac_pkg::buffer_lfsr_seed_t
          randcount: 800
          randtype: data
          name_top: RndCnstKmacBufferLfsrSeed
          default: 0x6d389bd5d0a06e314f7e0efdc7b7970a3ea735116a0c6b28f2300df47ac9287a219e00bb035f64c94def907a59c5b475db2d4ddee65528dfb5418d8791a40518626bff091f1bd0fbae67415fdca0e74227478f3a0d0e78f4f82ae004fb322a9d35fffae3
          randwidth: 800
        }
        {
          name: RndCnstMsgPerm
          desc: Compile-time random permutation for LFSR Message output
          type: kmac_pkg::msg_perm_t
          randcount: 64
          randtype: perm
          name_top: RndCnstKmacMsgPerm
          default: 0x5c5a911182b708e4164e9875cfa2f889d95fed2936e47d0cb80f48fb051537f25c1ab82c9e6681f0f671bed7a88dbc83
          randwidth: 384
        }
      ]
    }
    {
      name: otbn
      type: otbn
      base_addrs:
      {
        null:
        {
          hart: 0x21130000
        }
      }
      memory: {}
      param_list:
      [
        {
          name: RndCnstUrndPrngSeed
          desc: Default seed of the PRNG used for URND.
          type: otbn_pkg::urnd_prng_seed_t
          randcount: 288
          randtype: data
          name_top: RndCnstOtbnUrndPrngSeed
          default: 0xf4e13b0ca88b5a2ea38da2b1b9d78968bbcc29d9a9b33196d98b9ea0dd8511d5894d8150
          randwidth: 288
        }
        {
          name: RndCnstBnMacUrndPerm
          desc: Compile-time random permutation for URND permutation in BN MAC.
          type: otbn_pkg::bn_mac_urnd_perm_t
          randcount: 256
          randtype: perm
          name_top: RndCnstOtbnBnMacUrndPerm
          default: 0x377de63bfc0d2896085ea8c4170093c086fba4482f0258ed7ac7ac6df4bd04e8f6cb5d4311f278fe3d0ca503ef71af310fdef05c6934d0a7add15af52de1d28b1ac3a6bcbef7e0ee76cf2e262244a979522c904afa94cd2a8c8df84bd946d57b6a8924a05be7d4bf1d8eb270ff8f124ece6fc97261ae4184256c472305872b5677650b628ab13950cc4c459be409ecb80e59dd423f8085c67fda57b7f37e1b304fca3e066e38ba9a4955a3955133b981c8918315df66aa01e9073a21f11074635460c5a10ab5c2754d1635d3c1bbab9ea220f9eab073149cd7b37c13d63299db18889798b45329681ce26b9219e31eeb5fd83c9dfd36dcb6679fe52782401f64
          randwidth: 2048
        }
        {
          name: RndCnstMaiUrndPerm
          desc: Compile-time random permutation for URND permutation in MAI.
          type: otbn_pkg::mai_urnd_perm_t
          randcount: 389
          randtype: perm
          name_top: RndCnstOtbnMaiUrndPerm
          default: 0x164703a9a5072d2bd366378259b053132313125568cc327c6799da0b4ba0422538190a4e0da62c0aa0e6aeb01e6a54a59d7a3fb6a800cfd8dd1e8766514fc4b0e170485677759a0d61484858101e7bb4478bf52515465c9bd6602a79544e903836b05be7555bd4cc6a3b1c9daee1c9a662bb855eaaf44ad400f4138c49c54838216596b8a903e945561d8526a618182d7065994660e81192620f41e90942b746e0e2e7e9d17ccb511b0702aff1f4ce640b9748d5c0e474a10c8973da1535e63cd58d77963c46a8f42d2f01496f5bd14504aa4840aaaa178689a6e351f8576dc0cff3e273fa80b20009d0297a6c7252823ca2190e49a34cb0379ec89f0d68a4d88b4c88be4915c162e5596e2b01014b0b81c6340139db2f8445f376844fb160aca2487ae8860d20338b72b4cb115046bca7dd921c206e8d7f7d8750ec984490c4e3b030b03754e1d03f0c4853c5f7e113a641415e084a817b53bde47b9e465011e97d6df4e1930b5cb1db181e1769014e4357304c548e7d30b5d3b56019e0830d1d97562cabc030631682b656c05bb331ec4ba70e830d5bddcafa52ac5c56a4d96990dc6c2547d2355a9ced3c8414132becd45b88de11
          randwidth: 3501
        }
        {
          name: RndCnstOtbnKey
          desc: Compile-time random reset value for IMem/DMem scrambling key.
          type: otp_ctrl_pkg::otbn_key_t
          randcount: 128
          randtype: data
          name_top: RndCnstOtbnOtbnKey
          default: 0x929dbc5a763e47600489cfcbc522dfca
          randwidth: 128
        }
        {
          name: RndCnstOtbnNonce
          desc: Compile-time random reset value for IMem/DMem scrambling nonce.
          type: otp_ctrl_pkg::otbn_nonce_t
          randcount: 64
          randtype: data
          name_top: RndCnstOtbnOtbnNonce
          default: 0x36e37194c1678b18
          randwidth: 64
        }
      ]
    }
    {
      name: keymgr_dpe
      type: keymgr_dpe
      base_addrs:
      {
        null:
        {
          hart: 0x21140000
        }
      }
      memory: {}
      param_list:
      [
        {
          name: RndCnstLfsrSeed
          desc: Compile-time random bits for initial LFSR seed
          type: keymgr_pkg::lfsr_seed_t
          randcount: 64
          randtype: data
          name_top: RndCnstKeymgrDpeLfsrSeed
          default: 0xf7d74a894097d558
          randwidth: 64
        }
        {
          name: RndCnstLfsrPerm
          desc: Compile-time random permutation for LFSR output
          type: keymgr_pkg::lfsr_perm_t
          randcount: 64
          randtype: perm
          name_top: RndCnstKeymgrDpeLfsrPerm
          default: 0x93b5b027d4d9f23b462a211ce8b9f76e6d1022176881a48ea7345f171ac2036e55fec0eaf8dbd81d43f505ebb2325e17
          randwidth: 384
        }
        {
          name: RndCnstRandPerm
          desc: Compile-time random permutation for entropy used in share overriding
          type: keymgr_pkg::rand_perm_t
          randcount: 32
          randtype: perm
          name_top: RndCnstKeymgrDpeRandPerm
          default: 0xa96cce1c3e320775c054efe64069fb4e5ae54712
          randwidth: 160
        }
        {
          name: RndCnstRevisionSeed
          desc: Compile-time random bits for revision seed
          type: keymgr_pkg::seed_t
          randcount: 256
          randtype: data
          name_top: RndCnstKeymgrDpeRevisionSeed
          default: 0x562cf932293be920a81e2ae7731219d5a7a572c783a97a8c8e6d77f77c2baacd
          randwidth: 256
        }
        {
          name: RndCnstSoftOutputSeed
          desc: Compile-time random bits for software generation seed
          type: keymgr_pkg::seed_t
          randcount: 256
          randtype: data
          name_top: RndCnstKeymgrDpeSoftOutputSeed
          default: 0x64c21eca0bd3154b39125e1f6647c96185c1600d8d865abc4ca84a8a2cbea8a3
          randwidth: 256
        }
        {
          name: RndCnstHardOutputSeed
          desc: Compile-time random bits for hardware generation seed
          type: keymgr_pkg::seed_t
          randcount: 256
          randtype: data
          name_top: RndCnstKeymgrDpeHardOutputSeed
          default: 0x9c1e18477da86d062559b1844f92970163307a9b5ec9d644910f3d1ae9bcab1f
          randwidth: 256
        }
        {
          name: RndCnstAesSeed
          desc: Compile-time random bits for generation seed when aes destination selected
          type: keymgr_pkg::seed_t
          randcount: 256
          randtype: data
          name_top: RndCnstKeymgrDpeAesSeed
          default: 0x2422978de2c52cd7461440bb3fd3415345dd0c8d09896ed8422ba33758aa6df5
          randwidth: 256
        }
        {
          name: RndCnstKmacSeed
          desc: Compile-time random bits for generation seed when kmac destination selected
          type: keymgr_pkg::seed_t
          randcount: 256
          randtype: data
          name_top: RndCnstKeymgrDpeKmacSeed
          default: 0x8297565371f253fa96ce0026b1bfd9a27b0fe7f44b5c5e1363b103cd30edf7ad
          randwidth: 256
        }
        {
          name: RndCnstOtbnSeed
          desc: Compile-time random bits for generation seed when otbn destination selected
          type: keymgr_pkg::seed_t
          randcount: 256
          randtype: data
          name_top: RndCnstKeymgrDpeOtbnSeed
          default: 0xb1f56d7667869e1c5ff8a46d0dd621b49056ad9a11ba26e3f24998218a7728b7
          randwidth: 256
        }
        {
          name: RndCnstNoneSeed
          desc: Compile-time random bits for generation seed when no destination selected
          type: keymgr_pkg::seed_t
          randcount: 256
          randtype: data
          name_top: RndCnstKeymgrDpeNoneSeed
          default: 0x1eef72491036c3cf8e06c0b00a00b0726ff1e61224732af917e915bc8df507b0
          randwidth: 256
        }
      ]
    }
    {
      name: csrng
      type: csrng
      base_addrs:
      {
        null:
        {
          hart: 0x21150000
        }
      }
      memory: {}
      param_list:
      [
        {
          name: RndCnstCsKeymgrDivNonProduction
          desc: Compile-time random bits for csrng state group diversification value
          type: csrng_pkg::cs_keymgr_div_t
          randcount: 384
          randtype: data
          name_top: RndCnstCsrngCsKeymgrDivNonProduction
          default: 0x4c248a8727515c7ba339a3d47cbce25fe09b9d814ab6db9ced9c7954983187edea2cb6e681f82eb58734815fc2e02125
          randwidth: 384
        }
        {
          name: RndCnstCsKeymgrDivProduction
          desc: Compile-time random bits for csrng state group diversification value
          type: csrng_pkg::cs_keymgr_div_t
          randcount: 384
          randtype: data
          name_top: RndCnstCsrngCsKeymgrDivProduction
          default: 0xfd2d1d24795f9e18e2a393dc9bc3729c9a1afa28e1ea177c9121ec457ebb48684f91d090461014e7df0b4a87cd5710e
          randwidth: 384
        }
      ]
    }
    {
      name: sram_ctrl_main
      type: sram_ctrl
      base_addrs:
      {
        regs:
        {
          hart: 0x211c0000
        }
        ram:
        {
          hart: 0x10000000
        }
      }
      memory:
      {
        ram:
        {
          label: ram_main
          swaccess: rw
          data_intg_passthru: "true"
          exec: True
          byte_write: True
          size: 0x10000
        }
      }
      param_list:
      [
        {
          name: RndCnstSramKey
          desc: Compile-time random reset value for SRAM scrambling key.
          type: otp_ctrl_pkg::sram_key_t
          randcount: 128
          randtype: data
          name_top: RndCnstSramCtrlMainSramKey
          default: 0xd86c733bad9a3a336ffc69f9c511f04d
          randwidth: 128
        }
        {
          name: RndCnstSramNonce
          desc: Compile-time random reset value for SRAM scrambling nonce.
          type: otp_ctrl_pkg::sram_nonce_t
          randcount: 128
          randtype: data
          name_top: RndCnstSramCtrlMainSramNonce
          default: 0x33490c80c6fd0447e5b5c74e55b46e1
          randwidth: 128
        }
        {
          name: RndCnstLfsrSeed
          desc: Compile-time random bits for initial LFSR seed
          type: sram_ctrl_pkg::lfsr_seed_t
          randcount: 64
          randtype: data
          name_top: RndCnstSramCtrlMainLfsrSeed
          default: 0x2a86f2acff76372
          randwidth: 64
        }
        {
          name: RndCnstLfsrPerm
          desc: Compile-time random permutation for LFSR output
          type: sram_ctrl_pkg::lfsr_perm_t
          randcount: 64
          randtype: perm
          name_top: RndCnstSramCtrlMainLfsrPerm
          default: 0x5fac8c7913a5a09a529e11d66ea52d16ee4afb69812f1ad3fe262cef43daf15d4de247028c60ef65f404c08f60cf701d
          randwidth: 384
        }
      ]
    }
    {
      name: sram_ctrl_mbox
      type: sram_ctrl
      base_addrs:
      {
        regs:
        {
          hart: 0x211d0000
        }
        ram:
        {
          hart: 0x11000000
        }
      }
      memory:
      {
        ram:
        {
          label: ram_mbox
          swaccess: rw
          data_intg_passthru: "true"
          exec: False
          byte_write: True
          size: 0x1000
        }
      }
      param_list:
      [
        {
          name: RndCnstSramKey
          desc: Compile-time random reset value for SRAM scrambling key.
          type: otp_ctrl_pkg::sram_key_t
          randcount: 128
          randtype: data
          name_top: RndCnstSramCtrlMboxSramKey
          default: 0xa14af0225e497bb7178d82a9daf75787
          randwidth: 128
        }
        {
          name: RndCnstSramNonce
          desc: Compile-time random reset value for SRAM scrambling nonce.
          type: otp_ctrl_pkg::sram_nonce_t
          randcount: 128
          randtype: data
          name_top: RndCnstSramCtrlMboxSramNonce
          default: 0x6d328f08feed181ff4d6f018a8ad6496
          randwidth: 128
        }
        {
          name: RndCnstLfsrSeed
          desc: Compile-time random bits for initial LFSR seed
          type: sram_ctrl_pkg::lfsr_seed_t
          randcount: 64
          randtype: data
          name_top: RndCnstSramCtrlMboxLfsrSeed
          default: 0xe9c6c86748e75e4
          randwidth: 64
        }
        {
          name: RndCnstLfsrPerm
          desc: Compile-time random permutation for LFSR output
          type: sram_ctrl_pkg::lfsr_perm_t
          randcount: 64
          randtype: perm
          name_top: RndCnstSramCtrlMboxLfsrPerm
          default: 0xb30ac873a6b7bb50fe3d8a9f53ce26364be31f349b184a29d208b25cb396f51289167ef9d953197bf06d4c0842750c65
          randwidth: 384
        }
      ]
    }
    {
      name: rom_ctrl0
      type: rom_ctrl
      base_addrs:
      {
        rom:
        {
          hart: 0x00008000
        }
        regs:
        {
          hart: 0x211e0000
        }
      }
      memory:
      {
        rom:
        {
          label: rom0
          swaccess: ro
          data_intg_passthru: True
          exec: True
          byte_write: False
          size: 0x8000
        }
      }
      param_list:
      [
        {
          name: RndCnstScrNonce
          desc: Fixed nonce used for address / data scrambling
          type: bit [63:0]
          randcount: 64
          randtype: data
          name_top: RndCnstRomCtrl0ScrNonce
          default: 0x16ae90edacdf5436
          randwidth: 64
        }
        {
          name: RndCnstScrKey
          desc: Randomised constant used as a scrambling key for ROM data
          type: bit [127:0]
          randcount: 128
          randtype: data
          name_top: RndCnstRomCtrl0ScrKey
          default: 0x3d7cf8f2413dd6c6c741f00a11e4d93f
          randwidth: 128
        }
      ]
    }
    {
      name: rom_ctrl1
      type: rom_ctrl
      base_addrs:
      {
        rom:
        {
          hart: 0x00020000
        }
        regs:
        {
          hart: 0x211e1000
        }
      }
      memory:
      {
        rom:
        {
          label: rom1
          swaccess: ro
          data_intg_passthru: True
          exec: True
          byte_write: False
          size: 0x10000
        }
      }
      param_list:
      [
        {
          name: RndCnstScrNonce
          desc: Fixed nonce used for address / data scrambling
          type: bit [63:0]
          randcount: 64
          randtype: data
          name_top: RndCnstRomCtrl1ScrNonce
          default: 0x671d062d2ed853b1
          randwidth: 64
        }
        {
          name: RndCnstScrKey
          desc: Randomised constant used as a scrambling key for ROM data
          type: bit [127:0]
          randcount: 128
          randtype: data
          name_top: RndCnstRomCtrl1ScrKey
          default: 0x23ab29aff6687af1764ce972e5b8a4b7
          randwidth: 128
        }
      ]
    }
    {
      name: rv_core_ibex
      type: rv_core_ibex
      base_addrs:
      {
        cfg:
        {
          hart: 0x211f0000
        }
      }
      memory: {}
      param_list:
      [
        {
          name: RndCnstLfsrSeed
          desc: Default seed of the PRNG used for random instructions.
          type: ibex_pkg::lfsr_seed_t
          randcount: 32
          randtype: data
          name_top: RndCnstRvCoreIbexLfsrSeed
          default: 0x97ecac3f
          randwidth: 32
        }
        {
          name: RndCnstLfsrPerm
          desc: Permutation applied to the LFSR of the PRNG used for random instructions.
          type: ibex_pkg::lfsr_perm_t
          randcount: 32
          randtype: perm
          name_top: RndCnstRvCoreIbexLfsrPerm
          default: 0xf6882a67b869b677b1438ff9692d10038b7a8533
          randwidth: 160
        }
        {
          name: RndCnstIbexKey
          desc: Default icache scrambling key
          type: logic [ibex_pkg::SCRAMBLE_KEY_W-1:0]
          randcount: 128
          randtype: data
          name_top: RndCnstRvCoreIbexIbexKey
          default: 0x746c841b723bdee1534fd81449dbe40f
          randwidth: 128
        }
        {
          name: RndCnstIbexNonce
          desc: Default icache scrambling nonce
          type: logic [ibex_pkg::SCRAMBLE_NONCE_W-1:0]
          randcount: 64
          randtype: data
          name_top: RndCnstRvCoreIbexIbexNonce
          default: 0x7e54a9a090f074cc
          randwidth: 64
        }
      ]
      template_type: rv_core_ibex
    }
  ]
}
