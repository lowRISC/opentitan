// Copyright lowRISC contributors (OpenTitan project).
// Licensed under the Apache License, Version 2.0, see LICENSE for details.
// SPDX-License-Identifier: Apache-2.0
{
  name: "pinmux_fpv"
  // The requirements of the pinmux FPV testplan (doc/fpv/README.md), one entry each:
  //   name, desc   the requirement ID and its statement
  //   source      where the rule comes from: !!REGISTER.FIELD names a register field
  //               (reggen's form), a Markdown link names a document section or a key
  //   kind        "spec": a specification states the rule; "RTL": none does, and the
  //               rule follows the design's present behaviour or leaves the outcome
  //               to a specification question; a "spec" entry whose source list
  //               ends with "No specification states <part>." takes that one part
  //               from the design's present behaviour
  //   testpoint   its testpoint in pinmux_env_fpv_testplan.hjson
  //   checks      what decides it: "<check name> (<planned assertion>)", the CSR
  //               checker, or a check that waits on a specification question
  //   why         why those checks prove it
  //   milestone   the verification stage of its testpoint: V1, V2 or V2S
  //   priority    the order of work within a stage: "1" before "2"
  //   security    true when a security property depends on it
  //   state       "open" until its checks are proven; with a reason where no check
  //               of this plan decides it
  // The file holds, besides the entries:
  //   written_for   the top the plan was written for and read against
  //   rendered_for  the top of this copy
  //   terms         the words the requirements use, each with its meaning
  //   parameters    the values the top's configuration sets, which the
  //                 requirements name by parameter, with the key that sets each
  //   pad_roles     the roles of the pads the top description assigns, which the
  //                 requirements name by role
  //   groups        the requirements by feature; a group's conditions say when
  //                 its requirements hold and define its own words
  written_for: "earlgrey"
  rendered_for: "darjeeling"
  terms: [
    {
      name: '''`n`'''
      desc: '''MIO peripheral input, from 0 to `NMioPeriphIn` - 1'''
    }
    {
      name: '''`k`'''
      desc: '''MIO peripheral output, from 0 to `NMioPeriphOut` - 1'''
    }
    {
      name: '''`p`'''
      desc: '''MIO pad, from 0 to `NMioPads` - 1'''
    }
    {
      name: '''`d`'''
      desc: '''DIO pad, from 0 to `NDioPads` - 1'''
    }
    {
      name: '''Watched signal'''
      desc: '''The pad input that `MIODIO` and `PADSEL` pick'''
    }
    {
      name: '''Forwarded value'''
      desc: '''The watched signal sampled each `clk_aon_i` cycle, through the filter when `FILTER` is 1'''
    }
    {
      name: '''Asleep, awake'''
      desc: '''A pad is asleep while its sleep status bit is 1, awake while it is 0'''
    }
    {
      name: '''AON'''
      desc: '''The always-on domain: the logic on `clk_aon_i` and `rst_aon_ni`'''
    }
    {
      name: '''Lands'''
      desc: '''A written or sampled value lands in the cycle the register or flop it is meant for takes it'''
    }
    {
      name: '''Hardware write'''
      desc: '''A write to a register field made by the pinmux logic, not by software over the bus'''
    }
    {
      name: '''Allowed pad'''
      desc: '''A pad is allowed for a signal when the signal's pad list names the pad, or when the list is empty. The pad list is the signal's `pads` entry in the top's configuration ([top_darjeeling.hjson](hw/top_darjeeling/data/top_darjeeling.hjson); [top_darjeeling_pinmux.ipconfig.hjson](hw/top_darjeeling/ip_autogen/pinmux/data/top_darjeeling_pinmux.ipconfig.hjson) `mio_periph_ins`; [top_darjeeling_pinmux.ipconfig.hjson](hw/top_darjeeling/ip_autogen/pinmux/data/top_darjeeling_pinmux.ipconfig.hjson) `mio_periph_outs`).'''
    }
  ]
  parameters: [
    {
      name: "NMioPeriphIn"
      desc: '''Number of muxed peripheral inputs'''
      value: 4
    }
    {
      name: "NMioPeriphOut"
      desc: '''Number of muxed peripheral outputs'''
      value: 5
    }
    {
      name: "NMioPads"
      desc: '''Number of muxed pads'''
      value: 12
    }
    {
      name: "NDioPads"
      desc: '''Number of dedicated pads'''
      value: 73
    }
    {
      name: "NWkupDetect"
      desc: '''Number of wakeup detectors'''
      value: 8
    }
    {
      name: "WkupCntWidth"
      desc: '''Width of a wakeup detector's counter, in bits'''
      value: 8
    }
  ]
  pad_roles: [
  ]
  groups: [
    {
      name: '''Input selection'''
      conditions: [
        '''Every row holds in every cycle.'''
        '''An input's pad list limits only the select values that name a pad. The constant selects 0 and 1 act the same on every input, with or without a pad list.'''
      ]
      requirements: [
        {
          name: REQ_IN_01
          desc: '''MIO peripheral input `n` shall read 0 while `MIO_PERIPH_INSEL_n` is 0.'''
          source: [
            '''!!MIO_PERIPH_INSEL.IN'''
          ]
          kind: "spec"
          testpoint: "pad_listen"
          checks: ["reads tie 0 (assert_PadListen_ReadsTie0)"]
          why: '''In every cycle the check compares each MIO peripheral input whose select is 0 with 0.'''
          milestone: "V1"
          priority: "1"
          security: false
          state: "open"
        }
        {
          name: REQ_IN_02
          desc: '''MIO peripheral input `n` shall read 1 while `MIO_PERIPH_INSEL_n` is 1.'''
          source: [
            '''!!MIO_PERIPH_INSEL.IN'''
          ]
          kind: "spec"
          testpoint: "pad_listen"
          checks: ["reads tie 1 (assert_PadListen_ReadsTie1)"]
          why: '''In every cycle the check compares each MIO peripheral input whose select is 1 with 1.'''
          milestone: "V1"
          priority: "1"
          security: false
          state: "open"
        }
        {
          name: REQ_IN_03
          desc: '''MIO peripheral input `n` shall read the input of MIO pad `p`, in the same cycle, while `MIO_PERIPH_INSEL_n` is 2 + `p` and pad `p` is allowed for input `n`. Here `p` runs from 0 to `NMioPads` - 1.'''
          source: [
            '''!!MIO_PERIPH_INSEL.IN'''
            '''[Muxing Matrix](hw/top_darjeeling/ip_autogen/pinmux/doc/theory_of_operation.md#muxing-matrix)'''
            '''[top_darjeeling_pinmux.ipconfig.hjson `n_mio_pads`](hw/top_darjeeling/ip_autogen/pinmux/data/top_darjeeling_pinmux.ipconfig.hjson)'''
            '''[top_darjeeling_pinmux.ipconfig.hjson `mio_periph_ins`](hw/top_darjeeling/ip_autogen/pinmux/data/top_darjeeling_pinmux.ipconfig.hjson)'''
          ]
          kind: "spec"
          testpoint: "pad_listen"
          checks: ["reads selected pad (assert_PadListen_ReadsSelectedPad)"]
          why: '''The check compares each MIO peripheral input with `mio_in_i[p]` in the same cycle while its select is 2 + `p`, for every `p` from 0 to `NMioPads` - 1. For an input with a pad list, the check runs only over the pads that the list allows.'''
          milestone: "V1"
          priority: "1"
          security: false
          state: "open"
        }
        {
          name: REQ_IN_04
          desc: '''MIO peripheral input `n` shall read 0 while `MIO_PERIPH_INSEL_n` is greater than `NMioPads` + 1. These select values name no pad.'''
          source: [
            '''!!MIO_PERIPH_INSEL'''
            '''[top_darjeeling_pinmux.ipconfig.hjson `n_mio_pads`](hw/top_darjeeling/ip_autogen/pinmux/data/top_darjeeling_pinmux.ipconfig.hjson)'''
          ]
          kind: "RTL"
          testpoint: "pad_listen"
          checks: ["select without a pad reads 0 (assert_PadListen_SelectWithoutAPadReads0)"]
          why: '''While the select of a MIO peripheral input is greater than `NMioPads` + 1, the check compares the input with 0. These select values name no pad.'''
          milestone: "V1"
          priority: "1"
          security: false
          state: "open"
        }
        {
          name: REQ_IN_05
          desc: '''DIO peripheral input `d` shall read the input of DIO pad `d`, in the same cycle, at every value of the pinmux registers.'''
          source: [
            '''[MIO and DIO Signal Categories](hw/top_darjeeling/ip_autogen/pinmux/doc/theory_of_operation.md#mio-and-dio-signal-categories)'''
          ]
          kind: "spec"
          testpoint: "pad_listen"
          checks: ["DIO reads its pad (assert_PadListen_DioReadsItsPad)"]
          why: '''The check compares each DIO peripheral input with its own pad's bit of `dio_in_i` in the same cycle, at every value of the registers.'''
          milestone: "V1"
          priority: "1"
          security: false
          state: "open"
        }
        {
          name: REQ_IN_06
          desc: '''After reset and until software writes its select, MIO peripheral input `n` shall read the pad input or the constant 0 or 1 that the top defines as its reset selection. An input with no reset selection defined shall read 0.'''
          source: [
            '''[Pinmux Configuration](hw/top_darjeeling/ip_autogen/pinmux/doc/programmers_guide.md#pinmux-configuration)'''
            '''[MIO and DIO Signal Categories](hw/top_darjeeling/ip_autogen/pinmux/doc/theory_of_operation.md#mio-and-dio-signal-categories)'''
            '''!!MIO_PERIPH_INSEL.IN'''
            '''[top_darjeeling.hjson](hw/top_darjeeling/data/top_darjeeling.hjson)'''
            '''[top_darjeeling_pinmux.ipconfig.hjson `mio_periph_ins`](hw/top_darjeeling/ip_autogen/pinmux/data/top_darjeeling_pinmux.ipconfig.hjson)'''
          ]
          kind: "spec"
          testpoint: "reset_state"
          checks: ["input starts at default (assert_ResetState_InputStartsAtDefault)"]
          why: '''From reset until the input's select is written, the check compares the input with the input's default value in every cycle. For an input with no default, the check compares the input with 0.'''
          milestone: "V2"
          priority: "2"
          security: false
          state: "open"
        }
        {
          name: REQ_IN_07
          desc: '''MIO peripheral input `n` shall read 0 while `MIO_PERIPH_INSEL_n` is 2 + `p` and pad `p` is not allowed for input `n`.'''
          source: [
            '''[Muxing Matrix](hw/top_darjeeling/ip_autogen/pinmux/doc/theory_of_operation.md#muxing-matrix)'''
            '''[Pinmux Configuration](hw/top_darjeeling/ip_autogen/pinmux/doc/programmers_guide.md#pinmux-configuration)'''
            '''!!MIO_PERIPH_INSEL.IN'''
            '''[top_darjeeling_pinmux.ipconfig.hjson `mio_periph_ins`](hw/top_darjeeling/ip_autogen/pinmux/data/top_darjeeling_pinmux.ipconfig.hjson)'''
          ]
          kind: "spec"
          testpoint: "sparse_insel"
          checks: ["unlisted pad reads zero (assert_SparseInsel_UnlistedPadReadsZero)"]
          why: '''While the input select names a pad that the input's pad list does not allow, the check compares the input with 0 in the same cycle.'''
          milestone: "V2"
          priority: "2"
          security: false
          state: "open"
        }
      ]
    }
    {
      name: '''Output selection'''
      conditions: [
        '''Every row holds while the pad is awake.'''
        '''A pad list limits only the select values that name a peripheral output, so the constant select values 0, 1 and 2 behave the same on every pad.'''
      ]
      requirements: [
        {
          name: REQ_OUT_01a
          desc: '''The output of MIO pad `p` shall be 0 while `MIO_OUTSEL_p` is 0.'''
          source: [
            '''!!MIO_OUTSEL.OUT'''
          ]
          kind: "spec"
          testpoint: "pad_output"
          checks: ["tie 0 drives 0 (assert_PadOutput_Tie0Drives0)"]
          why: '''While an awake pad's select is 0, the check compares the pad's output with 0 in every cycle.'''
          milestone: "V1"
          priority: "1"
          security: false
          state: "open"
        }
        {
          name: REQ_OUT_01b
          desc: '''The output enable of MIO pad `p` shall be 1 while `MIO_OUTSEL_p` is 0, so the pad drives 0.'''
          source: [
            '''!!MIO_OUTSEL.OUT'''
          ]
          kind: "spec"
          testpoint: "pad_output"
          checks: ["tie 0 drives 0 (assert_PadOutput_Tie0Drives0)"]
          why: '''While an awake pad's select is 0, the check compares the pad's output enable with 1 in every cycle.'''
          milestone: "V1"
          priority: "1"
          security: false
          state: "open"
        }
        {
          name: REQ_OUT_02a
          desc: '''The output of MIO pad `p` shall be 1 while `MIO_OUTSEL_p` is 1.'''
          source: [
            '''!!MIO_OUTSEL.OUT'''
          ]
          kind: "spec"
          testpoint: "pad_output"
          checks: ["tie 1 drives 1 (assert_PadOutput_Tie1Drives1)"]
          why: '''While an awake pad's select is 1, the check compares the pad's output with 1 in every cycle.'''
          milestone: "V1"
          priority: "1"
          security: false
          state: "open"
        }
        {
          name: REQ_OUT_02b
          desc: '''The output enable of MIO pad `p` shall be 1 while `MIO_OUTSEL_p` is 1, so the pad drives 1.'''
          source: [
            '''!!MIO_OUTSEL.OUT'''
          ]
          kind: "spec"
          testpoint: "pad_output"
          checks: ["tie 1 drives 1 (assert_PadOutput_Tie1Drives1)"]
          why: '''While an awake pad's select is 1, the check compares the pad's output enable with 1 in every cycle.'''
          milestone: "V1"
          priority: "1"
          security: false
          state: "open"
        }
        {
          name: REQ_OUT_03a
          desc: '''The output enable of MIO pad `p` shall be 0 while `MIO_OUTSEL_p` is 2, so the pad is high-Z.'''
          source: [
            '''!!MIO_OUTSEL.OUT'''
          ]
          kind: "spec"
          testpoint: "pad_output"
          checks: ["select 2 is high-Z (assert_PadOutput_Select2IsHighZ)"]
          why: '''While an awake pad's select is 2, the check compares the pad's output enable with 0 in every cycle.'''
          milestone: "V1"
          priority: "1"
          security: false
          state: "open"
        }
        {
          name: REQ_OUT_03b
          desc: '''The output of MIO pad `p` shall be 0 while `MIO_OUTSEL_p` is 2.'''
          source: [
            '''!!MIO_OUTSEL.OUT'''
          ]
          kind: "spec"
          testpoint: "pad_output"
          checks: ["select 2 is high-Z (assert_PadOutput_Select2IsHighZ)"]
          why: '''While an awake pad's select is 2, the check compares the pad's output with 0 in every cycle.'''
          milestone: "V1"
          priority: "1"
          security: false
          state: "open"
        }
        {
          name: REQ_OUT_04a
          desc: '''MIO pad `p` shall carry peripheral output `k`, in the same cycle, while `MIO_OUTSEL_p` is 3 + `k` and pad `p` is allowed for output `k`. Here `k` runs from 0 to `NMioPeriphOut` - 1.'''
          source: [
            '''!!MIO_OUTSEL.OUT'''
            '''[Muxing Matrix](hw/top_darjeeling/ip_autogen/pinmux/doc/theory_of_operation.md#muxing-matrix)'''
            '''[top_darjeeling_pinmux.ipconfig.hjson `n_mio_periph_out`](hw/top_darjeeling/ip_autogen/pinmux/data/top_darjeeling_pinmux.ipconfig.hjson)'''
            '''[top_darjeeling_pinmux.ipconfig.hjson `mio_periph_outs`](hw/top_darjeeling/ip_autogen/pinmux/data/top_darjeeling_pinmux.ipconfig.hjson)'''
          ]
          kind: "spec"
          testpoint: "pad_output"
          checks: ["drives selected output (assert_PadOutput_DrivesSelectedOutput)"]
          why: '''While an awake pad's select is 3 + `k`, the check compares its output with `periph_to_mio_i[k]` in the same cycle, for `k` from 0 to `NMioPeriphOut` - 1. On a top with pad lists, the check skips outputs not allowed for the pad.'''
          milestone: "V1"
          priority: "1"
          security: false
          state: "open"
        }
        {
          name: REQ_OUT_04b
          desc: '''MIO pad `p` shall carry output enable `k`, in the same cycle, while `MIO_OUTSEL_p` is 3 + `k` and pad `p` is allowed for output `k`. Here `k` runs from 0 to `NMioPeriphOut` - 1.'''
          source: [
            '''!!MIO_OUTSEL.OUT'''
            '''[Muxing Matrix](hw/top_darjeeling/ip_autogen/pinmux/doc/theory_of_operation.md#muxing-matrix)'''
            '''[top_darjeeling_pinmux.ipconfig.hjson `n_mio_periph_out`](hw/top_darjeeling/ip_autogen/pinmux/data/top_darjeeling_pinmux.ipconfig.hjson)'''
            '''[top_darjeeling_pinmux.ipconfig.hjson `mio_periph_outs`](hw/top_darjeeling/ip_autogen/pinmux/data/top_darjeeling_pinmux.ipconfig.hjson)'''
          ]
          kind: "spec"
          testpoint: "pad_output"
          checks: ["drives selected output (assert_PadOutput_DrivesSelectedOutput)"]
          why: '''While an awake pad's select is 3 + `k`, the check compares its output enable with `periph_to_mio_oe_i[k]` in the same cycle, for `k` from 0 to `NMioPeriphOut` - 1. On a top with pad lists, the check skips outputs not allowed for the pad.'''
          milestone: "V1"
          priority: "1"
          security: false
          state: "open"
        }
        {
          name: REQ_OUT_05a
          desc: '''The output enable of MIO pad `p` shall be 0 while `MIO_OUTSEL_p` is greater than `NMioPeriphOut` + 2, so the pad is high-Z. These select values name no peripheral output. On this top, `MIO_OUTSEL_p` has no value greater than `NMioPeriphOut` + 2, so this row does not apply.'''
          source: [
            '''!!MIO_OUTSEL'''
            '''[top_darjeeling_pinmux.ipconfig.hjson `n_mio_periph_out`](hw/top_darjeeling/ip_autogen/pinmux/data/top_darjeeling_pinmux.ipconfig.hjson)'''
          ]
          kind: "RTL"
          testpoint: "pad_output"
          checks: ["select without an output is high-Z (assert_PadOutput_SelectWithoutAnOutputIsHighZ)"]
          why: '''While an awake pad's select is greater than `NMioPeriphOut` + 2, the check compares the pad's output enable with 0. These select values name no peripheral output.'''
          milestone: "V1"
          priority: "1"
          security: false
          state: "open"
        }
        {
          name: REQ_OUT_05b
          desc: '''The output of MIO pad `p` shall be 0 while `MIO_OUTSEL_p` is greater than `NMioPeriphOut` + 2. These select values name no peripheral output. On this top, `MIO_OUTSEL_p` has no value greater than `NMioPeriphOut` + 2, so this row does not apply.'''
          source: [
            '''!!MIO_OUTSEL'''
            '''[top_darjeeling_pinmux.ipconfig.hjson `n_mio_periph_out`](hw/top_darjeeling/ip_autogen/pinmux/data/top_darjeeling_pinmux.ipconfig.hjson)'''
          ]
          kind: "RTL"
          testpoint: "pad_output"
          checks: ["select without an output is high-Z (assert_PadOutput_SelectWithoutAnOutputIsHighZ)"]
          why: '''While an awake pad's select is greater than `NMioPeriphOut` + 2, the check compares the pad's output with 0. These select values name no peripheral output.'''
          milestone: "V1"
          priority: "1"
          security: false
          state: "open"
        }
        {
          name: REQ_OUT_06a
          desc: '''DIO pad `d` shall carry its peripheral's output, in the same cycle.'''
          source: [
            '''[MIO and DIO Signal Categories](hw/top_darjeeling/ip_autogen/pinmux/doc/theory_of_operation.md#mio-and-dio-signal-categories)'''
          ]
          kind: "spec"
          testpoint: "pad_output"
          checks: ["DIO drives its peripheral (assert_PadOutput_DioDrivesItsPeripheral)"]
          why: '''The check compares each awake DIO pad's output with `periph_to_dio_i[d]` in the same cycle, for any values that the registers hold.'''
          milestone: "V1"
          priority: "1"
          security: false
          state: "open"
        }
        {
          name: REQ_OUT_06b
          desc: '''DIO pad `d` shall carry its peripheral's output enable, in the same cycle.'''
          source: [
            '''[MIO and DIO Signal Categories](hw/top_darjeeling/ip_autogen/pinmux/doc/theory_of_operation.md#mio-and-dio-signal-categories)'''
          ]
          kind: "spec"
          testpoint: "pad_output"
          checks: ["DIO drives its peripheral (assert_PadOutput_DioDrivesItsPeripheral)"]
          why: '''The check compares each awake DIO pad's output enable with `periph_to_dio_oe_i[d]` in the same cycle, for any values that the registers hold.'''
          milestone: "V1"
          priority: "1"
          security: false
          state: "open"
        }
        {
          name: REQ_OUT_07
          desc: '''After reset and until software writes its select, MIO pad `p` shall carry the peripheral output that the top defines as the pad's reset selection. A pad with no reset selection defined shall be high-Z.'''
          source: [
            '''[MIO and DIO Signal Categories](hw/top_darjeeling/ip_autogen/pinmux/doc/theory_of_operation.md#mio-and-dio-signal-categories)'''
            '''[Pinmux Configuration](hw/top_darjeeling/ip_autogen/pinmux/doc/programmers_guide.md#pinmux-configuration)'''
            '''!!MIO_OUTSEL.OUT'''
            '''[top_darjeeling.hjson](hw/top_darjeeling/data/top_darjeeling.hjson)'''
            '''[top_darjeeling_pinmux.ipconfig.hjson `mio_periph_outs`](hw/top_darjeeling/ip_autogen/pinmux/data/top_darjeeling_pinmux.ipconfig.hjson)'''
          ]
          kind: "spec"
          testpoint: "reset_state"
          checks: ["pad starts at default (assert_ResetState_PadStartsAtDefault)"]
          why: '''From reset until the pad's select is written, the check compares an awake pad with the pad's default drive in every cycle. For a pad that no default names, the check requires output enable 0.'''
          milestone: "V2"
          priority: "2"
          security: false
          state: "open"
        }
        {
          name: REQ_OUT_08
          desc: '''MIO pad `p` shall be high-Z, with output enable 0 and output 0, while `MIO_OUTSEL_p` is 3 + `k` and pad `p` is not allowed for output `k`.'''
          source: [
            '''[Muxing Matrix](hw/top_darjeeling/ip_autogen/pinmux/doc/theory_of_operation.md#muxing-matrix)'''
            '''[Pinmux Configuration](hw/top_darjeeling/ip_autogen/pinmux/doc/programmers_guide.md#pinmux-configuration)'''
            '''!!MIO_OUTSEL.OUT'''
            '''[top_darjeeling_pinmux.ipconfig.hjson `mio_periph_outs`](hw/top_darjeeling/ip_autogen/pinmux/data/top_darjeeling_pinmux.ipconfig.hjson)'''
          ]
          kind: "spec"
          testpoint: "sparse_outsel"
          checks: ["unlisted output disables pad (assert_SparseOutsel_UnlistedOutputDisablesPad)", "disabled pad drives zero (assert_SparseOutsel_DisabledPadDrivesZero)"]
          why: '''While the pad's output select names an output whose pad list does not allow the pad, the checks compare the pad's `oe` and `out` with 0 in the same cycle.'''
          milestone: "V2"
          priority: "2"
          security: false
          state: "open"
        }
      ]
    }
    {
      name: '''Pad attributes'''
      conditions: [
        '''Every row holds in every cycle, whether the pad is asleep or awake.'''
        '''"Written" means a write that the register block accepts while the register's lock is open. The group Register locks gives the rules of a lock.'''
        '''"Reads back" means the value that a read of the register returns.'''
        '''A pad type "keeps" an attribute bit when the pads of that type implement the bit ([Pad Attributes](hw/top_darjeeling/ip_autogen/pinmux/doc/programmers_guide.md#pad-attributes)).'''
        '''A pad type keeps the same bits on every pad of the type, and the bits that it keeps never change. No document lists the bits that each pad type keeps, so the rows fix only that the pads of one type agree.'''
        '''A one-bit field is kept when its bit is kept, and each bit of `slew_rate` and of `drive_strength` is kept or not kept on its own ([Pad Attributes](hw/top_darjeeling/ip_autogen/pinmux/doc/programmers_guide.md#pad-attributes)).'''
      ]
      requirements: [
        {
          name: REQ_ATTR_01a
          desc: '''The `invert` field of the attribute output of MIO pad `p` shall equal the value that the `invert` field of `MIO_PAD_ATTR_p` reads back.'''
          source: [
            '''!!MIO_PAD_ATTR.invert'''
            '''[Type RW HWExt](util/reggen/README.md#type-rw-hwext)'''
            '''[Generic Pad Wrapper](hw/top_darjeeling/ip_autogen/pinmux/doc/theory_of_operation.md#generic-pad-wrapper)'''
          ]
          kind: "spec"
          testpoint: "pad_attr"
          checks: ["pad gets read-back (assert_PadAttr_PadGetsReadBack)"]
          why: '''In every cycle the check compares field `invert` of the pad's `mio_attr_o` with the read-back of `MIO_PAD_ATTR_p`.'''
          milestone: "V2"
          priority: "2"
          security: false
          state: "open"
        }
        {
          name: REQ_ATTR_01b
          desc: '''The `virtual_od_en` field of the attribute output of MIO pad `p` shall equal the value that the `virtual_od_en` field of `MIO_PAD_ATTR_p` reads back.'''
          source: [
            '''!!MIO_PAD_ATTR.virtual_od_en'''
            '''[Type RW HWExt](util/reggen/README.md#type-rw-hwext)'''
            '''[Generic Pad Wrapper](hw/top_darjeeling/ip_autogen/pinmux/doc/theory_of_operation.md#generic-pad-wrapper)'''
          ]
          kind: "spec"
          testpoint: "pad_attr"
          checks: ["pad gets read-back (assert_PadAttr_PadGetsReadBack)"]
          why: '''In every cycle the check compares field `virtual_od_en` of the pad's `mio_attr_o` with the read-back of `MIO_PAD_ATTR_p`.'''
          milestone: "V2"
          priority: "2"
          security: false
          state: "open"
        }
        {
          name: REQ_ATTR_01c
          desc: '''The `pull_en` field of the attribute output of MIO pad `p` shall equal the value that the `pull_en` field of `MIO_PAD_ATTR_p` reads back.'''
          source: [
            '''!!MIO_PAD_ATTR.pull_en'''
            '''[Type RW HWExt](util/reggen/README.md#type-rw-hwext)'''
            '''[Generic Pad Wrapper](hw/top_darjeeling/ip_autogen/pinmux/doc/theory_of_operation.md#generic-pad-wrapper)'''
          ]
          kind: "spec"
          testpoint: "pad_attr"
          checks: ["pad gets read-back (assert_PadAttr_PadGetsReadBack)"]
          why: '''In every cycle the check compares field `pull_en` of the pad's `mio_attr_o` with the read-back of `MIO_PAD_ATTR_p`.'''
          milestone: "V2"
          priority: "2"
          security: false
          state: "open"
        }
        {
          name: REQ_ATTR_01d
          desc: '''The `pull_select` field of the attribute output of MIO pad `p` shall equal the value that the `pull_select` field of `MIO_PAD_ATTR_p` reads back.'''
          source: [
            '''!!MIO_PAD_ATTR.pull_select'''
            '''[Type RW HWExt](util/reggen/README.md#type-rw-hwext)'''
            '''[Generic Pad Wrapper](hw/top_darjeeling/ip_autogen/pinmux/doc/theory_of_operation.md#generic-pad-wrapper)'''
          ]
          kind: "spec"
          testpoint: "pad_attr"
          checks: ["pad gets read-back (assert_PadAttr_PadGetsReadBack)"]
          why: '''In every cycle the check compares field `pull_select` of the pad's `mio_attr_o` with the read-back of `MIO_PAD_ATTR_p`.'''
          milestone: "V2"
          priority: "2"
          security: false
          state: "open"
        }
        {
          name: REQ_ATTR_01e
          desc: '''The `keeper_en` field of the attribute output of MIO pad `p` shall equal the value that the `keeper_en` field of `MIO_PAD_ATTR_p` reads back.'''
          source: [
            '''!!MIO_PAD_ATTR.keeper_en'''
            '''[Type RW HWExt](util/reggen/README.md#type-rw-hwext)'''
            '''[Generic Pad Wrapper](hw/top_darjeeling/ip_autogen/pinmux/doc/theory_of_operation.md#generic-pad-wrapper)'''
          ]
          kind: "spec"
          testpoint: "pad_attr"
          checks: ["pad gets read-back (assert_PadAttr_PadGetsReadBack)"]
          why: '''In every cycle the check compares field `keeper_en` of the pad's `mio_attr_o` with the read-back of `MIO_PAD_ATTR_p`.'''
          milestone: "V2"
          priority: "2"
          security: false
          state: "open"
        }
        {
          name: REQ_ATTR_01f
          desc: '''The `schmitt_en` field of the attribute output of MIO pad `p` shall equal the value that the `schmitt_en` field of `MIO_PAD_ATTR_p` reads back.'''
          source: [
            '''!!MIO_PAD_ATTR.schmitt_en'''
            '''[Type RW HWExt](util/reggen/README.md#type-rw-hwext)'''
            '''[Generic Pad Wrapper](hw/top_darjeeling/ip_autogen/pinmux/doc/theory_of_operation.md#generic-pad-wrapper)'''
          ]
          kind: "spec"
          testpoint: "pad_attr"
          checks: ["pad gets read-back (assert_PadAttr_PadGetsReadBack)"]
          why: '''In every cycle the check compares field `schmitt_en` of the pad's `mio_attr_o` with the read-back of `MIO_PAD_ATTR_p`.'''
          milestone: "V2"
          priority: "2"
          security: false
          state: "open"
        }
        {
          name: REQ_ATTR_01g
          desc: '''The `od_en` field of the attribute output of MIO pad `p` shall equal the value that the `od_en` field of `MIO_PAD_ATTR_p` reads back.'''
          source: [
            '''!!MIO_PAD_ATTR.od_en'''
            '''[Type RW HWExt](util/reggen/README.md#type-rw-hwext)'''
            '''[Generic Pad Wrapper](hw/top_darjeeling/ip_autogen/pinmux/doc/theory_of_operation.md#generic-pad-wrapper)'''
          ]
          kind: "spec"
          testpoint: "pad_attr"
          checks: ["pad gets read-back (assert_PadAttr_PadGetsReadBack)"]
          why: '''In every cycle the check compares field `od_en` of the pad's `mio_attr_o` with the read-back of `MIO_PAD_ATTR_p`.'''
          milestone: "V2"
          priority: "2"
          security: false
          state: "open"
        }
        {
          name: REQ_ATTR_01h
          desc: '''The `input_disable` field of the attribute output of MIO pad `p` shall equal the value that the `input_disable` field of `MIO_PAD_ATTR_p` reads back.'''
          source: [
            '''!!MIO_PAD_ATTR.input_disable'''
            '''[Type RW HWExt](util/reggen/README.md#type-rw-hwext)'''
            '''[Generic Pad Wrapper](hw/top_darjeeling/ip_autogen/pinmux/doc/theory_of_operation.md#generic-pad-wrapper)'''
          ]
          kind: "spec"
          testpoint: "pad_attr"
          checks: ["pad gets read-back (assert_PadAttr_PadGetsReadBack)"]
          why: '''In every cycle the check compares field `input_disable` of the pad's `mio_attr_o` with the read-back of `MIO_PAD_ATTR_p`.'''
          milestone: "V2"
          priority: "2"
          security: false
          state: "open"
        }
        {
          name: REQ_ATTR_01i
          desc: '''The `slew_rate` field of the attribute output of MIO pad `p` shall equal the value that the `slew_rate` field of `MIO_PAD_ATTR_p` reads back.'''
          source: [
            '''!!MIO_PAD_ATTR.slew_rate'''
            '''[Type RW HWExt](util/reggen/README.md#type-rw-hwext)'''
            '''[Generic Pad Wrapper](hw/top_darjeeling/ip_autogen/pinmux/doc/theory_of_operation.md#generic-pad-wrapper)'''
          ]
          kind: "spec"
          testpoint: "pad_attr"
          checks: ["pad gets read-back (assert_PadAttr_PadGetsReadBack)"]
          why: '''In every cycle the check compares both bits of field `slew_rate` of the pad's `mio_attr_o` with the read-back of `MIO_PAD_ATTR_p`.'''
          milestone: "V2"
          priority: "2"
          security: false
          state: "open"
        }
        {
          name: REQ_ATTR_01j
          desc: '''The `drive_strength` field of the attribute output of MIO pad `p` shall equal the value that the `drive_strength` field of `MIO_PAD_ATTR_p` reads back.'''
          source: [
            '''!!MIO_PAD_ATTR.drive_strength'''
            '''[Type RW HWExt](util/reggen/README.md#type-rw-hwext)'''
            '''[Generic Pad Wrapper](hw/top_darjeeling/ip_autogen/pinmux/doc/theory_of_operation.md#generic-pad-wrapper)'''
          ]
          kind: "spec"
          testpoint: "pad_attr"
          checks: ["pad gets read-back (assert_PadAttr_PadGetsReadBack)"]
          why: '''In every cycle the check compares the four bits of field `drive_strength` of the pad's `mio_attr_o` with the read-back of `MIO_PAD_ATTR_p`.'''
          milestone: "V2"
          priority: "2"
          security: false
          state: "open"
        }
        {
          name: REQ_ATTR_02a
          desc: '''The `invert` field of the attribute output of DIO pad `d` shall equal the value that the `invert` field of `DIO_PAD_ATTR_d` reads back.'''
          source: [
            '''!!DIO_PAD_ATTR.invert'''
            '''[Type RW HWExt](util/reggen/README.md#type-rw-hwext)'''
            '''[Generic Pad Wrapper](hw/top_darjeeling/ip_autogen/pinmux/doc/theory_of_operation.md#generic-pad-wrapper)'''
          ]
          kind: "spec"
          testpoint: "pad_attr"
          checks: ["pad gets read-back (assert_PadAttr_PadGetsReadBack)"]
          why: '''In every cycle the check compares field `invert` of the pad's `dio_attr_o` with the read-back of `DIO_PAD_ATTR_d`.'''
          milestone: "V2"
          priority: "2"
          security: false
          state: "open"
        }
        {
          name: REQ_ATTR_02b
          desc: '''The `virtual_od_en` field of the attribute output of DIO pad `d` shall equal the value that the `virtual_od_en` field of `DIO_PAD_ATTR_d` reads back.'''
          source: [
            '''!!DIO_PAD_ATTR.virtual_od_en'''
            '''[Type RW HWExt](util/reggen/README.md#type-rw-hwext)'''
            '''[Generic Pad Wrapper](hw/top_darjeeling/ip_autogen/pinmux/doc/theory_of_operation.md#generic-pad-wrapper)'''
          ]
          kind: "spec"
          testpoint: "pad_attr"
          checks: ["pad gets read-back (assert_PadAttr_PadGetsReadBack)"]
          why: '''In every cycle the check compares field `virtual_od_en` of the pad's `dio_attr_o` with the read-back of `DIO_PAD_ATTR_d`.'''
          milestone: "V2"
          priority: "2"
          security: false
          state: "open"
        }
        {
          name: REQ_ATTR_02c
          desc: '''The `pull_en` field of the attribute output of DIO pad `d` shall equal the value that the `pull_en` field of `DIO_PAD_ATTR_d` reads back.'''
          source: [
            '''!!DIO_PAD_ATTR.pull_en'''
            '''[Type RW HWExt](util/reggen/README.md#type-rw-hwext)'''
            '''[Generic Pad Wrapper](hw/top_darjeeling/ip_autogen/pinmux/doc/theory_of_operation.md#generic-pad-wrapper)'''
          ]
          kind: "spec"
          testpoint: "pad_attr"
          checks: ["pad gets read-back (assert_PadAttr_PadGetsReadBack)"]
          why: '''In every cycle the check compares field `pull_en` of the pad's `dio_attr_o` with the read-back of `DIO_PAD_ATTR_d`.'''
          milestone: "V2"
          priority: "2"
          security: false
          state: "open"
        }
        {
          name: REQ_ATTR_02d
          desc: '''The `pull_select` field of the attribute output of DIO pad `d` shall equal the value that the `pull_select` field of `DIO_PAD_ATTR_d` reads back.'''
          source: [
            '''!!DIO_PAD_ATTR.pull_select'''
            '''[Type RW HWExt](util/reggen/README.md#type-rw-hwext)'''
            '''[Generic Pad Wrapper](hw/top_darjeeling/ip_autogen/pinmux/doc/theory_of_operation.md#generic-pad-wrapper)'''
          ]
          kind: "spec"
          testpoint: "pad_attr"
          checks: ["pad gets read-back (assert_PadAttr_PadGetsReadBack)"]
          why: '''In every cycle the check compares field `pull_select` of the pad's `dio_attr_o` with the read-back of `DIO_PAD_ATTR_d`.'''
          milestone: "V2"
          priority: "2"
          security: false
          state: "open"
        }
        {
          name: REQ_ATTR_02e
          desc: '''The `keeper_en` field of the attribute output of DIO pad `d` shall equal the value that the `keeper_en` field of `DIO_PAD_ATTR_d` reads back.'''
          source: [
            '''!!DIO_PAD_ATTR.keeper_en'''
            '''[Type RW HWExt](util/reggen/README.md#type-rw-hwext)'''
            '''[Generic Pad Wrapper](hw/top_darjeeling/ip_autogen/pinmux/doc/theory_of_operation.md#generic-pad-wrapper)'''
          ]
          kind: "spec"
          testpoint: "pad_attr"
          checks: ["pad gets read-back (assert_PadAttr_PadGetsReadBack)"]
          why: '''In every cycle the check compares field `keeper_en` of the pad's `dio_attr_o` with the read-back of `DIO_PAD_ATTR_d`.'''
          milestone: "V2"
          priority: "2"
          security: false
          state: "open"
        }
        {
          name: REQ_ATTR_02f
          desc: '''The `schmitt_en` field of the attribute output of DIO pad `d` shall equal the value that the `schmitt_en` field of `DIO_PAD_ATTR_d` reads back.'''
          source: [
            '''!!DIO_PAD_ATTR.schmitt_en'''
            '''[Type RW HWExt](util/reggen/README.md#type-rw-hwext)'''
            '''[Generic Pad Wrapper](hw/top_darjeeling/ip_autogen/pinmux/doc/theory_of_operation.md#generic-pad-wrapper)'''
          ]
          kind: "spec"
          testpoint: "pad_attr"
          checks: ["pad gets read-back (assert_PadAttr_PadGetsReadBack)"]
          why: '''In every cycle the check compares field `schmitt_en` of the pad's `dio_attr_o` with the read-back of `DIO_PAD_ATTR_d`.'''
          milestone: "V2"
          priority: "2"
          security: false
          state: "open"
        }
        {
          name: REQ_ATTR_02g
          desc: '''The `od_en` field of the attribute output of DIO pad `d` shall equal the value that the `od_en` field of `DIO_PAD_ATTR_d` reads back.'''
          source: [
            '''!!DIO_PAD_ATTR.od_en'''
            '''[Type RW HWExt](util/reggen/README.md#type-rw-hwext)'''
            '''[Generic Pad Wrapper](hw/top_darjeeling/ip_autogen/pinmux/doc/theory_of_operation.md#generic-pad-wrapper)'''
          ]
          kind: "spec"
          testpoint: "pad_attr"
          checks: ["pad gets read-back (assert_PadAttr_PadGetsReadBack)"]
          why: '''In every cycle the check compares field `od_en` of the pad's `dio_attr_o` with the read-back of `DIO_PAD_ATTR_d`.'''
          milestone: "V2"
          priority: "2"
          security: false
          state: "open"
        }
        {
          name: REQ_ATTR_02h
          desc: '''The `input_disable` field of the attribute output of DIO pad `d` shall equal the value that the `input_disable` field of `DIO_PAD_ATTR_d` reads back.'''
          source: [
            '''!!DIO_PAD_ATTR.input_disable'''
            '''[Type RW HWExt](util/reggen/README.md#type-rw-hwext)'''
            '''[Generic Pad Wrapper](hw/top_darjeeling/ip_autogen/pinmux/doc/theory_of_operation.md#generic-pad-wrapper)'''
          ]
          kind: "spec"
          testpoint: "pad_attr"
          checks: ["pad gets read-back (assert_PadAttr_PadGetsReadBack)"]
          why: '''In every cycle the check compares field `input_disable` of the pad's `dio_attr_o` with the read-back of `DIO_PAD_ATTR_d`.'''
          milestone: "V2"
          priority: "2"
          security: false
          state: "open"
        }
        {
          name: REQ_ATTR_02i
          desc: '''The `slew_rate` field of the attribute output of DIO pad `d` shall equal the value that the `slew_rate` field of `DIO_PAD_ATTR_d` reads back.'''
          source: [
            '''!!DIO_PAD_ATTR.slew_rate'''
            '''[Type RW HWExt](util/reggen/README.md#type-rw-hwext)'''
            '''[Generic Pad Wrapper](hw/top_darjeeling/ip_autogen/pinmux/doc/theory_of_operation.md#generic-pad-wrapper)'''
          ]
          kind: "spec"
          testpoint: "pad_attr"
          checks: ["pad gets read-back (assert_PadAttr_PadGetsReadBack)"]
          why: '''In every cycle the check compares both bits of field `slew_rate` of the pad's `dio_attr_o` with the read-back of `DIO_PAD_ATTR_d`.'''
          milestone: "V2"
          priority: "2"
          security: false
          state: "open"
        }
        {
          name: REQ_ATTR_02j
          desc: '''The `drive_strength` field of the attribute output of DIO pad `d` shall equal the value that the `drive_strength` field of `DIO_PAD_ATTR_d` reads back.'''
          source: [
            '''!!DIO_PAD_ATTR.drive_strength'''
            '''[Type RW HWExt](util/reggen/README.md#type-rw-hwext)'''
            '''[Generic Pad Wrapper](hw/top_darjeeling/ip_autogen/pinmux/doc/theory_of_operation.md#generic-pad-wrapper)'''
          ]
          kind: "spec"
          testpoint: "pad_attr"
          checks: ["pad gets read-back (assert_PadAttr_PadGetsReadBack)"]
          why: '''In every cycle the check compares the four bits of field `drive_strength` of the pad's `dio_attr_o` with the read-back of `DIO_PAD_ATTR_d`.'''
          milestone: "V2"
          priority: "2"
          security: false
          state: "open"
        }
        {
          name: REQ_ATTR_03
          desc: '''The `invert` field of every pad shall read back as written.'''
          source: [
            '''[Generic Pad Wrapper](hw/top_darjeeling/ip_autogen/pinmux/doc/theory_of_operation.md#generic-pad-wrapper)'''
          ]
          kind: "spec"
          testpoint: "pad_attr"
          checks: ["invert reads back (assert_PadAttr_InvertReadsBack)"]
          why: '''On every pad type, the check compares the `invert` bit of the read-back with the `invert` bit of the pad's last attribute write. The check applies in every cycle after the pad's first attribute write.'''
          milestone: "V2"
          priority: "2"
          security: false
          state: "open"
        }
        {
          name: REQ_ATTR_05
          desc: '''The `virtual_od_en` field of a BidirStd pad or a BidirStr pad shall read back as written.'''
          source: [
            '''Earl Grey's [Virtual open drain](hw/top_earlgrey/doc/design/README.md#virtual-open-drain)'''
            '''[top_darjeeling.hjson](hw/top_darjeeling/data/top_darjeeling.hjson)'''
          ]
          kind: "spec"
          testpoint: "pad_attr"
          checks: ["virtual open drain reads back (assert_PadAttr_VirtualOpenDrainReadsBack)"]
          why: '''On every BidirStd pad and every BidirStr pad, the check compares the `virtual_od_en` bit of the read-back with the `virtual_od_en` bit of the pad's last attribute write. The check applies in every cycle after the pad's first attribute write.'''
          milestone: "V2"
          priority: "2"
          security: false
          state: "open"
        }
        {
          name: REQ_ATTR_06
          desc: '''The `od_en` field of every pad shall read back 0.'''
          source: [
            '''Earl Grey's [Virtual open drain](hw/top_earlgrey/doc/design/README.md#virtual-open-drain)'''
            '''[Pad Attributes](hw/top_darjeeling/ip_autogen/pinmux/doc/programmers_guide.md#pad-attributes)'''
            '''[top_darjeeling.hjson](hw/top_darjeeling/data/top_darjeeling.hjson)'''
          ]
          kind: "spec"
          testpoint: "pad_attr"
          checks: ["no open drain (assert_PadAttr_NoOpenDrain)"]
          why: '''On every pad, the check requires the `od_en` bit of the read-back to be 0 in every cycle, for any value that software wrote.'''
          milestone: "V2"
          priority: "2"
          security: false
          state: "open"
        }
        {
          name: REQ_ATTR_07
          desc: '''The `virtual_od_en` field of every pad whose type is neither BidirStd nor BidirStr shall read back 0.'''
          source: [
            '''Earl Grey's [Virtual open drain](hw/top_earlgrey/doc/design/README.md#virtual-open-drain)'''
            '''[Pad Attributes](hw/top_darjeeling/ip_autogen/pinmux/doc/programmers_guide.md#pad-attributes)'''
            '''[top_darjeeling.hjson](hw/top_darjeeling/data/top_darjeeling.hjson)'''
          ]
          kind: "spec"
          testpoint: "pad_attr"
          checks: ["no virtual open drain elsewhere (assert_PadAttr_NoVirtualOpenDrainElsewhere)"]
          why: '''On every pad whose type is neither BidirStd nor BidirStr, the check requires the `virtual_od_en` bit of the read-back to be 0 in every cycle, for any value that software wrote.'''
          milestone: "V2"
          priority: "2"
          security: false
          state: "open"
        }
        {
          name: REQ_ATTR_08c
          desc: '''The `pull_en` field of every pad shall read back as written in each bit that the pad's type keeps.'''
          source: [
            '''!!MIO_PAD_ATTR'''
            '''[Pad Attributes](hw/top_darjeeling/ip_autogen/pinmux/doc/programmers_guide.md#pad-attributes)'''
            '''[top_darjeeling.hjson](hw/top_darjeeling/data/top_darjeeling.hjson)'''
          ]
          kind: "spec"
          testpoint: "pad_attr"
          checks: ["supported bits read back (assert_PadAttr_SupportedBitsReadBack)"]
          why: '''The check requires `pull_en` to read back a written 0 as 0. Once a written 1 in `pull_en` reads back as 1 on one pad, the check requires a written 1 to read back as 1 on every pad of the same type from that cycle on.'''
          milestone: "V2"
          priority: "2"
          security: false
          state: "open"
        }
        {
          name: REQ_ATTR_08d
          desc: '''The `pull_select` field of every pad shall read back as written in each bit that the pad's type keeps.'''
          source: [
            '''!!MIO_PAD_ATTR'''
            '''[Pad Attributes](hw/top_darjeeling/ip_autogen/pinmux/doc/programmers_guide.md#pad-attributes)'''
            '''[top_darjeeling.hjson](hw/top_darjeeling/data/top_darjeeling.hjson)'''
          ]
          kind: "spec"
          testpoint: "pad_attr"
          checks: ["supported bits read back (assert_PadAttr_SupportedBitsReadBack)"]
          why: '''The check requires `pull_select` to read back a written 0 as 0. Once a written 1 in `pull_select` reads back as 1 on one pad, the check requires a written 1 to read back as 1 on every pad of the same type from that cycle on.'''
          milestone: "V2"
          priority: "2"
          security: false
          state: "open"
        }
        {
          name: REQ_ATTR_08e
          desc: '''The `keeper_en` field of every pad shall read back as written in each bit that the pad's type keeps.'''
          source: [
            '''!!MIO_PAD_ATTR'''
            '''[Pad Attributes](hw/top_darjeeling/ip_autogen/pinmux/doc/programmers_guide.md#pad-attributes)'''
            '''[top_darjeeling.hjson](hw/top_darjeeling/data/top_darjeeling.hjson)'''
          ]
          kind: "spec"
          testpoint: "pad_attr"
          checks: ["supported bits read back (assert_PadAttr_SupportedBitsReadBack)"]
          why: '''The check requires `keeper_en` to read back a written 0 as 0. Once a written 1 in `keeper_en` reads back as 1 on one pad, the check requires a written 1 to read back as 1 on every pad of the same type from that cycle on.'''
          milestone: "V2"
          priority: "2"
          security: false
          state: "open"
        }
        {
          name: REQ_ATTR_08f
          desc: '''The `schmitt_en` field of every pad shall read back as written in each bit that the pad's type keeps.'''
          source: [
            '''!!MIO_PAD_ATTR'''
            '''[Pad Attributes](hw/top_darjeeling/ip_autogen/pinmux/doc/programmers_guide.md#pad-attributes)'''
            '''[top_darjeeling.hjson](hw/top_darjeeling/data/top_darjeeling.hjson)'''
          ]
          kind: "spec"
          testpoint: "pad_attr"
          checks: ["supported bits read back (assert_PadAttr_SupportedBitsReadBack)"]
          why: '''The check requires `schmitt_en` to read back a written 0 as 0. Once a written 1 in `schmitt_en` reads back as 1 on one pad, the check requires a written 1 to read back as 1 on every pad of the same type from that cycle on.'''
          milestone: "V2"
          priority: "2"
          security: false
          state: "open"
        }
        {
          name: REQ_ATTR_08g
          desc: '''The `input_disable` field of every pad shall read back as written in each bit that the pad's type keeps.'''
          source: [
            '''!!MIO_PAD_ATTR'''
            '''[Pad Attributes](hw/top_darjeeling/ip_autogen/pinmux/doc/programmers_guide.md#pad-attributes)'''
            '''[top_darjeeling.hjson](hw/top_darjeeling/data/top_darjeeling.hjson)'''
          ]
          kind: "spec"
          testpoint: "pad_attr"
          checks: ["supported bits read back (assert_PadAttr_SupportedBitsReadBack)"]
          why: '''The check requires `input_disable` to read back a written 0 as 0. Once a written 1 in `input_disable` reads back as 1 on one pad, the check requires a written 1 to read back as 1 on every pad of the same type from that cycle on.'''
          milestone: "V2"
          priority: "2"
          security: false
          state: "open"
        }
        {
          name: REQ_ATTR_08h
          desc: '''The `slew_rate` field of every pad shall read back as written in each bit that the pad's type keeps.'''
          source: [
            '''!!MIO_PAD_ATTR'''
            '''[Pad Attributes](hw/top_darjeeling/ip_autogen/pinmux/doc/programmers_guide.md#pad-attributes)'''
            '''[top_darjeeling.hjson](hw/top_darjeeling/data/top_darjeeling.hjson)'''
          ]
          kind: "spec"
          testpoint: "pad_attr"
          checks: ["supported bits read back (assert_PadAttr_SupportedBitsReadBack)"]
          why: '''The check requires each bit of `slew_rate` to read back a written 0 as 0. Once a written 1 in a bit reads back as 1 on one pad, the check requires the same for that bit on every pad of the same type from that cycle on.'''
          milestone: "V2"
          priority: "2"
          security: false
          state: "open"
        }
        {
          name: REQ_ATTR_08i
          desc: '''The `drive_strength` field of every pad shall read back as written in each bit that the pad's type keeps.'''
          source: [
            '''!!MIO_PAD_ATTR'''
            '''[Pad Attributes](hw/top_darjeeling/ip_autogen/pinmux/doc/programmers_guide.md#pad-attributes)'''
            '''[top_darjeeling.hjson](hw/top_darjeeling/data/top_darjeeling.hjson)'''
          ]
          kind: "spec"
          testpoint: "pad_attr"
          checks: ["supported bits read back (assert_PadAttr_SupportedBitsReadBack)"]
          why: '''The check requires each bit of `drive_strength` to read back a written 0 as 0. Once a written 1 in a bit reads back as 1 on one pad, the check requires the same for that bit on every pad of the same type from that cycle on.'''
          milestone: "V2"
          priority: "2"
          security: false
          state: "open"
        }
        {
          name: REQ_ATTR_09c
          desc: '''The `pull_en` field of every pad shall read back 0 in each bit that the pad's type does not keep.'''
          source: [
            '''[Pad Attributes](hw/top_darjeeling/ip_autogen/pinmux/doc/programmers_guide.md#pad-attributes)'''
            '''[top_darjeeling.hjson](hw/top_darjeeling/data/top_darjeeling.hjson)'''
          ]
          kind: "spec"
          testpoint: "pad_attr"
          checks: ["unsupported bits read 0 (assert_PadAttr_UnsupportedBitsRead0)"]
          why: '''The check requires `pull_en` to read back a written 0 as 0. Once a written 1 in `pull_en` reads back as 0 on one pad, the check requires `pull_en` to read 0 on every pad of the same type from that cycle on.'''
          milestone: "V2"
          priority: "2"
          security: false
          state: "open"
        }
        {
          name: REQ_ATTR_09d
          desc: '''The `pull_select` field of every pad shall read back 0 in each bit that the pad's type does not keep.'''
          source: [
            '''[Pad Attributes](hw/top_darjeeling/ip_autogen/pinmux/doc/programmers_guide.md#pad-attributes)'''
            '''[top_darjeeling.hjson](hw/top_darjeeling/data/top_darjeeling.hjson)'''
          ]
          kind: "spec"
          testpoint: "pad_attr"
          checks: ["unsupported bits read 0 (assert_PadAttr_UnsupportedBitsRead0)"]
          why: '''The check requires `pull_select` to read back a written 0 as 0. Once a written 1 in `pull_select` reads back as 0 on one pad, the check requires `pull_select` to read 0 on every pad of the same type from that cycle on.'''
          milestone: "V2"
          priority: "2"
          security: false
          state: "open"
        }
        {
          name: REQ_ATTR_09e
          desc: '''The `keeper_en` field of every pad shall read back 0 in each bit that the pad's type does not keep.'''
          source: [
            '''[Pad Attributes](hw/top_darjeeling/ip_autogen/pinmux/doc/programmers_guide.md#pad-attributes)'''
            '''[top_darjeeling.hjson](hw/top_darjeeling/data/top_darjeeling.hjson)'''
          ]
          kind: "spec"
          testpoint: "pad_attr"
          checks: ["unsupported bits read 0 (assert_PadAttr_UnsupportedBitsRead0)"]
          why: '''The check requires `keeper_en` to read back a written 0 as 0. Once a written 1 in `keeper_en` reads back as 0 on one pad, the check requires `keeper_en` to read 0 on every pad of the same type from that cycle on.'''
          milestone: "V2"
          priority: "2"
          security: false
          state: "open"
        }
        {
          name: REQ_ATTR_09f
          desc: '''The `schmitt_en` field of every pad shall read back 0 in each bit that the pad's type does not keep.'''
          source: [
            '''[Pad Attributes](hw/top_darjeeling/ip_autogen/pinmux/doc/programmers_guide.md#pad-attributes)'''
            '''[top_darjeeling.hjson](hw/top_darjeeling/data/top_darjeeling.hjson)'''
          ]
          kind: "spec"
          testpoint: "pad_attr"
          checks: ["unsupported bits read 0 (assert_PadAttr_UnsupportedBitsRead0)"]
          why: '''The check requires `schmitt_en` to read back a written 0 as 0. Once a written 1 in `schmitt_en` reads back as 0 on one pad, the check requires `schmitt_en` to read 0 on every pad of the same type from that cycle on.'''
          milestone: "V2"
          priority: "2"
          security: false
          state: "open"
        }
        {
          name: REQ_ATTR_09g
          desc: '''The `input_disable` field of every pad shall read back 0 in each bit that the pad's type does not keep.'''
          source: [
            '''[Pad Attributes](hw/top_darjeeling/ip_autogen/pinmux/doc/programmers_guide.md#pad-attributes)'''
            '''[top_darjeeling.hjson](hw/top_darjeeling/data/top_darjeeling.hjson)'''
          ]
          kind: "spec"
          testpoint: "pad_attr"
          checks: ["unsupported bits read 0 (assert_PadAttr_UnsupportedBitsRead0)"]
          why: '''The check requires `input_disable` to read back a written 0 as 0. Once a written 1 in `input_disable` reads back as 0 on one pad, the check requires `input_disable` to read 0 on every pad of the same type from that cycle on.'''
          milestone: "V2"
          priority: "2"
          security: false
          state: "open"
        }
        {
          name: REQ_ATTR_09h
          desc: '''The `slew_rate` field of every pad shall read back 0 in each bit that the pad's type does not keep.'''
          source: [
            '''[Pad Attributes](hw/top_darjeeling/ip_autogen/pinmux/doc/programmers_guide.md#pad-attributes)'''
            '''[top_darjeeling.hjson](hw/top_darjeeling/data/top_darjeeling.hjson)'''
          ]
          kind: "spec"
          testpoint: "pad_attr"
          checks: ["unsupported bits read 0 (assert_PadAttr_UnsupportedBitsRead0)"]
          why: '''The check requires each bit of `slew_rate` to read back a written 0 as 0. Once a written 1 in a bit reads back as 0 on one pad, the check requires that bit to read 0 on every pad of the same type from that cycle on.'''
          milestone: "V2"
          priority: "2"
          security: false
          state: "open"
        }
        {
          name: REQ_ATTR_09i
          desc: '''The `drive_strength` field of every pad shall read back 0 in each bit that the pad's type does not keep.'''
          source: [
            '''[Pad Attributes](hw/top_darjeeling/ip_autogen/pinmux/doc/programmers_guide.md#pad-attributes)'''
            '''[top_darjeeling.hjson](hw/top_darjeeling/data/top_darjeeling.hjson)'''
          ]
          kind: "spec"
          testpoint: "pad_attr"
          checks: ["unsupported bits read 0 (assert_PadAttr_UnsupportedBitsRead0)"]
          why: '''The check requires each bit of `drive_strength` to read back a written 0 as 0. Once a written 1 in a bit reads back as 0 on one pad, the check requires that bit to read 0 on every pad of the same type from that cycle on.'''
          milestone: "V2"
          priority: "2"
          security: false
          state: "open"
        }
        {
          name: REQ_ATTR_10
          desc: '''After reset, each pad's attribute output shall be the reset value of the pad's entry in the top's configuration, and all 0 for a pad whose entry sets no attribute. Fields that the pad's type does not keep shall be 0.'''
          source: [
            '''!!MIO_PAD_ATTR'''
            '''!!DIO_PAD_ATTR'''
            '''[top_darjeeling.hjson](hw/top_darjeeling/data/top_darjeeling.hjson)'''
            '''[top_darjeeling_pinmux.ipconfig.hjson `mio_pad_attr_resvals`](hw/top_darjeeling/ip_autogen/pinmux/data/top_darjeeling_pinmux.ipconfig.hjson)'''
            '''[top_darjeeling_pinmux.ipconfig.hjson `dio_pad_attr_resvals`](hw/top_darjeeling/ip_autogen/pinmux/data/top_darjeeling_pinmux.ipconfig.hjson)'''
          ]
          kind: "spec"
          testpoint: "pad_attr"
          checks: ["reset attributes (assert_PadAttr_ResetAttributes)"]
          why: '''Until the pad's first attribute write after reset, the check compares the pad's attribute output with the attribute reset value that the top's configuration gives the pad. The fields that the pad's type does not keep are 0.'''
          milestone: "V2"
          priority: "2"
          security: false
          state: "open"
        }
      ]
    }
    {
      name: '''Sleep retention'''
      conditions: [
        '''In these rows, a pad is any MIO pad `p` or any DIO pad `d`.'''
        '''A pad's status bit is the pad's bit in `MIO_PAD_SLEEP_STATUS` or in `DIO_PAD_SLEEP_STATUS`.'''
        '''Sleep entry is a rise of `sleep_en_i` from 0 to 1.'''
        '''The rows for sleep modes 0 to 3 hold while the pad's sleep mode has not changed since sleep entry.'''
      ]
      requirements: [
        {
          name: REQ_SLP_01
          desc: '''At sleep entry, the status bit of every pad whose sleep enable is 1 shall become 1. `REQ_SLP_09` states the one exception, in which a software clear of that bit lands in the same cycle.'''
          source: [
            '''!!MIO_PAD_SLEEP_EN.EN'''
            '''[Sleep Features](hw/top_darjeeling/ip_autogen/pinmux/doc/programmers_guide.md#sleep-features)'''
          ]
          kind: "spec"
          testpoint: "pad_sleep"
          checks: ["bit set at entry (assert_PadSleep_BitSetAtEntry)"]
          why: '''At every sleep entry in which the pad's sleep enable is 1 and software does not clear the status bit in that cycle, the check requires the bit to be 1 in the next cycle.'''
          milestone: "V2"
          priority: "2"
          security: false
          state: "open"
        }
        {
          name: REQ_SLP_02
          desc: '''A status bit shall become 1 only at sleep entry, and only if the pad's sleep enable is 1.'''
          source: [
            '''!!MIO_PAD_SLEEP_STATUS.EN'''
            '''[Sleep Features](hw/top_darjeeling/ip_autogen/pinmux/doc/programmers_guide.md#sleep-features)'''
          ]
          kind: "spec"
          testpoint: "pad_sleep"
          checks: ["bit set only at entry (assert_PadSleep_BitSetOnlyAtEntry)"]
          why: '''Whenever a status bit rises from 0 to 1, the check requires the cycle before to be a sleep entry in which the pad's sleep enable is 1.'''
          milestone: "V2"
          priority: "2"
          security: false
          state: "open"
        }
        {
          name: REQ_SLP_03a
          desc: '''While a pad is asleep and its sleep mode is 0, the pad's output shall be 0.'''
          source: [
            '''!!MIO_PAD_SLEEP_MODE.OUT'''
            '''[Sleep Features](hw/top_darjeeling/ip_autogen/pinmux/doc/programmers_guide.md#sleep-features)'''
          ]
          kind: "spec"
          testpoint: "pad_sleep"
          checks: ["tie low in sleep (assert_PadSleep_TieLowInSleep)"]
          why: '''While a pad's status bit is 1 and its sleep mode was 0 at the sleep entry, the check compares the pad's output with 0 in the same cycle.'''
          milestone: "V2"
          priority: "2"
          security: false
          state: "open"
        }
        {
          name: REQ_SLP_03b
          desc: '''While a pad is asleep and its sleep mode is 0, the pad's output enable shall be 1, so the pad drives 0.'''
          source: [
            '''!!MIO_PAD_SLEEP_MODE.OUT'''
            '''[Sleep Features](hw/top_darjeeling/ip_autogen/pinmux/doc/programmers_guide.md#sleep-features)'''
          ]
          kind: "spec"
          testpoint: "pad_sleep"
          checks: ["tie low in sleep (assert_PadSleep_TieLowInSleep)"]
          why: '''While a pad's status bit is 1 and its sleep mode was 0 at the sleep entry, the check compares the pad's output enable with 1.'''
          milestone: "V2"
          priority: "2"
          security: false
          state: "open"
        }
        {
          name: REQ_SLP_04a
          desc: '''While a pad is asleep and its sleep mode is 1, the pad's output shall be 1.'''
          source: [
            '''!!MIO_PAD_SLEEP_MODE.OUT'''
          ]
          kind: "spec"
          testpoint: "pad_sleep"
          checks: ["tie high in sleep (assert_PadSleep_TieHighInSleep)"]
          why: '''While a pad's status bit is 1 and its sleep mode was 1 at the sleep entry, the check compares the pad's output with 1 in the same cycle.'''
          milestone: "V2"
          priority: "2"
          security: false
          state: "open"
        }
        {
          name: REQ_SLP_04b
          desc: '''While a pad is asleep and its sleep mode is 1, the pad's output enable shall be 1, so the pad drives 1.'''
          source: [
            '''!!MIO_PAD_SLEEP_MODE.OUT'''
          ]
          kind: "spec"
          testpoint: "pad_sleep"
          checks: ["tie high in sleep (assert_PadSleep_TieHighInSleep)"]
          why: '''While a pad's status bit is 1 and its sleep mode was 1 at the sleep entry, the check compares the pad's output enable with 1.'''
          milestone: "V2"
          priority: "2"
          security: false
          state: "open"
        }
        {
          name: REQ_SLP_05a
          desc: '''While a pad is asleep and its sleep mode is 2, the pad's output enable shall be 0, so the pad is high-Z.'''
          source: [
            '''!!MIO_PAD_SLEEP_MODE.OUT'''
          ]
          kind: "spec"
          testpoint: "pad_sleep"
          checks: ["high-Z in sleep (assert_PadSleep_HighZInSleep)"]
          why: '''While a pad's status bit is 1 and its sleep mode was 2 at the sleep entry, the check compares the pad's output enable with 0 in the same cycle.'''
          milestone: "V2"
          priority: "2"
          security: false
          state: "open"
        }
        {
          name: REQ_SLP_05b
          desc: '''While a pad is asleep and its sleep mode is 2, the pad's output shall be 0.'''
          source: [
            '''!!MIO_PAD_SLEEP_MODE.OUT'''
          ]
          kind: "spec"
          testpoint: "pad_sleep"
          checks: ["high-Z in sleep (assert_PadSleep_HighZInSleep)"]
          why: '''While a pad's status bit is 1 and its sleep mode was 2 at the sleep entry, the check compares the pad's output with 0.'''
          milestone: "V2"
          priority: "2"
          security: false
          state: "open"
        }
        {
          name: REQ_SLP_06a
          desc: '''While a pad is asleep and its sleep mode is 3, the pad shall keep the output that it drove in the last cycle before its status bit became 1.'''
          source: [
            '''!!MIO_PAD_SLEEP_MODE.OUT'''
            '''[Retention Logic](hw/top_darjeeling/ip_autogen/pinmux/doc/theory_of_operation.md#retention-logic)'''
          ]
          kind: "spec"
          testpoint: "pad_sleep"
          checks: ["keep holds (assert_PadSleep_KeepHolds)"]
          why: '''While a pad's status bit is 1 and its sleep mode was 3 at the sleep entry that set the bit, the check compares the pad's output with its output in that entry cycle.'''
          milestone: "V2"
          priority: "2"
          security: false
          state: "open"
        }
        {
          name: REQ_SLP_06b
          desc: '''While a pad is asleep and its sleep mode is 3, the pad shall keep the output enable that it drove in the last cycle before its status bit became 1.'''
          source: [
            '''!!MIO_PAD_SLEEP_MODE.OUT'''
            '''[Retention Logic](hw/top_darjeeling/ip_autogen/pinmux/doc/theory_of_operation.md#retention-logic)'''
          ]
          kind: "spec"
          testpoint: "pad_sleep"
          checks: ["keep holds (assert_PadSleep_KeepHolds)"]
          why: '''While a pad's status bit is 1 and its sleep mode was 3 at the sleep entry that set the bit, the check compares the pad's output enable with its enable in that entry cycle.'''
          milestone: "V2"
          priority: "2"
          security: false
          state: "open"
        }
        {
          name: REQ_SLP_07
          desc: '''Once a status bit is 1, the bit shall stay 1 until software writes 0 to it. The rule holds at every value of `sleep_en_i` and of the pad's sleep enable, and for every value that the peripheral drives.'''
          source: [
            '''!!MIO_PAD_SLEEP_STATUS.EN'''
            '''[Retention Logic](hw/top_darjeeling/ip_autogen/pinmux/doc/theory_of_operation.md#retention-logic)'''
          ]
          kind: "spec"
          testpoint: "pad_sleep"
          checks: ["bit holds until cleared (assert_PadSleep_BitHoldsUntilCleared)", "clear releases (assert_PadSleep_ClearReleases)"]
          why: '''If software does not clear a status bit at 1 in a cycle, the check _bit holds until cleared_ requires the bit to be 1 in the next cycle. The check _clear releases_ requires the bit to be 0 in the cycle after a clear.'''
          milestone: "V2"
          priority: "2"
          security: false
          state: "open"
        }
        {
          name: REQ_SLP_08
          desc: '''While an MIO pad is awake, the pad shall drive what its output select names. While a DIO pad is awake, the pad shall drive the output and output enable of its own peripheral.'''
          source: [
            '''[Retention Logic](hw/top_darjeeling/ip_autogen/pinmux/doc/theory_of_operation.md#retention-logic)'''
            '''[Sleep Features](hw/top_darjeeling/ip_autogen/pinmux/doc/programmers_guide.md#sleep-features)'''
          ]
          kind: "spec"
          testpoint: "sleep_release"
          checks: ["tie 0 drives 0 (assert_PadOutput_Tie0Drives0)", "tie 1 drives 1 (assert_PadOutput_Tie1Drives1)", "select 2 is high-Z (assert_PadOutput_Select2IsHighZ)", "drives selected output (assert_PadOutput_DrivesSelectedOutput)", "select without an output is high-Z (assert_PadOutput_SelectWithoutAnOutputIsHighZ)", "DIO drives its peripheral (assert_PadOutput_DioDrivesItsPeripheral)"]
          why: '''Each of these checks compares the pad's drive with its selected drive in every cycle in which the pad's status bit is 0.'''
          milestone: "V2"
          priority: "2"
          security: false
          state: "open"
        }
        {
          name: REQ_SLP_09
          desc: '''When sleep entry sets a status bit in the cycle that software writes 0 to that bit, the bit shall end at 0. The software clear has precedence over sleep entry.'''
          source: [
            '''!!MIO_PAD_SLEEP_STATUS'''
            '''[Type RW](util/reggen/README.md#type-rw)'''
            '''[Simultaneous SW and HW access](util/reggen/README.md#simultaneous-sw-and-hw-access)'''
          ]
          kind: "spec"
          testpoint: "pad_sleep"
          checks: ["clear wins (assert_PadSleep_ClearWins)"]
          why: '''When a sleep entry with the pad's sleep enable at 1 falls in the same cycle as a software clear of the status bit, the check requires the bit to be 0 in the next cycle.'''
          milestone: "V2"
          priority: "2"
          security: false
          state: "open"
        }
        {
          name: REQ_SLP_10a
          desc: '''A write to a pad's sleep mode while the pad is asleep shall leave the pad as it is.'''
          source: [
            '''[Retention Logic](hw/top_darjeeling/ip_autogen/pinmux/doc/theory_of_operation.md#retention-logic)'''
            '''[Sleep Features](hw/top_darjeeling/ip_autogen/pinmux/doc/programmers_guide.md#sleep-features)'''
          ]
          kind: "spec"
          testpoint: "pad_sleep"
          checks: ["mode write while held (assert_PadSleep_ModeWriteWhileHeld)"]
          why: '''After software writes the pad's sleep mode while the status bit is 1, the check requires the pad to keep the sleep value of the mode taken at the sleep entry.'''
          milestone: "V2"
          priority: "2"
          security: false
          state: "open"
        }
        {
          name: REQ_SLP_10b
          desc: '''After a write to a pad's sleep mode while the pad is asleep, the new mode shall take effect at the next sleep entry.'''
          source: [
            '''[Retention Logic](hw/top_darjeeling/ip_autogen/pinmux/doc/theory_of_operation.md#retention-logic)'''
            '''[Sleep Features](hw/top_darjeeling/ip_autogen/pinmux/doc/programmers_guide.md#sleep-features)'''
          ]
          kind: "spec"
          testpoint: "pad_sleep"
          checks: ["tie low in sleep (assert_PadSleep_TieLowInSleep)", "tie high in sleep (assert_PadSleep_TieHighInSleep)", "high-Z in sleep (assert_PadSleep_HighZInSleep)", "keep holds (assert_PadSleep_KeepHolds)", "the CSR checker"]
          why: '''Each of the four sleep mode checks uses the sleep mode that the pad had at the sleep entry. The CSR checker checks that the register keeps the written mode.'''
          milestone: "V2"
          priority: "2"
          security: false
          state: "open"
        }
      ]
    }
    {
      name: '''Register locks'''
      conditions: [
        '''A "lock" is one bit of a `*_REGWEN` register. Each lock locks the registers that have the same index. A lock is open while it is 1 and closed while it is 0.'''
        '''The rule that a locked pad's attribute output does not change (`REQ_LOCK_03a`) holds on every pad. The rule for the value that software reads (`REQ_LOCK_03b`) holds on every pad.'''
      ]
      requirements: [
        {
          name: REQ_LOCK_01a
          desc: '''Every lock shall read 1 after reset.'''
          source: [
            '''the register description: the `EN` field of each `*_REGWEN`, for example !!MIO_PAD_ATTR_REGWEN.EN `resval: "1"`, on `clk_i` with `rst_ni` ([pinmux.hjson `clocking`](hw/top_darjeeling/ip_autogen/pinmux/data/pinmux.hjson))'''
            '''[Configuration and Register Definition File Format](util/reggen/README.md#configuration-and-register-definition-file-format)'''
          ]
          kind: "spec"
          testpoint: "register_block"
          checks: ["the CSR checker"]
          why: '''After reset, the CSR checker expects every lock to be 1, and compares the lock's value and each read of it with 1. Bit 31 of `ALERT_TEST` locks the alert test in the same way, and the CSR checker expects it to be 1 after reset too.'''
          milestone: "V2"
          priority: "2"
          security: true
          state: "open"
        }
        {
          name: REQ_LOCK_01b
          desc: '''Once software writes 0 to a lock, the lock shall stay 0 until reset.'''
          source: [
            '''[Configuration and Register Definition File Format](util/reggen/README.md#configuration-and-register-definition-file-format)'''
            '''[Pad Attributes](hw/top_darjeeling/ip_autogen/pinmux/doc/programmers_guide.md#pad-attributes)'''
          ]
          kind: "spec"
          testpoint: "register_block"
          checks: ["the CSR checker"]
          why: '''The CSR checker predicts each lock as an `rw0c` field. In that prediction, an accepted write of 0 clears the lock and nothing sets it. A lock that returns to 1 before a reset fails the comparison.'''
          milestone: "V2"
          priority: "2"
          security: true
          state: "open"
        }
        {
          name: REQ_LOCK_01c
          desc: '''A write of 1 to a lock that is 0 shall not reopen it.'''
          source: [
            '''the register description: each lock `rw0c`'''
            '''[Configuration and Register Definition File Format](util/reggen/README.md#configuration-and-register-definition-file-format)'''
            '''[Pinmux Configuration](hw/top_darjeeling/ip_autogen/pinmux/doc/programmers_guide.md#pinmux-configuration)'''
          ]
          kind: "spec"
          testpoint: "register_block"
          checks: ["the CSR checker"]
          why: '''The CSR checker predicts each lock as an `rw0c` field, so a closed lock stays 0 on a write of 1. A lock that such a write reopens fails the comparison.'''
          milestone: "V2"
          priority: "2"
          security: true
          state: "open"
        }
        {
          name: REQ_LOCK_02
          desc: '''While a lock is 0, a write to a register it locks shall leave that register unchanged.'''
          source: [
            '''!!MIO_PERIPH_INSEL_REGWEN.EN'''
            '''[Configuration and Register Definition File Format](util/reggen/README.md#configuration-and-register-definition-file-format)'''
          ]
          kind: "spec"
          testpoint: "register_block"
          checks: ["locked read-back holds (assert_Regwen_LockedReadBackHolds)", "the CSR checker"]
          why: '''The CSR checker predicts that a register whose lock reads 0 keeps its value over every write. For the attribute registers, the check _locked read-back holds_ requires the read-back to stay unchanged while the lock reads 0.'''
          milestone: "V2"
          priority: "2"
          security: true
          state: "open"
        }
        {
          name: REQ_LOCK_03a
          desc: '''While a pad's attribute lock is 0, the pad's attribute output shall not change.'''
          source: [
            '''!!MIO_PAD_ATTR_REGWEN.EN'''
            '''[Pad Attributes](hw/top_darjeeling/ip_autogen/pinmux/doc/programmers_guide.md#pad-attributes)'''
          ]
          kind: "spec"
          testpoint: "regwen"
          checks: ["locked attribute holds (assert_Regwen_LockedAttributeHolds)"]
          why: '''While the attribute lock of a pad is closed, the check requires the pad's attribute output to keep its value from each cycle to the next. The check covers every pad.'''
          milestone: "V2"
          priority: "2"
          security: true
          state: "open"
        }
        {
          name: REQ_LOCK_03b
          desc: '''While a pad's attribute lock is 0, the value that software reads from the pad's attribute register shall not change.'''
          source: [
            '''!!MIO_PAD_ATTR_REGWEN.EN'''
            '''[Pad Attributes](hw/top_darjeeling/ip_autogen/pinmux/doc/programmers_guide.md#pad-attributes)'''
          ]
          kind: "spec"
          testpoint: "regwen"
          checks: ["locked read-back holds (assert_Regwen_LockedReadBackHolds)"]
          why: '''While the attribute lock of a pad is closed, the check requires the pad's read-back to keep its value from each cycle to the next. The check covers every pad.'''
          milestone: "V2"
          priority: "2"
          security: true
          state: "open"
        }
      ]
    }
    {
      name: '''Register block and bus'''
      conditions: [
        '''A "failed request" is a request whose command integrity code does not match, or whose data integrity code does not match ([Usage of User Bits](hw/ip/tlul/README.md#usage-of-user-bits)). No document says whether the data integrity code of a read is checked, because that code covers the write data ([Usage of User Bits](hw/ip/tlul/README.md#usage-of-user-bits)). These rows follow the design, which checks the data integrity code of every request.'''
        '''The pinmux's alert sender answers a ping of the alert handler with an alert event, which is a full handshake on the alert and acknowledge pairs. The alert handler takes that handshake as the answer to its ping ([Ping Testing](hw/top_darjeeling/ip_autogen/alert_handler/doc/theory_of_operation.md#ping-testing)).'''
        '''The "in-band reset" is the alert handler's re-initialization. During the in-band reset, the alert handler puts a signal integrity error on its ping and acknowledge pairs on purpose ([Employed Solution](hw/top_darjeeling/ip_autogen/alert_handler/doc/theory_of_operation.md#employed-solution)).'''
        '''A request has an "illegal combination of address, size and mask" when its address is not aligned to its size, when its size is greater than 2, or when its mask has a bit set outside the access. A `PutFullData` request also has an illegal combination when the mask bit of a lane inside the access is 0.'''
      ]
      requirements: [
        {
          name: REQ_REG_01a
          desc: '''Every register field shall behave as its access type requires on each software read or write that is answered without an error. This row covers a write only while the field's lock reads 1, or when the field has no lock.'''
          source: [
            '''the register description: each field's `swaccess`, for example !!MIO_PAD_SLEEP_STATUS `swaccess: "rw0c"`'''
            '''[Configuration and Register Definition File Format](util/reggen/README.md#configuration-and-register-definition-file-format)'''
          ]
          kind: "spec"
          testpoint: "register_block"
          checks: ["read-back changes only on a write (assert_PadAttr_ReadBackChangesOnlyOnAWrite)", "the CSR checker"]
          why: '''For the attribute registers, the check _read-back changes only on a write_ allows a read-back to change only in the cycle after an attribute write. The CSR checker predicts each field from its access type.'''
          milestone: "V2"
          priority: "2"
          security: true
          state: "open"
        }
        {
          name: REQ_REG_01b
          desc: '''After reset, every register field shall read the reset value that the register description gives the field.'''
          source: [
            '''the register description: each field's `resval`, for example !!MIO_PAD_SLEEP_STATUS.EN `resval: "0"`'''
            '''[Configuration and Register Definition File Format](util/reggen/README.md#configuration-and-register-definition-file-format)'''
          ]
          kind: "spec"
          testpoint: "register_block"
          checks: ["the CSR checker"]
          why: '''After reset, the CSR checker requires each field to hold its reset value. The check _reset attributes_ covers the reset values of the attribute registers.'''
          milestone: "V2"
          priority: "2"
          security: true
          state: "open"
        }
        {
          name: REQ_BUS_01a
          desc: '''The pinmux shall answer every request with one response, and only one.'''
          source: [
            '''TileLink 1.9.3 p. 39: "Receipt of request messages must result in the eventual receipt of a response message by the requestor."; p. 30: "it is illegal to receive a response without receiving the request."; p. 46: "In TL-UL, every message fits within a single beat"'''
            '''No specification states the limit of one response per request.'''
          ]
          kind: "spec"
          testpoint: "bus"
          checks: ["device rules (assert_Bus_DeviceRules)"]
          why: '''The check uses the device rules of the TL-UL ABVIP on the pinmux's port. These rules match each response to one open request.'''
          milestone: "V2"
          priority: "2"
          security: true
          state: "open"
        }
        {
          name: REQ_BUS_01b
          desc: '''The pinmux shall answer every request with a response that follows the TL-UL rules and carries the source ID of the request.'''
          source: [
            '''[Source ID requirements for device elements](hw/ip/tlul/README.md#source-id-requirements-for-device-elements)'''
          ]
          kind: "spec"
          testpoint: "bus"
          checks: ["device rules (assert_Bus_DeviceRules)"]
          why: '''The check uses the device rules of the TL-UL ABVIP on the pinmux's port. These rules compare the `d_source` of each response with the `a_source` of its request.'''
          milestone: "V2"
          priority: "2"
          security: true
          state: "open"
        }
        {
          name: REQ_BUS_01c
          desc: '''A request shall receive an error response only if it is a failed request, a request that one of `REQ_BUS_10a` to `REQ_BUS_10d` describes, or a request to an address that no register maps.'''
          source: [
            '''[Explicit Error Cases](hw/ip/tlul/README.md#explicit-error-cases)'''
            '''[Error responses](util/reggen/README.md#error-responses)'''
            '''No specification states the error on a read whose only mismatch is in its data integrity code, and the error on an address that is not aligned to the request's size.'''
          ]
          kind: "spec"
          testpoint: "bus"
          checks: ["errors as the register checker predicts", "the CSR checker"]
          why: '''For every request that is not a failed request, the error checks of the CSR checker require `d_error` to be 1 exactly when the request has one of the listed causes.'''
          milestone: "V2"
          priority: "2"
          security: true
          state: "open"
        }
        {
          name: REQ_BUS_02a
          desc: '''Every response shall carry the response integrity code, which is computed over the op code, the size and the error of that response.'''
          source: [
            '''[Usage of User Bits](hw/ip/tlul/README.md#usage-of-user-bits)'''
            '''[pinmux.hjson `countermeasures` BUS.INTEGRITY](hw/top_darjeeling/ip_autogen/pinmux/data/pinmux.hjson)'''
            '''No specification states the encoding of the response integrity code.'''
          ]
          kind: "spec"
          testpoint: "bus"
          checks: ["response codes correct (assert_Bus_ResponseCodesCorrect)"]
          why: '''For each response, the check recomputes the response code from the response's opcode, size and error with the integrity functions of `tlul_pkg`. The check then compares the result with the response code that the pinmux sends.'''
          milestone: "V2"
          priority: "2"
          security: true
          state: "open"
        }
        {
          name: REQ_BUS_02b
          desc: '''Every response shall carry the data integrity code, which is computed over the data of that response.'''
          source: [
            '''[Usage of User Bits](hw/ip/tlul/README.md#usage-of-user-bits)'''
            '''[pinmux.hjson `countermeasures` BUS.INTEGRITY](hw/top_darjeeling/ip_autogen/pinmux/data/pinmux.hjson)'''
            '''No specification states the encoding of the data integrity code.'''
          ]
          kind: "spec"
          testpoint: "bus"
          checks: ["response codes correct (assert_Bus_ResponseCodesCorrect)"]
          why: '''For each response, the check recomputes the data code over the response data with the integrity functions of `tlul_pkg`. The check then compares the result with the data code that the pinmux sends.'''
          milestone: "V2"
          priority: "2"
          security: true
          state: "open"
        }
        {
          name: REQ_BUS_03
          desc: '''A failed request shall receive an error response.'''
          source: [
            '''[Usage of User Bits](hw/ip/tlul/README.md#usage-of-user-bits)'''
            '''[cip_base_vseq](hw/dv/sv/cip_lib/README.md#cip_base_vseq)'''
          ]
          kind: "RTL"
          testpoint: "bus"
          checks: ["failed request errors (assert_Bus_FailedRequestErrors)"]
          why: '''The check requires `d_error` to be 1 on the response to every failed request.'''
          milestone: "V2"
          priority: "2"
          security: true
          state: "open"
        }
        {
          name: REQ_BUS_04
          desc: '''A write that is a failed request shall change no register.'''
          source: [
            '''[Usage of User Bits](hw/ip/tlul/README.md#usage-of-user-bits)'''
          ]
          kind: "RTL"
          testpoint: "bus"
          checks: ["failed write changes nothing (assert_Bus_FailedWriteChangesNothing)"]
          why: '''The check requires every register to keep its value over a failed write. The one exception is an AON field that is still taking an earlier write, which has not landed yet.'''
          milestone: "V2"
          priority: "2"
          security: true
          state: "open"
        }
        {
          name: REQ_BUS_05
          desc: '''Outside the alert handler's in-band reset, a failed request shall raise the fatal alert `fatal_fault`.'''
          source: [
            '''[pinmux.hjson `alert_list` fatal_fault](hw/top_darjeeling/ip_autogen/pinmux/data/pinmux.hjson)'''
            '''[Employed Solution](hw/top_darjeeling/ip_autogen/alert_handler/doc/theory_of_operation.md#employed-solution)'''
            '''No specification states the alert for a read whose only mismatch is in its data integrity code.'''
          ]
          kind: "spec"
          testpoint: "alert"
          checks: ["failed request alerts (assert_Alert_FailedRequestAlerts)"]
          why: '''The check requires an alert event on `alert_tx_o` within 40 cycles of every failed request.'''
          milestone: "V2S"
          priority: "2"
          security: true
          state: "open"
        }
        {
          name: REQ_BUS_06
          desc: '''Outside the alert handler's in-band reset, the pinmux shall send the fatal alert repeatedly from the time it is raised until reset.'''
          source: [
            '''[Alerts per Module](doc/contributing/hw/comportability/README.md#alerts-per-module)'''
            '''[Employed Solution](hw/top_darjeeling/ip_autogen/alert_handler/doc/theory_of_operation.md#employed-solution)'''
          ]
          kind: "spec"
          testpoint: "alert"
          checks: ["fatal alert repeats (assert_Alert_FatalAlertRepeats)"]
          why: '''After a failed request and until reset, the check requires every cycle to be followed by an alert event within 40 cycles.'''
          milestone: "V2S"
          priority: "2"
          security: true
          state: "open"
        }
        {
          name: REQ_BUS_07
          desc: '''While bit 31 of `ALERT_TEST` is 1, a write of 1 to bit 0 of `ALERT_TEST` that is answered without an error shall send one alert event. The rule applies only outside the alert handler's in-band reset.'''
          source: [
            '''The register page says of bit 0: "Write 1 to trigger one alert event of this kind." (!!ALERT_TEST)'''
            '''[Test Alert Register Creation](doc/contributing/hw/comportability/README.md#test-alert-register-creation)'''
            '''[Employed Solution](hw/top_darjeeling/ip_autogen/alert_handler/doc/theory_of_operation.md#employed-solution)'''
          ]
          kind: "spec"
          testpoint: "alert"
          checks: ["test sends an event (assert_Alert_TestSendsAnEvent)", "no alert without a cause (assert_Alert_NoAlertWithoutACause)"]
          why: '''The check _test sends an event_ requires an alert event within 40 cycles of each alert test. In the check _no alert without a cause_, each alert test allows one alert event, so one test gives one event.'''
          milestone: "V2S"
          priority: "2"
          security: true
          state: "open"
        }
        {
          name: REQ_BUS_08
          desc: '''While bit 31 of `ALERT_TEST` is 0, a write to bit 0 of `ALERT_TEST` that is not a failed request shall send no alert. The rule applies only outside the alert handler's in-band reset.'''
          source: [
            '''The register page says of bit 31: "Write 0 to disable alert testing until the next reset." (!!ALERT_TEST)'''
            '''[Employed Solution](hw/top_darjeeling/ip_autogen/alert_handler/doc/theory_of_operation.md#employed-solution)'''
          ]
          kind: "spec"
          testpoint: "alert"
          checks: ["no alert without a cause (assert_Alert_NoAlertWithoutACause)"]
          why: '''The check allows no alert event for a write of bit 0 while bit 31 of `ALERT_TEST` is 0. An alert event that has no other cause then fails the check.'''
          milestone: "V2S"
          priority: "2"
          security: true
          state: "open"
        }
        {
          name: REQ_BUS_09
          desc: '''Outside the alert handler's in-band reset, the pinmux shall send the fatal alert only after a failed request or an alert test. This rule does not cover the pinmux's answers to the alert handler's pings.'''
          source: [
            '''[pinmux.hjson `alert_list` fatal_fault](hw/top_darjeeling/ip_autogen/pinmux/data/pinmux.hjson)'''
            '''[Employed Solution](hw/top_darjeeling/ip_autogen/alert_handler/doc/theory_of_operation.md#employed-solution)'''
          ]
          kind: "spec"
          testpoint: "alert"
          checks: ["no alert without a cause (assert_Alert_NoAlertWithoutACause)"]
          why: '''The check allows an alert event only after a failed request, after a ping or after an alert test. Each ping and each alert test allows one event.'''
          milestone: "V2S"
          priority: "2"
          security: true
          state: "open"
        }
        {
          name: REQ_BUS_10a
          desc: '''A request with an undefined opcode shall receive an error response.'''
          source: [
            '''[Usage of Opcode, Size and Mask](hw/ip/tlul/README.md#usage-of-opcode-size-and-mask)'''
            '''[Error responses](util/reggen/README.md#error-responses)'''
          ]
          kind: "spec"
          testpoint: "bus"
          checks: ["errors as the register checker predicts", "the CSR checker"]
          why: '''The error checks of the CSR checker require `d_error` to be 1 on a request with an undefined opcode. The proof lets the opcode take any value.'''
          milestone: "V2"
          priority: "2"
          security: true
          state: "open"
        }
        {
          name: REQ_BUS_10b
          desc: '''A request with an illegal combination of address, size and mask shall receive an error response. These combinations are defined in the Conditions above.'''
          source: [
            '''[Explicit Error Cases](hw/ip/tlul/README.md#explicit-error-cases)'''
            '''TileLink 1.9.3 p. 51: "a_address must be aligned to a_size."'''
            '''No specification states the error on an address that is not aligned to the request's size.'''
          ]
          kind: "spec"
          testpoint: "bus"
          checks: ["errors as the register checker predicts", "the CSR checker"]
          why: '''The error checks of the CSR checker require `d_error` to be 1 on a request with an illegal combination of address, size and mask. The proof keeps every mask contiguous.'''
          milestone: "V2"
          priority: "2"
          security: true
          state: "open"
        }
        {
          name: REQ_BUS_10c
          desc: '''A write of 8 or 16 bits to an address not aligned to a word shall receive an error response.'''
          source: [
            '''[Error responses](util/reggen/README.md#error-responses)'''
            '''[Explicit Error Cases](hw/ip/tlul/README.md#explicit-error-cases)'''
          ]
          kind: "spec"
          testpoint: "bus"
          checks: ["errors as the register checker predicts", "the CSR checker"]
          why: '''The error checks of the CSR checker require `d_error` to be 1 on an 8-bit or 16-bit write that is not aligned to a word.'''
          milestone: "V2"
          priority: "2"
          security: true
          state: "open"
        }
        {
          name: REQ_BUS_10d
          desc: '''A write narrower than its register shall receive an error response. The width of a register is set by the location of its fields.'''
          source: [
            '''[Error responses](util/reggen/README.md#error-responses)'''
          ]
          kind: "spec"
          testpoint: "bus"
          checks: ["errors as the register checker predicts", "the CSR checker"]
          why: '''The error checks of the CSR checker require `d_error` to be 1 on a write that is narrower than its register.'''
          milestone: "V2"
          priority: "2"
          security: true
          state: "open"
        }
        {
          name: REQ_BUS_10e
          desc: '''A request to an address that no register maps shall receive an error response, when that address is within the address bits that the register block decodes.'''
          source: [
            '''[Explicit Error Cases](hw/ip/tlul/README.md#explicit-error-cases)'''
            '''[Error responses](util/reggen/README.md#error-responses)'''
          ]
          kind: "spec"
          testpoint: "bus"
          checks: ["errors as the register checker predicts", "the CSR checker"]
          why: '''The error checks of the CSR checker require `d_error` to be 1 on a request to an address that maps to no register.'''
          milestone: "V2"
          priority: "2"
          security: true
          state: "open"
        }
        {
          name: REQ_BUS_11
          desc: '''A write that is answered with an error for any reason other than a failed integrity check shall change no register.'''
          source: [
            '''[cip_base_vseq](hw/dv/sv/cip_lib/README.md#cip_base_vseq)'''
            '''[Error responses](util/reggen/README.md#error-responses)'''
          ]
          kind: "spec"
          testpoint: "bus"
          checks: ["error write changes nothing", "the CSR checker"]
          why: '''A write answered with an error is not an accepted write. The CSR checker and the no-write checks of the attribute registers and the AON fields therefore require every register to keep its value over that write.'''
          milestone: "V2"
          priority: "2"
          security: true
          state: "open"
        }
        {
          name: REQ_BUS_12
          desc: '''Outside the alert handler's in-band reset, the pinmux shall answer each ping of the alert handler with one alert event within a bounded time.'''
          source: [
            '''[Ping Testing](hw/top_darjeeling/ip_autogen/alert_handler/doc/theory_of_operation.md#ping-testing)'''
          ]
          kind: "spec"
          testpoint: "alert"
          checks: ["ping answered (assert_Alert_PingAnswered)", "no alert without a cause (assert_Alert_NoAlertWithoutACause)"]
          why: '''The check _ping answered_ requires an alert event within 40 cycles of each ping. In the check _no alert without a cause_, each ping allows one alert event, so one ping gives one event.'''
          milestone: "V2S"
          priority: "2"
          security: true
          state: "open"
        }
      ]
    }
    {
      name: '''Wakeup detectors'''
      conditions: [
        '''The detector index `w` runs from 0 to `NWkupDetect` - 1, and a cycle in these rows is a cycle of `clk_aon_i`. The watched signal and the forwarded value are defined in the Terms.'''
        '''The register values in these rows are those that the AON logic holds once a write has crossed into the AON domain.'''
        '''The rows hold while an enabled detector keeps its mode. The other fields of the detector may change while it is enabled, although no specification states what such a change does.'''
        '''The rows hold at every value of `sleep_en_i` and of the scan mode, and also while `clk_i` is stopped.'''
        '''The rows are checked from the filter's fourth sample after the AON reset `rst_aon_ni`.'''
        '''The timed rows (`REQ_WKUP_09a` to `REQ_WKUP_10b`) hold while `CNT_TH` is 1 or greater.'''
      ]
      requirements: [
        {
          name: REQ_WKUP_01
          desc: '''While a detector's `MIODIO` is 0, its watched signal shall be the input of MIO pad `PADSEL` - 2 for `PADSEL` from 2 to `NMioPads` + 1, the constant 0 for `PADSEL` 0 and the constant 1 for `PADSEL` 1.'''
          source: [
            '''!!MIO_PERIPH_INSEL.IN'''
            '''!!WKUP_DETECTOR.MIODIO'''
            '''!!WKUP_DETECTOR_PADSEL.SEL'''
            '''[Retention and Wakeup Features](hw/top_darjeeling/ip_autogen/pinmux/doc/theory_of_operation.md#retention-and-wakeup-features)'''
            '''[Wakeup Detectors](hw/top_darjeeling/ip_autogen/pinmux/doc/theory_of_operation.md#wakeup-detectors)'''
            '''[top_darjeeling_pinmux.ipconfig.hjson `n_mio_pads`](hw/top_darjeeling/ip_autogen/pinmux/data/top_darjeeling_pinmux.ipconfig.hjson)'''
          ]
          kind: "spec"
          testpoint: "wakeup"
          checks: ["edge sets cause (assert_Wakeup_EdgeSetsCause)", "timed high sets cause (assert_Wakeup_TimedHighSetsCause)", "timed low sets cause (assert_Wakeup_TimedLowSetsCause)", "no false cause (assert_Wakeup_NoFalseCause)"]
          why: '''The checks watch the MIO pad or the constant that the select names.'''
          milestone: "V2"
          priority: "1"
          security: false
          state: "open"
        }
        {
          name: REQ_WKUP_02
          desc: '''While a detector's `MIODIO` is 1, its watched signal shall be the input of DIO pad `PADSEL` for `PADSEL` from 0 to `NDioPads` - 1.'''
          source: [
            '''!!WKUP_DETECTOR.MIODIO'''
            '''!!WKUP_DETECTOR_PADSEL.SEL'''
            '''[MIO and DIO Signal Categories](hw/top_darjeeling/ip_autogen/pinmux/doc/theory_of_operation.md#mio-and-dio-signal-categories)'''
            '''[top_darjeeling_pinmux.ipconfig.hjson `n_dio_pads`](hw/top_darjeeling/ip_autogen/pinmux/data/top_darjeeling_pinmux.ipconfig.hjson)'''
          ]
          kind: "spec"
          testpoint: "wakeup"
          checks: ["edge sets cause (assert_Wakeup_EdgeSetsCause)", "no false cause (assert_Wakeup_NoFalseCause)"]
          why: '''The checks watch the forwarded value of the DIO pad that the select names.'''
          milestone: "V2"
          priority: "1"
          security: false
          state: "open"
        }
        {
          name: REQ_WKUP_03
          desc: '''A detector's watched signal shall be 0 while its `PADSEL` names no pad. `PADSEL` names no pad when it is greater than `NMioPads` + 1 and `MIODIO` is 0, or when it is `NDioPads` or greater and `MIODIO` is 1.'''
          source: [
            '''!!WKUP_DETECTOR_PADSEL.SEL'''
            '''[top_darjeeling_pinmux.ipconfig.hjson `n_mio_pads`, `n_dio_pads`](hw/top_darjeeling/ip_autogen/pinmux/data/top_darjeeling_pinmux.ipconfig.hjson)'''
          ]
          kind: "spec"
          testpoint: "wakeup"
          checks: ["timed low sets cause (assert_Wakeup_TimedLowSetsCause)", "no false cause (assert_Wakeup_NoFalseCause)"]
          why: '''On a select that names no pad, the checks watch the value 0. The checks therefore require a detector in mode 4 to detect, and allow no edge to set the cause bit.'''
          milestone: "V2"
          priority: "1"
          security: false
          state: "open"
        }
        {
          name: REQ_WKUP_04
          desc: '''While a detector's `FILTER` is 0, its forwarded value shall be the watched signal as sampled at each `clk_aon_i` edge.'''
          source: [
            '''[Wakeup Detectors](hw/top_darjeeling/ip_autogen/pinmux/doc/theory_of_operation.md#wakeup-detectors)'''
          ]
          kind: "spec"
          testpoint: "wakeup"
          checks: ["edge sets cause (assert_Wakeup_EdgeSetsCause)", "no false cause (assert_Wakeup_NoFalseCause)"]
          why: '''With `FILTER` 0, the forwarded value that the checks watch is the sampled pad. The checks allow the pad to be seen up to 4 cycles late.'''
          milestone: "V2"
          priority: "1"
          security: false
          state: "open"
        }
        {
          name: REQ_WKUP_05
          desc: '''While a detector's `FILTER` is 1, its forwarded value shall take a new value only once 4 consecutive samples of the watched signal have had that value.'''
          source: [
            '''!!WKUP_DETECTOR.FILTER'''
          ]
          kind: "spec"
          testpoint: "wakeup"
          checks: ["edge sets cause (assert_Wakeup_EdgeSetsCause)", "no false cause (assert_Wakeup_NoFalseCause)"]
          why: '''The checks count a level that holds for 4 consecutive samples as an edge of the forwarded value. A glitch of 3 samples gives no edge.'''
          milestone: "V2"
          priority: "1"
          security: false
          state: "open"
        }
        {
          name: REQ_WKUP_06a
          desc: '''An enabled detector in mode 0 (Posedge) shall detect every rise of the forwarded value.'''
          source: [
            '''!!WKUP_DETECTOR.MODE'''
            '''[Wakeup Detectors](hw/top_darjeeling/ip_autogen/pinmux/doc/theory_of_operation.md#wakeup-detectors)'''
          ]
          kind: "spec"
          testpoint: "wakeup"
          checks: ["posedge sets cause (assert_Wakeup_PosedgeSetsCause)"]
          why: '''The check requires a hardware write of 1 to the cause bit within 8 cycles of each rise of the forwarded value, if `EN` is 1 at the rise and in each of the 4 cycles after it. A pulse of one sample counts as a rise.'''
          milestone: "V2"
          priority: "1"
          security: false
          state: "open"
        }
        {
          name: REQ_WKUP_06b
          desc: '''An enabled detector in mode 0 (Posedge) shall detect only at a rise of the forwarded value.'''
          source: [
            '''!!WKUP_DETECTOR.MODE'''
            '''[Wakeup Detectors](hw/top_darjeeling/ip_autogen/pinmux/doc/theory_of_operation.md#wakeup-detectors)'''
          ]
          kind: "spec"
          testpoint: "wakeup"
          checks: ["no false cause (assert_Wakeup_NoFalseCause)"]
          why: '''In mode 0, the check allows a hardware write of 1 to a cause bit at 0 only when the write answers a rise of the forwarded value with `EN` 1. The check allows the rise to be seen up to 4 cycles late.'''
          milestone: "V2"
          priority: "1"
          security: false
          state: "open"
        }
        {
          name: REQ_WKUP_07a
          desc: '''An enabled detector in mode 1 (Negedge) shall detect every fall of the forwarded value.'''
          source: [
            '''!!WKUP_DETECTOR.MODE'''
          ]
          kind: "spec"
          testpoint: "wakeup"
          checks: ["negedge sets cause (assert_Wakeup_NegedgeSetsCause)"]
          why: '''The check requires a hardware write of 1 to bit `w` within 8 cycles of each fall of the forwarded value, if `EN` is 1 at the fall and in each of the 4 cycles after it.'''
          milestone: "V2"
          priority: "1"
          security: false
          state: "open"
        }
        {
          name: REQ_WKUP_07b
          desc: '''An enabled detector in mode 1 (Negedge) shall detect only at a fall of the forwarded value.'''
          source: [
            '''!!WKUP_DETECTOR.MODE'''
          ]
          kind: "spec"
          testpoint: "wakeup"
          checks: ["no false cause (assert_Wakeup_NoFalseCause)"]
          why: '''In mode 1, the check allows a hardware write of 1 to a cause bit at 0 only when the write answers a fall of the forwarded value. A detector that detects on a rise therefore fails the check.'''
          milestone: "V2"
          priority: "1"
          security: false
          state: "open"
        }
        {
          name: REQ_WKUP_08a
          desc: '''An enabled detector in mode 2 (Edge) shall detect every change of the forwarded value.'''
          source: [
            '''!!WKUP_DETECTOR.MODE'''
          ]
          kind: "spec"
          testpoint: "wakeup"
          checks: ["edge sets cause (assert_Wakeup_EdgeSetsCause)"]
          why: '''The check requires a hardware write of 1 to bit `w` within 8 cycles of each rise and each fall of the forwarded value, if `EN` is 1 at the edge and in each of the 4 cycles after it.'''
          milestone: "V2"
          priority: "1"
          security: false
          state: "open"
        }
        {
          name: REQ_WKUP_08b
          desc: '''An enabled detector in mode 2 (Edge) shall detect only at a change of the forwarded value.'''
          source: [
            '''!!WKUP_DETECTOR.MODE'''
          ]
          kind: "spec"
          testpoint: "wakeup"
          checks: ["no false cause (assert_Wakeup_NoFalseCause)"]
          why: '''In mode 2, the check allows a hardware write of 1 to a cause bit at 0 only when the write answers a rise or a fall of the forwarded value.'''
          milestone: "V2"
          priority: "1"
          security: false
          state: "open"
        }
        {
          name: REQ_WKUP_09a
          desc: '''An enabled detector in mode 3 (TimedHigh) shall detect when the forwarded value has been 1 for `CNT_TH` consecutive cycles.'''
          source: [
            '''!!WKUP_DETECTOR.MODE'''
            '''!!WKUP_DETECTOR_CNT_TH.TH'''
            '''[Wakeup Detectors](hw/top_darjeeling/ip_autogen/pinmux/doc/theory_of_operation.md#wakeup-detectors)'''
            '''[top_darjeeling_pinmux.ipconfig.hjson `wkup_cnt_width`](hw/top_darjeeling/ip_autogen/pinmux/data/top_darjeeling_pinmux.ipconfig.hjson)'''
          ]
          kind: "spec"
          testpoint: "wakeup"
          checks: ["timed high sets cause (assert_Wakeup_TimedHighSetsCause)"]
          why: '''The check requires the cause bit to be set within 8 cycles of the cycle in which the forwarded value has been 1 for `CNT_TH` + 1 consecutive cycles with `EN` 1. The sources of this count differ by one cycle, so a detection after `CNT_TH` + 1 cycles also passes.'''
          milestone: "V2"
          priority: "1"
          security: false
          state: "open"
        }
        {
          name: REQ_WKUP_09b
          desc: '''An enabled detector in mode 3 (TimedHigh) shall never detect while the forwarded value has been 1 for fewer than `CNT_TH` consecutive cycles.'''
          source: [
            '''!!WKUP_DETECTOR.MODE'''
            '''[top_darjeeling_pinmux.ipconfig.hjson `wkup_cnt_width`](hw/top_darjeeling/ip_autogen/pinmux/data/top_darjeeling_pinmux.ipconfig.hjson)'''
          ]
          kind: "spec"
          testpoint: "wakeup"
          checks: ["no false cause (assert_Wakeup_NoFalseCause)"]
          why: '''In mode 3, the check refuses a set of the cause bit while the forwarded value has been 1 for fewer than `CNT_TH` consecutive cycles with `EN` 1.'''
          milestone: "V2"
          priority: "1"
          security: false
          state: "open"
        }
        {
          name: REQ_WKUP_10a
          desc: '''An enabled detector in mode 4 (TimedLow) shall detect when the forwarded value has been 0 for `CNT_TH` consecutive cycles.'''
          source: [
            '''!!WKUP_DETECTOR.MODE'''
            '''!!WKUP_DETECTOR_CNT_TH.TH'''
            '''[Wakeup Detectors](hw/top_darjeeling/ip_autogen/pinmux/doc/theory_of_operation.md#wakeup-detectors)'''
            '''[top_darjeeling_pinmux.ipconfig.hjson `wkup_cnt_width`](hw/top_darjeeling/ip_autogen/pinmux/data/top_darjeeling_pinmux.ipconfig.hjson)'''
          ]
          kind: "spec"
          testpoint: "wakeup"
          checks: ["timed low sets cause (assert_Wakeup_TimedLowSetsCause)"]
          why: '''The check requires the cause bit to be set within 8 cycles of the cycle in which the forwarded value has been 0 for `CNT_TH` + 1 consecutive cycles with `EN` 1. The sources of this count differ by one cycle, so a detection after `CNT_TH` + 1 cycles also passes.'''
          milestone: "V2"
          priority: "1"
          security: false
          state: "open"
        }
        {
          name: REQ_WKUP_10b
          desc: '''An enabled detector in mode 4 (TimedLow) shall never detect while the forwarded value has been 0 for fewer than `CNT_TH` consecutive cycles.'''
          source: [
            '''!!WKUP_DETECTOR.MODE'''
            '''[top_darjeeling_pinmux.ipconfig.hjson `wkup_cnt_width`](hw/top_darjeeling/ip_autogen/pinmux/data/top_darjeeling_pinmux.ipconfig.hjson)'''
          ]
          kind: "spec"
          testpoint: "wakeup"
          checks: ["no false cause (assert_Wakeup_NoFalseCause)"]
          why: '''In mode 4, the check refuses a set of the cause bit while the forwarded value has been 0 for fewer than `CNT_TH` consecutive cycles with `EN` 1.'''
          milestone: "V2"
          priority: "1"
          security: false
          state: "open"
        }
        {
          name: REQ_WKUP_11
          desc: '''An enabled detector in mode 5, 6 or 7 shall detect exactly the rises of the forwarded value, as in mode 0 (Posedge).'''
          source: [
            '''!!WKUP_DETECTOR.MODE'''
          ]
          kind: "spec"
          testpoint: "wakeup"
          checks: ["posedge sets cause (assert_Wakeup_PosedgeSetsCause)", "no false cause (assert_Wakeup_NoFalseCause)"]
          why: '''Both checks read `MODE` 5, 6 and 7 as mode 0.'''
          milestone: "V2"
          priority: "1"
          security: false
          state: "open"
        }
        {
          name: REQ_WKUP_12
          desc: '''A detector whose enable is 0 shall detect nothing.'''
          source: [
            '''!!WKUP_DETECTOR_EN.EN'''
          ]
          kind: "spec"
          testpoint: "wakeup"
          checks: ["no false cause (assert_Wakeup_NoFalseCause)"]
          why: '''The check allows a hardware write of 1 to a cause bit at 0 only when the write answers a pattern with `EN` 1. An edge within 4 cycles of a change of `EN` may set the cause bit or not.'''
          milestone: "V2"
          priority: "1"
          security: false
          state: "open"
        }
        {
          name: REQ_WKUP_13a
          desc: '''The sampling of a detector's watched signal shall run while the detector is disabled, so that enabling the detector does not restart the sampling.'''
          source: [
            '''None: the theory of operation and the register description are silent'''
          ]
          kind: "RTL"
          testpoint: "wakeup"
          checks: ["no false cause (assert_Wakeup_NoFalseCause)", "posedge sets cause (assert_Wakeup_PosedgeSetsCause)"]
          why: '''The checks sample the pad at every value of `EN`. A pad that is already 1 before the enable therefore gives no rise, and a rise immediately after the enable counts as a rise.'''
          milestone: "V2"
          priority: "1"
          security: false
          state: "open"
        }
        {
          name: REQ_WKUP_13b
          desc: '''A detector's filter shall run while the detector is disabled, so that enabling the detector does not restart the filter.'''
          source: [
            '''None: the theory of operation and the register description are silent'''
          ]
          kind: "RTL"
          testpoint: "wakeup"
          checks: ["no false cause (assert_Wakeup_NoFalseCause)", "posedge sets cause (assert_Wakeup_PosedgeSetsCause)"]
          why: '''The filter of the checks runs at every value of `EN`. A rise whose 4 samples span the enable counts as a rise, and a pad that is already 1 before the enable does not.'''
          milestone: "V2"
          priority: "1"
          security: false
          state: "open"
        }
        {
          name: REQ_WKUP_14
          desc: '''When detector `w` is enabled and detects, bit `w` of `WKUP_CAUSE` shall become 1.'''
          source: [
            '''[Wakeup Detectors](hw/top_darjeeling/ip_autogen/pinmux/doc/theory_of_operation.md#wakeup-detectors)'''
            '''!!WKUP_CAUSE.CAUSE'''
            '''[Wakeup Features](hw/top_darjeeling/ip_autogen/pinmux/doc/programmers_guide.md#wakeup-features)'''
            '''[top_darjeeling_pinmux.ipconfig.hjson `n_wkup_detect`](hw/top_darjeeling/ip_autogen/pinmux/data/top_darjeeling_pinmux.ipconfig.hjson)'''
          ]
          kind: "spec"
          testpoint: "wakeup"
          checks: ["posedge sets cause (assert_Wakeup_PosedgeSetsCause)", "negedge sets cause (assert_Wakeup_NegedgeSetsCause)", "edge sets cause (assert_Wakeup_EdgeSetsCause)", "timed high sets cause (assert_Wakeup_TimedHighSetsCause)", "timed low sets cause (assert_Wakeup_TimedLowSetsCause)", "set lands (assert_Wakeup_SetLands)"]
          why: '''The checks require a cause set within 8 cycles of each detection, and the cause bit to be 1 in the cycle after the set.'''
          milestone: "V2"
          priority: "1"
          security: false
          state: "open"
        }
        {
          name: REQ_WKUP_15
          desc: '''Bit `w` of `WKUP_CAUSE` shall become 1 only when detector `w` detects.'''
          source: [
            '''!!WKUP_CAUSE.CAUSE'''
            '''[top_darjeeling_pinmux.ipconfig.hjson `n_wkup_detect`](hw/top_darjeeling/ip_autogen/pinmux/data/top_darjeeling_pinmux.ipconfig.hjson)'''
          ]
          kind: "spec"
          testpoint: "wakeup"
          checks: ["no false cause (assert_Wakeup_NoFalseCause)", "cause rises only on a set (assert_Wakeup_CauseRisesOnlyOnASet)"]
          why: '''The checks allow a cause set of bit `w` only on a pattern of detector `w`, and allow bit `w` to rise only in the cycle after a cause set of that bit.'''
          milestone: "V2"
          priority: "1"
          security: false
          state: "open"
        }
        {
          name: REQ_WKUP_16
          desc: '''Once a cause bit (a bit of `WKUP_CAUSE`) is 1, it shall stay 1 until software's clear of that bit lands. This holds for any behaviour of the bit's detector, of the detector's enable and of the pad that the detector watches.'''
          source: [
            '''!!WKUP_CAUSE'''
            '''!!WKUP_CAUSE.CAUSE'''
            '''[Wakeup Features](hw/top_darjeeling/ip_autogen/pinmux/doc/programmers_guide.md#wakeup-features)'''
            '''[Wakeup Recording](hw/top_darjeeling/ip_autogen/pwrmgr/doc/theory_of_operation.md#wakeup-recording)'''
          ]
          kind: "spec"
          testpoint: "wakeup_cause"
          checks: ["cause holds until cleared (assert_WakeupCause_CauseHoldsUntilCleared)", "hardware only sets cause (assert_WakeupCause_HardwareOnlySetsCause)"]
          why: '''The checks allow the cause bit to fall only in the cycle after a landed clear, or at `rst_aon_ni`. The checks allow a hardware write of 0 to the bit only in a cycle in which a clear lands.'''
          milestone: "V2"
          priority: "2"
          security: false
          state: "open"
        }
        {
          name: REQ_WKUP_17
          desc: '''When a detection sets a cause bit in the cycle in which software's clear of that bit lands, the bit shall end at 0. Software's clear has precedence over the detection.'''
          source: [
            '''!!WKUP_CAUSE'''
            '''[Type RW](util/reggen/README.md#type-rw)'''
            '''[Simultaneous SW and HW access](util/reggen/README.md#simultaneous-sw-and-hw-access)'''
          ]
          kind: "spec"
          testpoint: "wakeup_cause"
          checks: ["set and clear together (assert_WakeupCause_SetAndClearTogether)"]
          why: '''When a hardware write of 1 to a cause bit comes in the cycle in which a clear of that bit lands, the check requires the bit to be 0 in the next cycle.'''
          milestone: "V2"
          priority: "2"
          security: false
          state: "open"
        }
        {
          name: REQ_WKUP_18a
          desc: '''`pin_wkup_req_o` shall be 1 while at least one cause bit is 1.'''
          source: [
            '''[Inter-Module Signals](hw/top_darjeeling/ip_autogen/pinmux/doc/interfaces.md#inter-module-signals)'''
            '''[Wakeup Detectors](hw/top_darjeeling/ip_autogen/pinmux/doc/theory_of_operation.md#wakeup-detectors)'''
            '''[Wakeup Recording](hw/top_darjeeling/ip_autogen/pwrmgr/doc/theory_of_operation.md#wakeup-recording)'''
            '''[top_darjeeling_pinmux.ipconfig.hjson `n_wkup_detect`](hw/top_darjeeling/ip_autogen/pinmux/data/top_darjeeling_pinmux.ipconfig.hjson)'''
          ]
          kind: "spec"
          testpoint: "wakeup_cause"
          checks: ["request follows cause (assert_WakeupCause_RequestFollowsCause)"]
          why: '''The check requires `pin_wkup_req_o` to be 1 within 2 cycles of any cause bit rising. The check also requires the request to be 1 while any cause bit has been 1 for 3 consecutive cycles.'''
          milestone: "V2"
          priority: "2"
          security: false
          state: "open"
        }
        {
          name: REQ_WKUP_18b
          desc: '''`pin_wkup_req_o` shall be 0 while every cause bit is 0.'''
          source: [
            '''[Inter-Module Signals](hw/top_darjeeling/ip_autogen/pinmux/doc/interfaces.md#inter-module-signals)'''
            '''[Wakeup Detectors](hw/top_darjeeling/ip_autogen/pinmux/doc/theory_of_operation.md#wakeup-detectors)'''
            '''[Wakeup Recording](hw/top_darjeeling/ip_autogen/pwrmgr/doc/theory_of_operation.md#wakeup-recording)'''
            '''[top_darjeeling_pinmux.ipconfig.hjson `n_wkup_detect`](hw/top_darjeeling/ip_autogen/pinmux/data/top_darjeeling_pinmux.ipconfig.hjson)'''
          ]
          kind: "spec"
          testpoint: "wakeup_cause"
          checks: ["no request without cause (assert_WakeupCause_NoRequestWithoutCause)"]
          why: '''The check requires `pin_wkup_req_o` to be 0 once every cause bit has been 0 for 3 consecutive cycles.'''
          milestone: "V2"
          priority: "2"
          security: false
          state: "open"
        }
        {
          name: REQ_WKUP_19a
          desc: '''A write to a detector's enable shall reach the AON logic within a bounded time.'''
          source: [
            '''!!WKUP_DETECTOR_EN'''
            '''[Wakeup Features](hw/top_darjeeling/ip_autogen/pinmux/doc/programmers_guide.md#wakeup-features)'''
          ]
          kind: "spec"
          testpoint: "wakeup_sync"
          checks: ["write lands (assert_WakeupSync_WriteLands)", "no change without a write (assert_WakeupSync_NoChangeWithoutAWrite)"]
          why: '''For `EN`, the checks require each accepted write to land within 4 cycles, and allow only a write that has not yet landed to change the field.'''
          milestone: "V2"
          priority: "2"
          security: false
          state: "open"
        }
        {
          name: REQ_WKUP_19b
          desc: '''A write to a detector's configuration shall reach the AON logic within a bounded time.'''
          source: [
            '''!!WKUP_DETECTOR'''
            '''[Wakeup Features](hw/top_darjeeling/ip_autogen/pinmux/doc/programmers_guide.md#wakeup-features)'''
          ]
          kind: "spec"
          testpoint: "wakeup_sync"
          checks: ["write lands (assert_WakeupSync_WriteLands)", "no change without a write (assert_WakeupSync_NoChangeWithoutAWrite)"]
          why: '''For `MODE`, `FILTER` and `MIODIO`, the checks require each accepted write to land within 4 cycles, and allow only a write that has not yet landed to change one of these fields.'''
          milestone: "V2"
          priority: "2"
          security: false
          state: "open"
        }
        {
          name: REQ_WKUP_19c
          desc: '''A write to a detector's threshold shall reach the AON logic within a bounded time.'''
          source: [
            '''!!WKUP_DETECTOR_CNT_TH'''
            '''[Wakeup Features](hw/top_darjeeling/ip_autogen/pinmux/doc/programmers_guide.md#wakeup-features)'''
          ]
          kind: "spec"
          testpoint: "wakeup_sync"
          checks: ["write lands (assert_WakeupSync_WriteLands)", "no change without a write (assert_WakeupSync_NoChangeWithoutAWrite)"]
          why: '''For `CNT_TH`, the checks require each accepted write to land within 4 cycles, and allow only a write that has not yet landed to change the field.'''
          milestone: "V2"
          priority: "2"
          security: false
          state: "open"
        }
        {
          name: REQ_WKUP_19d
          desc: '''A clear of `WKUP_CAUSE` shall reach the AON logic within a bounded time.'''
          source: [
            '''!!WKUP_CAUSE'''
            '''[Wakeup Features](hw/top_darjeeling/ip_autogen/pinmux/doc/programmers_guide.md#wakeup-features)'''
          ]
          kind: "spec"
          testpoint: "wakeup_sync"
          checks: ["clear lands (assert_WakeupSync_ClearLands)", "landed clear clears cause (assert_WakeupSync_LandedClearClearsCause)", "no clear without a write (assert_WakeupSync_NoClearWithoutAWrite)"]
          why: '''The checks require each software clear of the cause bit to land within 10 cycles, and the bit to be 0 one cycle later. The checks allow no clear to land without a software clear.'''
          milestone: "V2"
          priority: "2"
          security: false
          state: "open"
        }
        {
          name: REQ_WKUP_20a
          desc: '''A write to a detector's configuration that is accepted before a write to its enable shall hold in the AON logic no later than that enable write does.'''
          source: [
            '''!!WKUP_DETECTOR_EN'''
          ]
          kind: "spec"
          testpoint: "wakeup_sync"
          checks: ["writes land in order (assert_WakeupSync_WritesLandInOrder)"]
          why: '''The check compares the AON cycles in which a configuration write and a later enable write land. The check fails when the enable write lands first.'''
          milestone: "V2"
          priority: "2"
          security: false
          state: "open"
        }
        {
          name: REQ_WKUP_20b
          desc: '''A write to a detector's threshold that is accepted before a write to its enable shall hold in the AON logic no later than that enable write does.'''
          source: [
            '''!!WKUP_DETECTOR_EN'''
          ]
          kind: "spec"
          testpoint: "wakeup_sync"
          checks: ["writes land in order (assert_WakeupSync_WritesLandInOrder)"]
          why: '''The check compares the AON cycles in which a threshold write and a later enable write land. An enable that holds before the threshold fails the check.'''
          milestone: "V2"
          priority: "2"
          security: false
          state: "open"
        }
      ]
    }
  ]
}
