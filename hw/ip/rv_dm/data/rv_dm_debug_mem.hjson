// Copyright lowRISC contributors.
// Licensed under the Apache License, Version 2.0, see LICENSE for details.
// SPDX-License-Identifier: Apache-2.0

// Expansion of debug memory within rv_dm used for DV purposes.
//
// The debug memory region is specified in the PULP debug system documentation here:
// https://github.com/pulp-platform/riscv-dbg/blob/master/doc/debug-system.md
//
// The debug module exposes a 16kB memory called debug memory. It has a ROM portion (debug ROM),
// some memory mapped CSRs and a RAM portion (program buffer). This region is accessible over the TL
// interface only if debug mode is active.
//
// The OpenTitan RV_DM implementation that wraps around the PULP developed debug module only creates
// an empty "window" to this space in the adjoining `rv_dm.hjson`, since there is no need to carve
// out the region explicitly for RTL generation. For DV purposes, we fully specify that region to
// make the common DV tests more effective.
//
// TODO: Most of the CSRs below are required to be parameterized to the number of Harts the debug
// module caters to, which in case of RV_DM is 1. Consider making this actually parameterized to
// more accurately reflect the state of the design.
// The address skips and jumps were also obtained from the documentation page referenced above. They
// are expected to be stable, given that this Hjson is written manually.
{ name: "rv_dm_debug_mem",
  clocking: [
    {clock: "clk_i", reset: "rst_ni"}
  ]
  bus_interfaces: [
    { protocol: "tlul", direction: "device" }
  ],
  regwidth: "32",
  registers: [
    { skipto: "0x100" }
    { name: "HALTED",
      desc: "Write to this address to acknowledge that the core has halted.",
      swaccess: "wo",
      hwaccess: "hrw", // updated by write to RESUMING
      fields: [
        { bits: "0",
          resval: "0"
        },
      ]
    },
    { name: "GOING",
      desc: "Write to this address to acknowledge that the core is executing.",
      swaccess: "wo",
      hwaccess: "hro",
      fields: [
        { bits: "0",
          resval: "0"
        },
      ]
    },
    { name: "RESUMING",
      desc: "Write to this address to acknowledge that the core is resuming non-debug operation.",
      swaccess: "wo",
      hwaccess: "hro",
      fields: [
        { bits: "0",
          resval: "0"
        },
      ]
    },
    { name: "EXCEPTION",
      desc: "An exception was triggered while the core was in debug mode.",
      swaccess: "wo",
      hwaccess: "hro",
      fields: [
        { bits: "0",
          resval: "0"
        },
      ]
    },
    { skipto: "0x300" }
    { name: "WHERETO",
      desc: "TODO: No description provided in the spec.",
      swaccess: "ro",
      hwaccess: "hrw",
      fields: [
        { bits: "31:0",
          resval: "0"
        },
      ]
    },
    { skipto: "0x338" }
    { multireg: {
        cname: "ABSTRACTCMD"
        name:  "ABSTRACTCMD"
        desc:  "TODO: No description provided in the spec."
        count: "10"
        swaccess: "ro"
        hwaccess: "hro"
        fields: [
          { bits: "31:0"
            resval: "0"
          }
        ]
        tags: [// TODO: It is unclear how to predict these values.
               "excl:CsrAllTests:CsrExclCheck"]
      }
    },
    { multireg: {
        cname: "PROGRAM_BUFFER"
        name:  "PROGRAM_BUFFER"
        desc:  "TODO: No description provided in the spec."
        count: "8"
        swaccess: "ro"
        hwaccess: "hro"
        fields: [
          { bits: "31:0"
            resval: "0"
          }
        ]
      }
    },
    { multireg: {
        cname: "DATAADDR"
        name:  "DATAADDR"
        desc:  "TODO: No description provided in the spec."
        count: "2"
        swaccess: "rw"
        hwaccess: "hro"
        fields: [
          { bits: "31:0"
            resval: "0"
          }
        ]
        tags: [// TODO: Write-read-check will work after "activating" the debug module via JTAG.
               "excl:CsrNonInitTests:CsrExclWriteCheck"]
      }
    },
    { skipto: "0x400" }
    { multireg: {
        cname: "FLAGS"
        name:  "FLAGS"
        desc:  "TODO: No description provided in the spec."
        count: "256"
        swaccess: "ro"
        hwaccess: "hro"
        fields: [
          { bits: "31:0"
            resval: "0"
          }
        ]
      }
    },
    // ROM size (given as `items` below) must be a power of two.
    { window: {
        name: "ROM"
        items: "512" // 2 KiB
        swaccess: "ro",
        desc: '''Access window into the debug ROM.'''
      }
    },
  ]
}
