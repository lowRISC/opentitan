// Copyright lowRISC contributors.
// Licensed under the Apache License, Version 2.0, see LICENSE for details.
// SPDX-License-Identifier: Apache-2.0
{ name: "kmac"
  clock_primary: "clk_i"
  bus_device: "tlul"
  bus_host: "none"
  estimated_gates: "70kGE" // Excluding SRAM macro
  interrupt_list: [
    { name: "kmac_done"
      desc: "KMAC/SHA3 completes a message"
    }
    { name: "fifo_empty"
      desc: "Message FIFO empty condition"
    }
    { name: "kmac_err"
      desc: "KMAC error occurred. ERR_CODE register shows which error occurred"
    }
  ]
  alert_list: [
    { name: "sram_uncorrectable"
      desc: "MSG_FIFO SRAM uncorrectable error occurred."
    }
    { name: "data_parity"
      desc: "countermeasure data doesn't match with the expected data"
    }
  ]

  inter_signal_list: [
    { struct:  "hw_key_req"
      type:    "uni"  // no `_req/rsp`
      name:    "keymgr_key"
      act:     "rcv"
      package: "keymgr_pkg"
    } // keymgr_key
    { struct:  "kmac_data"
      type:    "req_rsp"
      name:    "keymgr_data"
      act:     "rsp"
      package: "keymgr_pkg"
    } // keymgr_data
  ] // inter_signal_list

  regwidth: "32"
  registers: [
    { name: "CFG"
      desc: '''KMAC Configuration Register.
            
            The reigster is updated when the engine is in Idle.
            '''
      hwext: "true"
      hwqe:  "true"
      swaccess: "rw"
      hwaccess: "hrw"
      fields: [
        { bits: "0"
          name: "kmac_en"
          desc: '''KMAC datapath enable.

                If this bit is 1, KMAC operates when `hash_start` toggles.
                '''
        }
        { bits: "2"
          name: "endian_swap"
          desc: "Convert TL-UL wdata[31:0] to big-endian style {w[7:0], w[15:8], .. }"
          resval: "1"
        }
        { bits: "3"
          name: "digest_swap"
          desc: "DIGEST register byte-order. If 1, it swaps each DIGEST registers' byte-order."
          resval: "0"
        }
        { bits: "5:4"
          name: "mode"
          desc: '''KMAC mode selection.
                '''
          resval: "0"
          enum: [
            { value: "0"
              name:  "Software"
              desc: '''Fully Software Controlled mode.

                    Secret Key and the data are fed by the software.
                    Software needs to pad the secret key. Hardware operates as SHA3 (TBD)
                    '''
            }
            { value: "1"
              name: "Sideload"
              desc: '''Secret Key Sideload mode.

                    The data is fed by the software or through TL-UL port.
                    The key comes from KeyMgr via `keymgr_key` port
                    '''
            }
            { value: "2"
              name: "KeyMgr"
              desc: '''Fully Key Manager Controlled mode.

                    The secret key and the data come from KeyMgr IP.
                    The result (hash) will be returned to KeyMgr directly and
                    not visible in the software interface (registers)
                    '''
            }
          ] // enum
        } // field : Mode
        { bits: "9:8"
          name: "data_width"
          desc: '''SHA3 Data Width.
                '''
          enum: [
            { value: "0"
              desc:  "SHA3-224 hash mode"
              name:  "SHA224"
            }
            { value: "1"
              desc:  "SHA3-256 hash mode"
              name:  "SHA256"
            }
            { value: "2"
              desc:  "SHA3-384 hash mode"
              name:  "SHA384"
            }
            { value: "3"
              desc:  "SHA3-512 hash mode"
              name:  "SHA512"
            }
          ]
        } // field : data_width
      ]
    } // register : cfg
    { name: "CMD"
      desc: "KMAC command register"
      swaccess: "r0w1c"
      hwaccess: "hro"
      hwext: "true"
      hwqe: "true"
      fields: [
        { bits: "0"
          name: "start"
          desc: '''If writes 1, KMAC/SHA3 begins its operation.
                '''
        } // field : start
        { bits: "1"
          name: "process"
          desc: '''If writes 1, KMAC/SHA3 calculates the given message and
                store the results into DIGEST
                '''
        } // field : process
      ] // field
    } // register : cmd
    { name: "STATUS",
      desc: "KMAC Status register",
      swaccess: "ro",
      hwaccess: "hwo",
      hwext: "true",
      fields: [
        { bits: "0",
          name: "fifo_empty",
          desc: "FIFO empty",
          resval: "1"
        }
        { bits: "1",
          name: "fifo_full",
          desc: "FIFO full. Data written to the FIFO whilst it is full will cause back-pressure on the interconnect"
        }
        { bits: "8:4",
          name: "fifo_depth",
          desc: "FIFO entry count."
        }
      ]
    } // register : status
    { name: "DUMMY"
      desc: "Dummy register to make prim_gate_gen to not be optimized"
      swaccess: "rw"
      hwaccess: "hrw"
      hwext: "false"
      hwqe: "true"
      fields: [
        { bits: "31:0"
          name: "dummy"
          desc: "dummy field"
        }
      ]
    }
    { name: "ALERT_TEST"
      desc: "connect alerts"
      swaccess: "wo"
      hwaccess: "hro"
      hwqe: "true"
      fields: [
        { bits: "1"
          name: "sram_uncorrectable"
          desc: "uncorrect error"
        }
        { bits: "0"
          name: "data_parity"
          desc: "data doesn't match"
        }
      ]
    }
    { name: "ERR_CODE",
      desc: "KMAC Error Code",
      swaccess: "ro",
      hwaccess: "hwo",
      fields: [
        { bits: "31:0",
          name: "err_code",
          desc: '''If error interrupt occurs, this register has information of error cause.
                Please take a look at `hw/ip/kmac/rtl/kmac_pkg.sv:err_code_e enum type.
                '''
        }
      ]
    } // register : err_code
    { skipto: "0x400" }
    { window: {
        name: "DIGEST"
        items: "16"
        swaccess: "ro"
        byte-write: "false"
        desc: '''DIGEST read port.

              After read a word from DIGEST, that word will be replaced with random value (TBD)
              '''
      }
    } // window : digest
    { skipto: "0x800" }
    { window: {
        name: "MSG_FIFO"
        items: "512"      // 2kB
        swaccess: "wo",
        byte-write: "true",
        desc: '''Message FIFO.
        
              Any write to this window will be appended to the FIFO.
              Only the lower [1:0] bits of the address matter to writes
              within the window (for correctly dealing with non 32-bit writes)
              '''
      }
    } // window : msg_fifo
  ]
}
