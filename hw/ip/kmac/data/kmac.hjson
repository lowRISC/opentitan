// Copyright lowRISC contributors (OpenTitan project).
// Licensed under the Apache License, Version 2.0, see LICENSE for details.
// SPDX-License-Identifier: Apache-2.0

{
  name:               "kmac",
  human_name:         "KMAC Accelerator",
  one_line_desc:      "Accelerator for Keccak-based keyed hash message authentication code and SHA-3 hash functions; with SCA and FI countermeasures",
  one_paragraph_desc: '''
  OpenTitan protocols use [Keccak/SHA-3][nist-fips-202]-based cryptographic primitives for data authentication, integrity checking, and key derivation.
  KMAC Accelerator supports Keccak-based Message Authentication Code (KMAC) and the SHA3-derived functions SHAKE and cSHAKE as defined in [NIST SP 800-185][nist-sp-800-185].
  The Keccak core uses first-order domain-oriented masking (DOM) to deter side-channel analysis (SCA).
  To save area, the masking can optionally be disabled using a compile-time Verilog parameter.
  In addition, KMAC Accelerator features several countermeasures to deter fault injection (FI) attacks.

  [nist-fips-202]: https://nvlpubs.nist.gov/nistpubs/FIPS/NIST.FIPS.202.pdf
  [nist-sp-800-185]: https://nvlpubs.nist.gov/nistpubs/SpecialPublications/NIST.SP.800-185.pdf
  '''
  // Unique comportable IP identifier defined under KNOWN_CIP_IDS in the regtool.
  cip_id:             "13",
  design_spec:        "../doc",
  dv_doc:             "../doc/dv",
  hw_checklist:       "../doc/checklist",
  sw_checklist:       "/sw/device/lib/dif/dif_kmac",
  revisions: [
    {
      version:            "2.0.0",
      life_stage:         "L1",
      design_stage:       "D2S",
      verification_stage: "V2S",
      dif_stage:          "S2",
      commit_id:          "0742a8e0ad0f0c9a50720ecfea93287035d52944",
    },
    {
      version:            "3.0.0",
      life_stage:         "L1",
      design_stage:       "D1",
      verification_stage: "V0",
      dif_stage:          "S1",
    }
  ]
  clocking: [
    {clock: "clk_i", reset: "rst_ni", idle: "idle_o", primary: true},
    {clock: "clk_edn_i", reset: "rst_edn_ni", idle: "idle_o"}
  ]
  bus_interfaces: [
    { protocol: "tlul", direction: "device" }
  ],

  interrupt_list: [
    { name: "kmac_done"
      desc: "KMAC/SHA3 absorbing has been completed"
    }
    { name: "fifo_empty"
      type: "status"
      desc: '''
            The message FIFO is empty.
            This interrupt is raised only if the message FIFO is actually writable by software, i.e., if all of the following conditions are met:
            i) The KMAC block is not exercised by a hardware application interface.
            ii) The SHA3 block is in the Absorb state.
            iii) Software has not yet written the Process command to finish the absorption process.
            For the interrupt to be raised, the message FIFO must also have been full previously.
            Otherwise, the hardware empties the FIFO faster than software can fill it and there is no point in interrupting the software to inform it about the message FIFO being empty.
            '''
    }
    { name: "kmac_err"
      desc: "KMAC/SHA3 error occurred. ERR_CODE register shows the details"
    }
  ]
  alert_list: [
    { name: "recov_operation_err"
      desc: '''
        Alert for KMAC operation error. It occurs when the shadow registers have update errors.
        '''
    }
    { name: "fatal_fault_err",
      desc: '''
      This fatal alert is triggered when a fatal error is detected inside the KMAC unit.
      Examples for such faults include:
      i) TL-UL bus integrity fault.
      ii) Storage errors in the shadow registers.
      iii) Errors in the message, round, or key counter.
      iv) Any internal FSM entering an invalid state.
      v) An error in the redundant lfsr.
      vi) A SHA3 core error occurs when an app interface is active.
      The KMAC unit cannot recover from such an error and needs to be reset.
      '''
    }
  ],
  param_list: [
    { name:    "EnMasking"
      type:    "bit"
      default: "1"
      desc:    '''
        Disable(0) or enable(1) first-order masking of Keccak round.
        '''
      local:   "false"
      expose:  "true"
    }
    { name:    "EnFullKmac"
      type:    "bit"
      default: "1"
      desc:    '''
        Disable(0) or enable(1) the full KMAC functionality.
        If disabled, the module is stripped down to only support SHA3, SHAKE and cSHAKE.
        '''
      local:   "false"
      expose:  "true"
    }
    { name:    "SwKeyMasked"
      type:    "bit"
      default: "0"
      desc:    '''
        Disable(0) or enable(1) software key masking in case masking is disabled (EnMasking == 0).
        If masking is enabled, this parameter has no effect.
        Mainly useful for software interface compatibility between the masked and unmasked design.
        Mostly relevant for SCA measurements.
        '''
      local:   "false"
      expose:  "true"
    }
    { name:    "SecCmdDelay"
      type:    "int"
      default: "0"
      desc: '''
        Command delay, useful for SCA measurements only.
        A value of e.g. 40 allows the processor to go into sleep before KMAC starts operation.
        If a value greater than 0 is chosen, software can pass two commands in series.
        The second command is buffered internally and will be presented to the hardware SecCmdDelay number of cycles after the first one.
        '''
      local:   "false"
      expose:  "true"
    }
    { name:    "SecIdleAcceptSwMsg"
      type:    "bit"
      default: "0"
      desc: '''
        If enabled (1), software writes to the message FIFO before having received a START command are not ignored.
        Disabled (0) by default.
        Useful for SCA measurements only.
        '''
      local:   "false"
      expose:  "true"
    }
    { name:    "NumAppIntf"
      type:    "int"
      default: "4"
      desc:    "Number of application interfaces"
      local:   "false"
      expose:  "true"
    }
    { name:                "AppCfg"
      desc:                '''Application interface configuration.
                           Top-level connection to the application interface must follow this definition.
                           '''
      type:                "kmac_pkg::app_config_t"
      unpacked_dimensions: "[KmacNumAppIntf]"
      default:             "'{kmac_pkg::AppCfgKeyMgr, kmac_pkg::AppCfgLcCtrl, kmac_pkg::AppCfgRomCtrl, kmac_pkg::AppCfgOtbn}"
      local:               "false"
      expose:              "true"
    }
    { name:    "NumWordsKey"
      type:    "int"
      default: "16"
      desc:    "Number of words for the secret key"
      local:   "true"
    }
    { name:    "NumWordsPrefix"
      type:    "int"
      default: "11"
      desc:    "Number of words for Encoded NsPrefix."
      local:   "true"
    }
    { name:    "NumEntriesMsgFifo"
      type:    "int"
      default: "10"
      desc:    "Number of entries in the message FIFO. Must match kmac_pkg::MsgFifoDepth."
      local:   "true"
    }
    { name:    "NumBytesMsgFifoEntry"
      type:    "int"
      default: "8"
      desc:    "Number of bytes in a single entry of the message FIFO. Must match kmac_pkg::MsgWidth."
      local:   "true"
    }
    { name:    "HashCntW"
      type:    "int unsigned"
      default: "10"
      desc:    "Width of the hash counter in the entropy"
      local:   "true"
    }
    { name:    "NumSeedsEntropy",
      type:    "int",
      default: "6",
      desc:    "Number of words for the PRNG seed used for entropy generation",
      local:   "true"
    }
    { name:      "RndCnstLfsrSeed"
      desc:      "Compile-time random data for PRNG default seed"
      type:      "kmac_pkg::lfsr_seed_t"
      randcount: "288"
      randtype:  "data"
    }
    { name:      "RndCnstLfsrPerm",
      desc:      "Compile-time random permutation for PRNG output",
      type:      "kmac_pkg::lfsr_perm_t"
      randcount: "800",
      randtype:  "perm",
    }
    { name:      "RndCnstBufferLfsrSeed"
      desc:      "Compile-time random data for PRNG buffer default seed"
      type:      "kmac_pkg::buffer_lfsr_seed_t"
      randcount: "800"
      randtype:  "data"
    }
    { name:      "RndCnstMsgPerm"
      desc:      "Compile-time random permutation for LFSR Message output"
      type:      "kmac_pkg::msg_perm_t"
      randcount: "64"
      randtype:  "perm"
    }
  ]
  inter_signal_list: [
    { struct:  "hw_key_req"
      type:    "uni"
      name:    "keymgr_key"
      act:     "rcv"
      package: "keymgr_dpe_pkg"
    }
    { struct:  "app"
      type:    "req_rsp"
      name:    "app"
      act:     "rsp"
      package: "kmac_pkg"
      width:   "NumAppIntf"
      default: "kmac_pkg::APP_REQ_DEFAULT"
    }
    { struct:  "edn"
      type:    "req_rsp"
      name:    "entropy"
      act:     "req"
      width:   "1"
      package: "edn_pkg"
    }
    { name:    "idle",
      type:    "uni",
      act:     "req",
      package: "prim_mubi_pkg",
      struct:  "mubi4",
      width:   "1"
    }
    { struct:  "logic"
      type:    "uni"
      name:    "en_masking"
      act:     "req"
    }
    { struct:  "lc_tx"
      type:    "uni"
      name:    "lc_escalate_en"
      act:     "rcv"
      default: "lc_ctrl_pkg::Off"
      package: "lc_ctrl_pkg"
    }
  ]
  features: [
    {
      name: "KMAC.MODE.SHA3",
      desc: '''SHA3 hashing algorithm supporting the following security strength configurations:
            SHA3-224, SHA3-256, SHA3-384, and SHA3-512. Compliant with NIST FIPS 202.
            '''
    }
    {
      name: "KMAC.MODE.SHAKE",
      desc: '''SHAKE hashing algorithm supporting the following security strength configurations:
            SHAKE128, and SHAKE256. Compliant with NIST FIPS 202.
            '''
    }
    {
      name: "KMAC.MODE.CSHAKE",
      desc: '''cSHAKE hashing algorithm supporting the following security strength configurations:
            cSHAKE128, and cSHAKE256. Compliant with NIST SP 800-185.
            '''
    }
    {
      name: "KMAC.MODE.KMAC",
      desc: '''KMAC Keccak Message Authentication Code supporting the following security strength
            configurations: KMAC128, KMAC256. Compliant with NIST SP 800-185.
            '''
    }
    {
      name: "KMAC.MODE.XOF",
      desc: '''SHAKE, cSHAKE and KMAC modes of operation support eXtendable-Output Format (XOF)
            as specified in NIST SP 800-185.
            '''
    }
    {
      name: "KMAC.ENDIANNESS.MESSAGE",
      desc: "Configurable input message endianness."
    }
    {
      name: "KMAC.ENDIANNESS.DIGEST",
      desc: "Configurable output digest endianness."
    }
    {
      name: "KMAC.KEY.SIDELOAD",
      desc: "Key can be loaded directly from the keymgr."
    }
    {
      name: "KMAC.ENTROPY_MODES",
      desc: '''
            Entropy required for countermeasures can be configured to be provided by software or EDN.
            In EDN Mode, the cadence of entropy requests from EDN is configurable.
            '''
    }
  ]
  countermeasures: [
    { name: "BUS.INTEGRITY",
      desc: "End-to-end bus integrity scheme."
    }
    { name: "LC_ESCALATE_EN.INTERSIG.MUBI"
      desc: "The global escalation input signal from the life cycle is multibit encoded"
    }
    { name: "SW_KEY.KEY.MASKING"
      desc: '''Data storage and secret key are two share to guard against 1st
        order attack.'''
    }
    { name: "KEY.SIDELOAD"
      desc: "Key from KeyMgr is sideloaded."
    }
    { name: "CFG_SHADOWED.CONFIG.SHADOW"
      desc: "Shadowed CFG register."
    }
    { name: "FSM.SPARSE"
      desc: "FSMs in KMAC are sparsely encoded."
    }
    { name: "CTR.REDUN"
      desc: '''Round counter, key index counter, sentmsg counter and hash counter
        use prim_count for redundancy'''
    }
    { name: "PACKER.CTR.REDUN"
      desc: "Packer Position counter uses prim_count for redundancy"
    }
    { name: "CFG_SHADOWED.CONFIG.REGWEN"
      desc: "CFG_SHADOWED is protected by REGWEN"
    }
    { name: "FSM.GLOBAL_ESC"
      desc: "Escalation moves all sparse FSMs into an invalid state."
    }
    { name: "FSM.LOCAL_ESC"
      desc: "Local fatal faults move all sparse FSMs into an invalid state."
    }
    { name: "LOGIC.INTEGRITY"
      desc: "The reset net for the internal state register and critical nets around the output register are buried."
    }
    { name: "ABSORBED.CTRL.MUBI"
      desc: "`absorbed` signal is mubi4_t type to protect against FI attacks."
    }
    { name: "SW_CMD.CTRL.SPARSE"
      desc: "`sw_cmd` and related signals are sparse encoded to protect against FI attacks."
    }
  ]
  regwidth: "32"
  registers: [
    { name: "CFG_REGWEN"
      desc: "Register write enable for !!CFG_SHADOWED register."
      swaccess: "ro"
      hwaccess: "hwo"
      hwext: "true"
      fields: [
        { bits: "0"
          desc: '''
                This bit indicates whether the !!CFG_SHADOWED register can be updated by software (1) or not (0).
                This bit reads 0 if the Keccak core is operating as indicated in the !!STATUS register.
                '''
          resval: "1"
        }
      ]
      tags: [// This regwen is completely under HW management and thus cannot be manipulated
             // by software.
             "excl:CsrNonInitTests:CsrExclCheck"]
    } // R : CFG_REGWEN
    { name: "CFG_SHADOWED"
      desc: '''KMAC Configuration register.

            This register can only be updated when the Keccak core is idle.
            This is indicated by !!CFG_REGWEN reading as 1.
            If !!CFG_REGWEN reads as 0 (meaning the Keccak core is busy), writes to this register are ignored.
            '''
      regwen:   "CFG_REGWEN"
      swaccess: "rw"
      hwaccess: "hro"
      shadowed: "true"
      hwqe:     "true"
      update_err_alert:  "recov_operation_err"
      storage_err_alert: "fatal_fault_err"
      fields: [
        { bits: "0"
          name: "kmac_en"
          desc: '''KMAC datapath enable.

                If this bit is 1, the KMAC mode is active and the secret key is prepended to the incoming message.
                '''
          tags: [// don't enable kmac and sha data paths - we will do that in functional tests
                 "excl:CsrNonInitTests:CsrExclWrite",
                 "shadowed_reg_path:u_cfg_reg_shadowed.u_cfg_reg_shadowed_kmac_en"
                 ]
        } // f: kmac_en
        { bits: "3:1"
          name: "kstrength"
          desc: '''Hashing Strength

                3 bit field to select the security strength of SHA3 hashing
                engine. If mode field is set to SHAKE or cSHAKE, only 128 and
                256 strength can be selected. Other value will result error
                when hashing starts.
                '''
          enum: [
            { value: "0"
              name:  "L128"
              desc: "128 bit strength. Keccak rate is 1344 bit"
            }
            { value: "1"
              name:  "L224"
              desc: "224 bit strength. Keccak rate is 1152 bit"
            }
            { value: "2"
              name:  "L256"
              desc: "256 bit strength. Keccak rate is 1088 bit"
            }
            { value: "3"
              name:  "L384"
              desc: "384 bit strength. Keccak rate is 832 bit"
            }
            { value: "4"
              name:  "L512"
              desc: "512 bit strength. Keccak rate is 576 bit"
            }
          ]
          tags: ["shadowed_reg_path:u_cfg_reg_shadowed.u_cfg_reg_shadowed_kstrength"]
        } // f: strength
        { bits: "5:4"
          name: "mode"
          desc: '''Keccak hashing mode.

                This module supports SHA3 main hashing algorithm and the part
                of its derived functions, SHAKE and cSHAKE with limitations.
                This field is to select the mode.
                '''
          enum: [
            { value: "0"
              name: "SHA3"
              desc: "SHA3 hashing mode. It appends `2'b 10` to the end of msg"
            }
            { value: "2"
              name: "SHAKE"
              desc: "SHAKE hashing mode. It appends `1111` to the end of msg"
            }
            { value: "3"
              name: "cSHAKE"
              desc: "cSHAKE hashing mode. It appends `00` to the end of msg"
            }
          ]
          tags: ["shadowed_reg_path:u_cfg_reg_shadowed.u_cfg_reg_shadowed_mode"]
        } // f: mode
        { bits: "8"
          name: "msg_endianness"
          desc: '''Message Endianness.

                If 1 then each individual multi-byte value, regardless of its
                alignment, written to !!MSG_FIFO will be added to the message
                in big-endian byte order.
                If 0, each value will be added to the message in little-endian
                byte order.
                A message written to !!MSG_FIFO one byte at a time will not be
                affected by this setting.
                From a hardware perspective byte swaps are performed on a TL-UL
                word granularity.
                '''
          resval: "0"
          tags: ["shadowed_reg_path:u_cfg_reg_shadowed.u_cfg_reg_shadowed_msg_endianness"]
        } // f: msg_endianness
        { bits: "9"
          name: "state_endianness"
          desc: '''State Endianness.

                If 1 then each individual word in the !!STATE output register
                is converted to big-endian byte order.
                The order of the words in relation to one another is not
                changed.
                This setting does not affect how the state is interpreted
                during computation.
                '''
          tags: ["shadowed_reg_path:u_cfg_reg_shadowed.u_cfg_reg_shadowed_state_endianness"]
        } // f: state_endianness
        { bits: "12"
          name: "sideload"
          desc: '''Sideloaded Key.

                If 1, KMAC uses KeyMgr sideloaded key for SW initiated KMAC
                operation. KMAC uses the sideloaded key regardless of this
                configuration when KeyMgr initiates the KMAC operation for
                Key Derivation Function (KDF).
                '''
          tags: ["shadowed_reg_path:u_cfg_reg_shadowed.u_cfg_reg_shadowed_sideload"]
        } // f: sideload
        { bits: "19"
          name: entropy_fast_process
          desc: '''Entropy Fast process mode.

          If 1, entropy logic uses garbage data while not processing the KMAC
          key block. It will re-use previous entropy value and will not
          expand the entropy when it is consumed. Only it refreshes the
          entropy while processing the secret key block. This process should
          not be used if SCA resistance is required because it may cause side
          channel leakage.
          '''
          tags: ["shadowed_reg_path:u_cfg_reg_shadowed.u_cfg_reg_shadowed_entropy_fast_process"]
        } // f: entropy_fast_process
        { bits: "20"
          name: msg_mask
          desc: '''Message Masking with PRNG.

            If 1, KMAC applies PRNG to the input messages to the Keccak module
            when KMAC mode is on.
            '''
        } // f: msg_mask
        { bits: "26"
          name: en_unsupported_modestrength
          desc: '''Enable Unsupported Mode and Strength configs.

            SW may set this field for KMAC to move forward with unsupported
            Keccak Mode and Strength configurations, such as cSHAKE512.

            If not set, KMAC won't propagate the SW command (CmdStart) to the
            rest of the blocks (AppIntf, KMAC Core, SHA3).
            '''
          tags: [// Randomly write mem will cause this reg updated by design
                 "excl:CsrAllTests:CsrExclWrite",
                 "shadowed_reg_path:u_cfg_reg_shadowed.u_cfg_reg_shadowed_en_unsupported_modestrength"]
        } // f: en_unsupported_modestrength
      ]
      tags: ["shadowed_reg_path:u_cfg_reg_shadowed"]
    } // R: CFG
    { name: "CMD"
      desc: '''KMAC/ SHA3 command register.

            This register is to control the KMAC to start accepting message,
            to process the message, and to manually run additional keccak
            rounds at the end. Only at certain stage, the CMD affects to the
            control logic. It follows the sequence of

            `start` --> `process` --> {`run` if needed --> } `done`
            '''
      swaccess: "r0w1c"
      hwaccess: "hro"
      hwext: "true"
      hwqe:  "true"
      tags: [// design assertion : after start sets, can only wr msg or set process
             // design assertion : process can be set only after start is set
             "excl:CsrAllTests:CsrExclWrite"]
      fields: [
        { bits: "5:0"
          name: "cmd"
          desc: '''Issue a command to the KMAC/SHA3 IP. The command is sparse
                encoded. To prevent sw from writing multiple commands at once,
                the field is defined as enum.
                '''
          enum: [
            { value: "7"
              name: "start"
              desc: '''Writing 6'b000111 or dec 7 into this field when KMAC/SHA3
                    is in idle, KMAC/SHA3 begins its operation.

                    If the mode is cSHAKE, before receiving the message, the
                    hashing logic processes Function name string N and
                    customization input string S first. If KMAC mode is enabled,
                    additionally it processes secret key block.
                    '''
            } // e: start
            { value: "50"
              name: "process"
              desc: '''Writing 6'b110010 or dec 50 into this field when KMAC/SHA3
                    began its operation and received the entire message, it
                    computes the digest or signing.
                    '''
            } // e: process
            { value: "46"
              name: "run"
              desc: '''The `run` field is used in the sponge squeezing stage.
                    It triggers the keccak round logic to run full 24 rounds.
                    This is optional and used when software needs more digest
                    bits than the keccak rate.

                    It only affects when the kmac/sha3 operation is completed.
                    '''
            } // e: run
            { value: "53"
              name: "done"
              desc: '''Writing 6'b110101 or dec 53 into this field completes the
                    operation. The KMAC/SHA3 hashing engine clears the Keccak
                    state and internal variables and goes back to Idle state for
                    the next command. The command also releases the KMAC HWIP
                    when SW has claimed it with the `state_write` command.
                    '''
            } // e: done
            { value: "28"
              name: "stop"
              desc: '''Writing 6'b011100 or dec 28 into this field when KMAC/SHA3
                    is receiving the message stops the sponge absorbing stage
                    without appending any padding. The Keccak state then holds a
                    valid intermediate sponge state, which SW can read from
                    !!STATE to save the context.

                    The message received since the last `start` or `continue`
                    command must be a multiple of the Keccak rate. Otherwise the
                    absorbing stage is stopped anyway, but the exposed state is
                    not a valid context and `ErrSwStopNotBlockAligned` is
                    reported.

                    Once !!STATUS.sha3_stopped is set, or the `kmac_done`
                    interrupt is raised, SW reads !!STATE and completes the
                    operation with the `done` command, which clears the Keccak
                    state.

                    This command is not available when a sideloaded key is used,
                    as saving the context would expose the key. The command is
                    then discarded and `ErrSwSaveRestoreSideload` is reported.
                    '''
            } // e: stop
            { value: "27"
              name: "state_write"
              desc: '''Writing 6'b011011 or dec 27 into this field when KMAC/SHA3
                    is idle claims the KMAC HWIP for SW such that it can write a
                    previously saved context to the KMAC HWIP. The command also
                    clears the Keccak state, so a restore always starts from a
                    known state.

                    SW resumes the operation with the `continue` command once the
                    full context is written. If SW decides not to resume after
                    all, the `done` command releases the KMAC HWIP again.

                    This command is not available when a sideloaded key is used.
                    The command is then discarded and `ErrSwSaveRestoreSideload`
                    is reported.
                    '''
            } // e: state_write
            { value: "41"
              name: "continue"
              desc: '''Writing 6'b101001 or dec 41 into this field after the
                    `state_write` command resumes the sponge absorbing stage from
                    the context that SW has written into !!STATE. Issuing it
                    without claiming the KMAC HWIP first is discarded and reported
                    as `ErrSwCmdSequence`.

                    In contrast to the `start` command, the prefix and key are
                    not processed again, as both are already part of the
                    restored state. The !!KEY_SHARE0 and !!KEY_SHARE1 registers
                    therefore do not need to be restored, but !!CFG_SHADOWED must
                    hold the same configuration as before the context was saved.

                    This command is not available when a sideloaded key is used.
                    The command is then discarded and `ErrSwSaveRestoreSideload`
                    is reported.
                    '''
            } // e: continue
          ] // enum
        } // f: cmd
        { bits: "8"
          name: "entropy_req"
          desc: '''
                Software can set this bit to 1 to manually trigger the reseeding of the internal PRNG when running in EDN Mode or in Software Mode.
                This will also clear !!ENTROPY_REFRESH_HASH_CNT.

                After setting this bit, the !!STATUS.entropy_ready bit should read as 0 and the !!STATUS.entropy_reseeding bit as 1 indicating that a reseed operation is ongoing.

                If !!ENTROPY_CFG_SHADOWED.ignore_cmd_entropy_req is set, this bit is ignored.
                If masking is disabled, this bit is ignored.
                '''
        }
        { bits: "9"
          name: "hash_cnt_clr"
          desc: '''
                Software can set this bit to 1 to manually clear !!ENTROPY_REFRESH_HASH_CNT.
                '''
        }
        { bits: "10"
          name: err_processed
          desc: '''When error occurs and one of the state machine stays at
                 Error handling state, SW may process the error based on
                 ERR_CODE, then let FSM back to the reset state
                '''
        } // f: err_processed
      ]
    } // R: CMD
    { name: "STATUS"
      desc: '''KMAC/SHA3 Status register.'''
      swaccess: "ro"
      hwaccess: "hwo"
      hwext: "true"
      fields: [
        { bits: "0"
          name: "sha3_idle"
          desc: "If 1, SHA3 hashing engine is in idle state."
          resval: "1"
        }
        { bits: "1"
          name: "sha3_absorb"
          desc: "If 1, SHA3 is receiving message stream and processing it"
        }
        { bits: "2"
          name: "sha3_squeeze"
          desc: '''If 1, SHA3 completes sponge absorbing stage.
                In this stage, SW can manually run the hashing engine.
                '''
        }
        { bits: "3"
          name: "sha3_stopped"
          desc: '''If 1, SHA3 has stopped the sponge absorbing stage for a
                context switch. In this stage, SW can read the !!STATE to save
                the context. The absorbing stage is resumed by restoring the
                !!STATE and issuing the `continue` command.
                '''
        }
        { bits: "4"
          name: "state_write"
          desc: '''If 1, SW has claimed the KMAC HWIP with the `state_write`
                command and writes to !!STATE are accepted. SW must poll this
                bit after issuing the command and before writing the context.

                The bit clears again when SW leaves the state with the
                `continue` or the `done` command.
                '''
        }
        { bits: "12:8"
          name: "fifo_depth"
          desc: "Count of occupied entries in the message FIFO."
        }
        { bits: "14"
          name: "fifo_empty"
          desc: '''Message FIFO Empty indicator.

            The FIFO's `Pass` parameter is set to `1'b 1`. So, by default, if
            the SHA engine is ready, the write data to FIFO just passes
            through.

            In this case, `fifo_depth` remains **0**. `fifo_empty`, however,
            lowers the value to **0** for a cycle, then goes back to the empty
            state, **1**.

            See the "Message FIFO" section in the spec for the reason.
            '''
          resval: "1"
        }
        { bits: "15"
          name: "fifo_full"
          desc: "Message FIFO Full indicator"
        }
        { bits: "20"
          name: "entropy_ready"
          desc: '''If 1, the internal PRNG is ready.
                If 0, the internal PRNG is either not operating in EDN Mode or Software Mode (i.e., Entropy Boot Mode is active), or the PRNG is currently performing a reseed operation via EDN or waiting for software to provide a new seed via !!ENTROPY_SEED.
                While this bit reads 0, the module will reject KMAC mode operation:
                - If software tries to trigger a KMAC mode operation, a `ErrSwHashingWithoutEntropyReady` error is returned.
                - If an application interface tries to trigger a KMAC mode operation, a `service rejected error` is returned.

                If masking is disabled, this bit matches the inverse of the !!ENTROPY_CFG_SHADOWED.entropy_boot_mode bit.
                '''
          resval: "0"
        }
        { bits: "21"
          name: "entropy_reseeding"
          desc: '''If 1, the internal PRNG is currently performing a reseed operation via EDN or waiting for software to provide a new seed.

                If masking is disabled, this bit always reads as 0.
                '''
          resval: "0"
        }
        { bits: "28",
          name: "ALERT_FATAL_FAULT",
          resval: "0",
          desc: '''
            No fatal fault has occurred inside the KMAC unit (0).
            A fatal fault has occurred and the KMAC unit needs to be reset (1),
            Examples for such faults include
            i) TL-UL bus integrity fault
            ii) storage errors in the shadow registers
            iii) errors in the message, round, or key counter
            iv) any internal FSM entering an invalid state
            v) an error in the redundant lfsr
          '''
        }
        { bits: "29",
          name: "ALERT_RECOV_CTRL_UPDATE_ERR",
          resval: "0",
          desc: '''
            An update error has not occurred (0) or has occurred (1) in the shadowed Control Register.
            KMAC operation needs to be restarted by re-writing the Control Register.
          '''
        }
      ]
    } // R: STATUS
    { name: "ENTROPY_CFG_LOCK"
      desc: '''
            Software lock for the !!ENTROPY_CFG_SHADOWED register.

            By setting this register to 1, software can lock the current content of the !!ENTROPY_CFG_SHADOWED register until the next reset.
            '''
      swaccess: "rw1s"
      hwaccess: "hro"
      fields: [
        { bits: "0"
          desc: '''
                This bit indicates whether software has locked the current content of the !!ENTROPY_CFG_SHADOWED register (1) or not (0).
                Whether the !!ENTROPY_CFG_SHADOWED register can be updated, is indicated in !!ENTROPY_CFG_REGWEN.
                Once this bit is set to 1, !!ENTROPY_CFG_REGWEN keeps reading as 0 until the next reset.
                '''
          resval: "0"
          tags: [// Setting this bit permanently blocks updates to the ENTROPY_CFG_SHADOWED register.
                 "excl:CsrAllTests:CsrExclWrite"]
        }
      ]
    } // R : ENTROPY_CFG_LOCK
    { name: "ENTROPY_CFG_REGWEN"
      desc: "Register write enable for !!ENTROPY_CFG_SHADOWED register."
      swaccess: "ro"
      hwaccess: "hwo"
      fields: [
        { bits: "0"
          desc: '''
                This bit indicates whether the !!ENTROPY_CFG_SHADOWED register can be updated by software (1) or not (0).
                If !!ENTROPY_CFG_LOCK is 1, this bit reads as 0.
                This bit also reads 0 if the internal PRNG is currently being reseeded or if the Keccak core is operating as indicated in the !!STATUS register.
                '''
          resval: "1"
        }
      ]
    } // R : ENTROPY_CFG_REGWEN
    { name: "ENTROPY_CFG_SHADOWED"
      desc: '''Entropy Configuration register.

            This register can only be updated when the Keccak core is idle and if write access has not yet been locked down.
            This is indicated by !!ENTROPY_CFG_REGWEN reading as 1.
            If !!ENTROPY_CFG_REGWEN reads as 0 (meaning the Keccak core is busy and/or write access has been locked down), writes to this register are ignored.

            If masking is disabled, only the Entropy Boot Mode field of this register is relevant and the remaining fields are ignored.
            '''
      regwen:   "ENTROPY_CFG_REGWEN"
      swaccess: "rw"
      hwaccess: "hro"
      shadowed: "true"
      update_err_alert:  "recov_operation_err"
      storage_err_alert: "fatal_fault_err"
      fields: [
        { bits: 0
          name: entropy_boot_mode
          swaccess: rw0c
          resval: 1
          desc: '''Entropy Boot Mode

                If this field reads 1, the internal pseudo-random number generator (PRNG) is operating in boot mode irrespective of the value of !!ENTROPY_CFG.entropy_mode.
                The sole purpose of the Entropy Boot Mode is to enable the initial ROM_CTRL operation right after coming out of reset.

                In this mode, the internal PRNG is not reseeded with fresh entropy, nor updated while the Keccak core operates.
                It should therefore not be used after this very initial boot phase and software should disable the Entropy Boot Mode and configure the desired !!ENTROPY_CFG.entropy_mode value as early as possible.
                '''
          tags: [// Clearing this bit temporarily blocks further updates to the register.
                 "excl:CsrAllTests:CsrExclWrite"]
        }
        { bits: 1
          name: entropy_mode
          desc: '''Entropy Mode

                Using this field, software can configure the non-boot mode of operation of the internal pseudo-random number generator (PRNG).

                The value of this field is only relevant if !!ENTROPY_CFG.entropy_boot_mode reads as 0.
                '''

          enum: [
            { value: "0"
              name: "edn_mode"
              desc: '''Receive fresh entropy from EDN for reseeding the internal PRNG.

                    This entropy mode is to be used for regular operation.

                    When this mode is activated first after reset, the !!STATUS.entropy_reseeding bit is set to 1 and the module requests fresh entropy from EDN for reseeding the internal PRNG.
                    Once the reseed operation finishes, the !!STATUS.entropy_ready bit is set to 1 and the module can start processing commands.
                    Depending on !!CFG_SHADOWED, the internal PRNG is then used for (re-)masking inputs (prefix, key, message) and intermediate results of the Keccak core.

                    The module will then automatically reseed the internal PRNG with fresh entropy from EDN every !!ENTROPY_CFG_SHADOWED.edn_mode_refresh_threshold messages in KMAC mode.
                    More precisely, automatic reseed operations are always triggered directly after the key absorption phase.
                    How close the module is to automatically trigger a reseed operation can be inferred from !!ENTROPY_REFRESH_HASH_CNT.
                    Alternatively, software can manually initiate reseeding operations using !!CMD.entropy_req while the module is idle.
                    This will also clear !!ENTROPY_REFRESH_HASH_CNT.

                    Depending on the state of the system, it may take a very long or even indefinite time for the entropy to be delivered.
                    For guidance, refer to [EDN Entropy Mode](programmers_guide.md#edn-entropy-mode).

                    To change from this mode to `sw_mode`, software has to first configure the mode and then trigger a reseed operation using !!CMD.entropy_req.
                    '''
            }
            { value: "1"
              name: "sw_mode"
              desc: '''Receive entropy from software for reseeding the internal PRNG.

                    This entropy mode is a fall-back option to be used if the entropy complex is not available.

                    When this mode is activated first after reset, the !!STATUS.entropy_reseeding bit is set to 1 and the module waits for software to write the !!ENTROPY_SEED register 6 times.
                    Upon each write, the written value is loaded into the corresponding state chunk of the PRNG.
                    After the last write operation, the !!STATUS.entropy_ready bit is set to 1 and the module can start processing commands.
                    Depending on !!CFG_SHADOWED, the internal PRNG is then used for (re-)masking inputs (prefix, key, message) and intermediate results of the Keccak core.

                    After this point, software can manually initiate reseeding operations using !!CMD.entropy_req while the module is idle.
                    This will also clear !!ENTROPY_REFRESH_HASH_CNT.

                    To change from this mode to `edn_mode`, software has to first configure the mode and then trigger a reseed operation using !!CMD.entropy_req.
                    '''
            }
          ]
        }
        { bits: "2"
          name: ignore_cmd_entropy_req
          desc: '''
                If this bit is set, writes to !!CMD.entropy_req are ignored.
                This can be useful for locking down the PRNG configuration and prevent further reseed operations, e.g., if later software stages aren't trusted.
                '''
        }
        { bits: "16+HashCntW-1:16"
          name: edn_mode_refresh_threshold
          desc: '''EDN Mode Refresh Threshold

                The number of KMAC messages after which the module automatically triggers a reseed operation when running in EDN Mode.
                Note that the automatic reseed operation is not triggered when ending the message processing, but after processing the KMAC key block.
                If an automatic reseed operation is triggered, the Keccak core can continue processing the message in parallel to the reseed operation.

                If this field reads as 0, no automatic reseed operations are triggered in EDN Mode.
                '''
        }
      ]
      tags: ["shadowed_reg_path:u_entropy_cfg_reg_shadowed"]
    } // R: ENTROPY_CFG_SHADOWED
    {
      name: "ENTROPY_SEED"
      desc: '''Entropy Seed

            Entropy seed register for the internal PRNG.

            If !!ENTROPY_CFG_SHADOWED.entropy_boot_mode reads 0, if !!ENTROPY_CFG_SHADOWED.entropy_mode is set to `sw_mode`, and if !!STATUS.entropy_reseeding reads 1, software can write this register 6 times.
            Upon each write, the written value is loaded into the corresponding state chunk of the internal PRNG.

            After writing the register 6 times, the !!STATUS.entropy_reseeding bit drops to 0, the PRNG is ready to deliver randomness to the Keccak core which is indicated by the !!STATUS.entropy_ready bit being set.
            After this point, another reseed operation can be initiated via !!CMD.entropy_req.
            '''
      hwext: "true"
      hwqe : "true"
      swaccess: "wo"
      hwaccess: "hro"
      fields: [
        { bits: "31:0"
          name: "seed"
          desc: "32-bit chunk of the entropy generator seed"
        }
      ]
    } // R: ENTROPY_SEED
    {
      name: "ENTROPY_REFRESH_HASH_CNT"
      desc: '''Entropy Refresh Counter

      KMAC entropy can be refreshed after the given threshold KMAC operations
      run. If the KMAC hash counter !!ENTROPY_REFRESH_HASH_CNT hits (GTE) the
      configured threshold !!ENTROPY_CFG_SHADOWED.edn_mode_refresh_threshold, the entropy
      module in the KMAC IP requests new seed to EDN and reset the KMAC
      hash counter.

      If the threshold is 0, the refresh by the counter does not work. And the
      counter is only reset by the CMD.hash_cnt_clr CSR bit.
      '''
      swaccess: "ro"
      hwaccess: "hwo"
      fields: [
        { bits: "HashCntW-1:0"
          name: "hash_cnt"
          desc: "Hash (KMAC) counter"
        }
      ]
    } // R: ENTROPY_REFRESH_HASH_CNT
    { multireg: {
        name: "KEY_SHARE0"
        desc: '''KMAC Secret Key

              KMAC secret key can be up to 512 bit.
              Order of the secret key is:
              key[512:0] = {KEY15, KEY14, ... , KEY0};

              The registers are allowed to be updated when the engine is in Idle state.
              If the engine computes the hash, it discards any attempts to update the secret keys
              and report an error.

              Current KMAC supports up to 512 bit secret key. It is the sw
              responsibility to keep upper bits of the secret key to 0.
              '''
        count: "NumWordsKey"
        cname: "KMAC"
        hwext: "true"
        hwqe : "true"
        swaccess: "wo"
        hwaccess: "hro"
        regwen:   "CFG_REGWEN"
        fields: [
          { bits: "31:0"
            name: "key"
            desc: "32-bit chunk of up-to 512-bit Secret Key"
          }
        ]
      } // R: KEY_SHARE0
    } // multireg: KEY_SHARE0
    { multireg: {
        name: "KEY_SHARE1"
        desc: '''KMAC Secret Key, 2nd share.

              KMAC secret key can be up to 512 bit.
              Order of the secret key is:
              key[512:0] = {KEY15, KEY14, ... , KEY0};

              The registers are allowed to be updated when the engine is in Idle state.
              If the engine computes the hash, it discards any attempts to update the secret keys
              and report an error.

              Current KMAC supports up to 512 bit secret key. It is the sw
              responsibility to keep upper bits of the secret key to 0.
              '''
        count: "NumWordsKey"
        cname: "KMAC"
        hwext: "true"
        hwqe : "true"
        swaccess: "wo"
        hwaccess: "hro"
        regwen:   "CFG_REGWEN"
        fields: [
          { bits: "31:0"
            name: "key"
            desc: "32-bit chunk of up-to 512-bit Secret Key"
          }
        ]
      } // R: KEY_SHARE1
    } // multireg: KEY_SHARE1
    { name: "KEY_LEN"
      desc: '''Secret Key length in bit.

            This value is used to make encoded secret key in KMAC.
            KMAC supports certain lengths of the secret key. Currently it
            supports 128b, 192b, 256b, 384b, and 512b secret keys.
            '''
      regwen: "CFG_REGWEN"
      swaccess: "wo"
      hwaccess: "hro"
      hwext: "false"
      fields: [
        { bits: "2:0"
          name: "len"
          desc: "Key length choice"
          enum: [
            { value: "0"
              name:  "Key128"
              desc: "Key length is 128 bit."
            }
            { value: "1"
              name:  "Key192"
              desc: "Key length is 192 bit."
            }
            { value: "2"
              name:  "Key256"
              desc: "Key length is 256 bit."
            }
            { value: "3"
              name:  "Key384"
              desc: "Key length is 384 bit."
            }
            { value: "4"
              name:  "Key512"
              desc: "Key length is 512 bit."
            }
          ]
        } // f : len
      ]
    } // R : KEY_LEN
    { multireg: {
        name: "PREFIX"
        desc: '''cSHAKE Prefix register.

              Prefix including Function Name N and Customization String S.
              The SHA3 assumes this register value is encoded as:
              `encode_string(N) || encode_string(S) || 0`. It means that the
              software can freely decide the length of N or S based on the
              given Prefix register size 320bit. 320bit is determined to have
              32-bit of N and up to 256-bit of S + encode of their length.

              It is SW responsibility to fill the register with encoded value
              that is described at Section 2.3.2 String Encoding in NIST SP
              800-185 specification.

              Order of Prefix is:
              prefix[end:0] := {PREFIX(N-1), ..., PREFIX(1), PREFIX(0) }

              The registers are allowed to be updated when the engine is in Idle state.
              If the engine computes the hash, it discards any attempts to update the secret keys
              and report an error.
              '''
        count: "NumWordsPrefix"
        cname: "KMAC"
        hwext: "false"
        swaccess: "rw"
        hwaccess: "hro"
        regwen:   "CFG_REGWEN"
        fields: [
          { bits: "31:0"
            name: "prefix"
            desc: "32-bit chunk of Encoded NS Prefix"
          }
        ]
      } // R: PREFIX
    } // multireg: PREFIX
    { name: "ERR_CODE"
      desc: "KMAC/SHA3 Error Code",
      swaccess: "ro",
      hwaccess: "hwo",
      fields: [
        { bits: "31:0",
          name: "err_code",
          desc: '''
                If the `kmac_err` interrupt occurs, this register has information on the error cause.
                Bits 31:24 contain the error code (please refer to `err_code_e` in `hw/ip/kmac/rtl/kmac_pkg.sv`) for the encoding, and bits 23:0 contain additional debug information.
                This register does *not* get cleared when the `kmac_err` interrupt state gets cleared.
                '''
          tags: [// Randomly write mem will cause this reg updated by design
                 "excl:CsrNonInitTests:CsrExclWriteCheck"]
        }
      ]
    } // R: ERR_CODE
    { skipto: "0x400"}
    { window: {
        name: "STATE"
        items: "128"  // 512B address space
        swaccess: "rw"
        desc: '''Keccak State (1600 bit) memory.

              The software can get the processed digest by reading this memory
              region. Unlike MSG_FIFO, STATE memory space sees the addr[9:0].
              If Masking feature is enabled, the software reads two shares from
              this memory space.

              Software can write to the register to restore a previously saved
              context. Writes are only accepted once software claimed the KMAC
              HWIP with the `state_write` command and while the hashing engine
              is idle, which !!STATUS.state_write reports. Writes at any other
              time are acknowledged on the bus and ignored.

              Writes must be full 32-bit word writes. Sub-word writes are
              answered with a bus error, as a partial write cannot be applied
              to the Keccak state.

              0x400 - 0x4C7: State share
              0x500 - 0x5C7: Mask share of the state, 0 if EnMasking = 0
              '''
      }
    } // W: STATE

    { skipto: "0x800"}

    { window: {
        name: "MSG_FIFO"
        items: "512"     // 2kB range
        swaccess: "wo"
        byte-write: "true"
        desc: '''Message FIFO.

              Any write operation to this window will be appended to MSG_FIFO. SW can
              simply write bytes/words to any address within this address range.
              Ordering and packing of the incoming bytes/words are handled
              internally. Therefore, the least significant 12 bits of the address
              are ignored.
              '''
      }
    } // W: MSG_FIFO
  ]
}
