// Copyright lowRISC contributors (OpenTitan project).
// Licensed under the Apache License, Version 2.0, see LICENSE for details.
// SPDX-License-Identifier: Apache-2.0
{ name:               "csrng",
  human_name:         "Cryptographically Secure Random Number Generator",
  one_line_desc:      "Takes entropy bits to produce cryptographically secure random numbers for consumption by hardware blocks and by software",
  one_paragraph_desc: '''
  Cryptographically Secure Random Number Generator (CSRNG) consumes random seeds from Entropy Source and generates random numbers for separate application interface contexts, such as multiple entropy distribution networks and software.
  When used in fully deterministic mode, the random numbers are generated just based on seeds provided by the application input.
  CSRNG targets compliance with [BSI's AIS31 recommendations for Common Criteria (CC)][bsi-ais31] as well as NIST's [SP 800-90A][nist-sp-800-90a] and [SP 800-90C][nist-sp-800-90c].
  Internally, it uses the CTR_DRBG construction with a security strength of 256 bits as specified by [SP 800-90A][nist-sp-800-90a].

  [bsi-ais31]: https://www.bsi.bund.de/SharedDocs/Downloads/DE/BSI/Zertifizierung/Interpretationen/AIS_31_Functionality_classes_for_random_number_generators_e.pdf
  [nist-sp-800-90a]: https://nvlpubs.nist.gov/nistpubs/SpecialPublications/NIST.SP.800-90Ar1.pdf
  [nist-sp-800-90c]: https://csrc.nist.gov/CSRC/media/Publications/sp/800-90c/draft/documents/sp800_90c_second_draft.pdf
  '''
  // Unique comportable IP identifier defined under KNOWN_CIP_IDS in the regtool.
  cip_id:             "5",
  design_spec:        "../doc",
  dv_doc:             "../doc/dv",
  hw_checklist:       "../doc/checklist",
  sw_checklist:       "/sw/device/lib/dif/dif_csrng",
  version:            "3.0.0",
  life_stage:         "L1",
  design_stage:       "D2",
  verification_stage: "V1",
  dif_stage:          "S2",
  clocking: [{clock: "clk_i", reset: "rst_ni"}],
  bus_interfaces: [
    { protocol: "tlul", direction: "device" }
  ],
  param_list: [
    // Random netlist constants
    { name:      "RndCnstCsKeymgrDivNonProduction",
      desc:      "Compile-time random bits for csrng state group diversification value",
      type:      "csrng_pkg::cs_keymgr_div_t",
      randcount: "384",
      randtype:  "data",
    }
    { name:      "RndCnstCsKeymgrDivProduction",
      desc:      "Compile-time random bits for csrng state group diversification value",
      type:      "csrng_pkg::cs_keymgr_div_t",
      randcount: "384",
      randtype:  "data",
    }
    // Regular parameters
    { name: "SBoxImpl",
      type: "aes_pkg::sbox_impl_e",
      default: "aes_pkg::SBoxImplCanright",
      desc: "Selection of the S-Box implementation. See aes_pkg.sv.",
      local: "false",
      expose: "true"
    },
    # Note: All parameters below are local, they are not actually configurable.
    # Selecting values different from the default values below might cause undefined behavior.
    { name:    "NumApps",
      type:    "int",
      default: "3",
      desc:    "Number of application interfaces",
      local:   "true"
    },
  ],
  interrupt_list: [
    { name: "cs_cmd_req_done"
      desc: "Asserted when a command request is completed, or when a CSRNG instance halted via INT_STATE_HALT has quiesced."}
    { name: "cs_entropy_req"
      desc: "Asserted when an instantiate or reseed command requiring entropy is blocked because no seed is available."}
    { name: "cs_hw_inst_exc"
      desc: "Asserted when a hardware-attached CSRNG instance encounters a command exception"}
    { name: "cs_fatal_err"
      desc: "Asserted when a FIFO error or a fatal alert occurs. Check the !!ERR_CODE register to get more information."}
  ],
  alert_list: [
    { name: "recov_alert",
      desc: "This alert is triggered when a recoverable alert occurs.  Check the !!RECOV_ALERT_STS register to get more information."
    }
    { name: "fatal_alert",
      desc: '''
            This alert triggers (i) if an illegal state machine state is reached, or
            (ii) if an AES fatal alert condition occurs, or (iii) if a fatal integrity
            failure is detected on the TL-UL bus, or (iv) if a FIFO error is detected while
            CSRNG is enabled.
            '''
    }
  ],
  inter_signal_list: [
    { struct:  "csrng"
      type:    "req_rsp"
      name:    "csrng_cmd"
      act:     "rsp"
      package: "csrng_pkg"
      width:   "2",
    }
    { struct:  "entropy_src_hw_if"
      type:    "req_rsp",
      name:    "entropy_src_hw_if"
      act:     "req"
      package: "entropy_src_pkg"
    }
    { struct:  "lc_tx"
      type:    "uni"
      name:    "lc_hw_debug_en"
      act:     "rcv"
      default: "lc_ctrl_pkg::Off"
      package: "lc_ctrl_pkg"
    }
  ],
  features: [
    {
      name: "CSRNG.INTERFACE.SOFTWARE",
      desc: '''
            CSRNG has an application interface for the software to interact with.

            Note that for software to actually retrieve random numbers from this interface, !!CTRL.SW_APP_ENABLE needs to be set to `kMultiBitBool4True`.
            Otherwise the !!GENBITS register always reads 0.
            '''
    }
    {
      name: "CSRNG.INTERFACE.HARDWARE0",
      desc: "CSRNG has an application interface intended for hardware; this interface is labelled zero."
    }
    {
      name: "CSRNG.INTERFACE.HARDWARE1",
      desc: "CSRNG has an application interface intended for hardware; this interface is labelled one."
    }
    {
      name: "CSRNG.MODE.DETERMINISTIC",
      desc: "CSRNG can be set up to deterministically generate the same sequence of random values by using a fixed seed."
    }
    {
      name: "CSRNG.MODE.NONDETERMINISTIC",
      desc: "CSRNG can be set up to generate non-deterministic random values by using a random seed from the entropy source."
    }
    {
      name: "CSRNG.HALT",
      desc: '''
            CSRNG allows software to halt a selected instance via !!INT_STATE_HALT without affecting other instances.
            Halting can be enabled per instance via !!INT_STATE_HALT_ENABLE.
            '''
    }
    {
      name: "CSRNG.GENERATE_ABORT",
      desc: '''
            CSRNG allows software to abort a Generate command in progress via !!GEN_ABORT.
            The aborted instance is uninstantiated.
            '''
    }
    {
      name: "CSRNG.SAVE_AND_RESTORE",
      desc: '''
            CSRNG allows the internal state of a selected instance to be read out or overwritten via !!INT_STATE_VAL.
            This is useful for debugging and validation testing, as well as for context save/restore.
            '''
    }
    {
      name: "CSRNG.LIFECYCLE.DEBUGENABLE",
      desc: '''
            CSRNG has a debug enable signal, which allows for seed diversification.
            Depending on this value it will use the non-production seed constant or the production seed constant.
            This state is controlled by the life-cycle controller and so debug is enabled only in test mode.
            '''
    }
  ],
  countermeasures: [
    { name: "CONFIG.REGWEN"
      desc: "Registers are protected from writes."
    }
    { name: "CONFIG.MUBI"
      desc: "Registers have multi-bit encoded fields."
    }
    { name: "CMD_STAGE.FSM.SPARSE"
      desc: "The CSRNG command stage state machines use a sparse state encoding."
    }
    { name: "MAIN_SM.FSM.SPARSE"
      desc: "The CSRNG main state machine uses a sparse state encoding."
    }
    { name: "CTR_DRBG.FSM.SPARSE"
      desc: "The CTR DRBG state machine uses a sparse state encoding."
    }
    { name: "CTR_DRBG.CTR.REDUN"
      desc: "The ctr_drbg algorithm uses a counter that is protected by a second counter that counts in the opposite direction."
    }
    { name: "STATE_DB.CTR.REDUN"
      desc: "The !!INT_STATE_VAL word pointer uses a counter that is protected by a second counter that counts in the opposite direction."
    }
    { name: "CTRL.MUBI"
      desc: "Multi-bit field used for selection control."
    }
    { name: "MAIN_SM.CTR.LOCAL_ESC"
      desc: "A mismatch detected inside any CSRNG counter moves the  main state machine into a terminal error state."
    }
    { name: "CONSTANTS.LC_GATED"
      desc: "Seed diversification based on the lifecycle state."
    }
    { name: "SW_GENBITS.BUS.CONSISTENCY"
      desc: "Comparison on successive bus values for genbits returned on the software channel."
    }
    { name: "TILE_LINK.BUS.INTEGRITY"
      desc: "Tilelink end-to-end bus integrity scheme."
    }
    { name: "AES_CIPHER.FSM.SPARSE",
      desc: '''
        The AES cipher core FSM uses a sparse state encoding.
        See the AES module documentation for AES-specific countermeasures.
      '''
    }
    { name: "AES_CIPHER.FSM.REDUN",
      desc: '''
        The AES cipher core FSM uses multiple, independent logic rails.
        See the AES module documentation for AES-specific countermeasures.
      '''
    }
    { name: "AES_CIPHER.CTRL.SPARSE",
      desc: '''
        Critical control signals for the AES cipher core such as handshake and MUX control signals use sparse encodings.
        See the AES module documentation for AES-specific countermeasures.
      '''
    }
    { name: "AES_CIPHER.FSM.LOCAL_ESC",
      desc: '''
        The AES cipher core FSM moves to a terminal error state upon local escalation.
        Can be triggered by AES_CIPHER.FSM.SPARSE, AES_CIPHER.FSM.REDUN, AES_CIPHER.CTR.REDUN and AES_CIPHER.CTRL.SPARSE.
        See the AES module documentation for AES-specific countermeasures.
      '''
    }
    { name: "AES_CIPHER.CTR.REDUN",
      desc: '''
        The AES round counter inside the AES cipher core FSM is protected with multiple, independent logic rails.
        See the AES module documentation for AES-specific countermeasures.
      '''
    }
    { name: "AES_CIPHER.DATA_REG.LOCAL_ESC",
      desc: '''
        Upon local escalation, the AES cipher core doesn't output intermediate state.
        See the AES module documentation for AES-specific countermeasures.
      '''
    }
  ],
  regwidth: "32",
  registers: [
    { name: "REGWEN",
      desc: "Register write enable for all control registers",
      swaccess: "rw0c",
      hwaccess: "none",
      fields: [
        {
            bits: "0",
            desc: ''' When true, all writeable registers can be modified.
            When false, they become read-only.
            '''
            resval: 1
        }
      ]
    },
    { name: "CTRL",
      desc: "Control register",
      swaccess: "rw",
      hwaccess: "hro",
      regwen: "REGWEN",
      tags: [// Keep HW from affecting other registers.
                 "excl:CsrAllTests:CsrExclWrite"]
      fields: [
        {
            bits: "3:0",
            name: "ENABLE",
            mubi: true
            desc: '''
                  Setting this field to kMultiBitBool4True will enable the CSRNG module. The modules
                  of the entropy complex may only be enabled and disabled in a specific order, see
                  Programmers Guide for details.
                  '''
          resval: false
        },
        {
            bits: "7:4",
            name: "SW_APP_ENABLE",
            mubi: true
            desc: '''
                  Setting this field to kMultiBitBool4True will enable reading from the !!GENBITS register.
                  '''
          resval: false
        },
        {
            bits: "11:8",
            name: "READ_INT_STATE",
            mubi: true
            desc: '''
                  Setting this field to kMultiBitBool4True will enable reading the internal state via !!INT_STATE_VAL.
                  Also, the !!INT_STATE_READ_ENABLE bit of the selected instance needs to be set to true for this to work.
                  '''
          resval: false
        },
        {
            bits: "15:12",
            name: "WRITE_INT_STATE",
            mubi: true
            desc: '''
                  Setting this field to kMultiBitBool4True will enable writing the internal state via !!INT_STATE_VAL.
                  Also, the !!INT_STATE_WRITE_ENABLE bit of the selected instance needs to be set to true for this to work.
                  '''
          resval: false
        },
        { bits: "19:16",
          name: "FIPS_FORCE_ENABLE",
          mubi: true
          desc: '''
                Setting this field to kMultiBitBool4True enables forcing the FIPS/CC compliance flag to true via the !!FIPS_FORCE register.
                '''
          resval: false
        },
      ]
    },
    {
      name: "CMD_REQ",
      desc: "Command request register",
      swaccess: "wo",
      hwaccess: "hro",
      hwqe: "true",
      fields: [
        { bits: "31:0",
          name: "CMD_REQ",
          desc: '''
                Writing this request with defined CSRNG commands will initiate all
                possible CSRNG actions. The application interface must wait for the
                "ack" to return before issuing new commands.
                Before writing each word of a command, !!SW_CMD_STS.CMD_RDY needs to be polled.
                '''
        }
      ]
    },
    { name: "RESEED_INTERVAL",
      desc: "CSRNG maximum number of generate requests allowed between reseeds register",
      swaccess: "rw",
      hwaccess: "hro",
      hwqe: "true",
      fields: [
        { bits: "31:0",
          name: "RESEED_INTERVAL",
          desc: '''
                Setting this field will set the number of generate requests that can be
                made to CSRNG before a reseed request needs to be made.
                This register supports a maximum of 2^32 requests between reseeds.
                This register will be compared to a counter, which counts the number of
                generate commands between reseed or instantiate commands.
                If the counter reaches the value of this register, the violating command
                will be acknowledged with a status error.
                If the violating command was issued by a HW instance, an interrupt will
                be triggered.
                '''
          resval: 0xffff_ffff
        }
      ]
    },
    { multireg: {
      name: "RESEED_COUNTER",
      desc: '''
        Reseed counter.

        The per-instance reseed counter indicates the number of Generate requests that have been completed since new entropy input has been obtained with an Instantiate or a Reseed command.
      '''
      count: "NumApps",
      cname: "RESEED_COUNTER",
      swaccess: "ro",
      hwaccess: "hwo",
      hwext:    "true",
      fields: [
        { bits: "31:0",
          name: "RESEED_COUNTER",
          desc: "Reseed Counter indicating the number of completed Generate requests since the last Instantiate or Reseed command."
          resval: "0",
        }
      ],
      },
    },
    {
      name: "SW_CMD_STS",
      desc: "Application interface command status register",
      swaccess: "ro",
      hwaccess: "hwo",
      tags: [// Internal HW can modify status register
                 "excl:CsrNonInitTests:CsrExclCheck"]
      fields: [
        { bits: "1",
          name: "CMD_RDY",
          desc: '''
                This bit indicates when the command interface is ready to accept the next command word.
                Before writing each word of a command to !!CMD_REQ, this field needs to be polled.
                Words written while this field is low are dropped, set !!ERR_CODE.SFIFO_CMD_ERR and
                !!ERR_CODE.FIFO_WRITE_ERR, and trigger a fatal alert.
                0b0: CSRNG is not ready to accept the next command word or the last command hasn't been acked yet.
                0b1: CSRNG is ready to accept the next command word.
                '''
          resval: "0"
        }
        { bits: "2",
          name: "CMD_ACK",
          desc: '''
                This one bit field indicates when a SW command has been acknowledged by the CSRNG.
                It is set to low each time a new command is written to !!CMD_REQ.
                The field is set to high once a SW command request has been acknowledged by the CSRNG.
                0b0: The last SW command has not been acknowledged yet.
                0b1: The last SW command has been acknowledged.
                In case of a generate command the acknowledgement goes high after all of the requested entropy is consumed.
                '''
          resval: "0"
        }
        { bits: "5:3",
          name: "CMD_STS",
          desc: '''
                This field represents the status code returned with the application command ack.
                It is updated each time a command ack is asserted on the internal application
                interface for software use.
                To check whether a command was successful, wait for !!INTR_STATE.CS_CMD_REQ_DONE or
                !!SW_CMD_STS.CMD_ACK to be high and then check the value of this field.
                '''
          resval: "0"
          enum: [
            { value: "0",
              name: "SUCCESS",
              desc: '''
                    Request completed successfully.
                    '''
            },
            { value: "1",
              name: "INVALID_ACMD",
              desc: '''
                    Request completed with an invalid application command error.
                    This error indicates that the issued application command doesn't represent a valid operation.
                    '''
            },
            { value: "2",
              name: "INVALID_GEN_CMD",
              desc: '''
                    Request completed with an invalid Generate command error.
                    This error indicates that a Generate command was issued with a `glen` field of zero.
                    The command is ignored and no entropy is generated.
                    '''
            },
            { value: "3",
              name: "INVALID_CMD_SEQ",
              desc: '''
                    This error indicates that the last command was issued out of sequence.
                    This happens when a command other than Instantiate was issued without sending an Instantiate command first.
                    This can also happen when an Uninstantiate command is sent without instantiating first.
                    '''
            },
            { value: "4",
              name: "RESEED_CNT_EXCEEDED",
              desc: '''
                    This error indicates that the number of generate requests between reseeds exceeded the maximum number allowed (see !!RESEED_INTERVAL).
                    This happens only for Generate commands.
                    '''
            },
            { value: "5",
              name: "GEN_ABORTED",
              desc: '''
                    This bit indicates that a Generate command for this instance was aborted via !!GEN_ABORT before returning all requested genbits.
                    The instance has been uninstantiated as a result and must be instantiated again before further commands will succeed.
                    This happens only for Generate commands.
                    '''
            },
          ]
        }
      ]
    },
    {
      name: "GENBITS_VLD",
      desc: "Generate bits returned valid register",
      swaccess: "ro",
      hwaccess: "hwo",
      hwext: "true",
      fields: [
        { bits: "0",
          name: "GENBITS_VLD",
          desc: "This bit is set when genbits are available on this application interface after a generate command has been issued."
        }
        { bits: "1",
          name: "GENBITS_FIPS",
          desc: "This bit is set when genbits are FIPS/CC compliant."
        }
      ]
    },
    {
      name: "GENBITS",
      desc: "Generate bits returned register",
      swaccess: "ro",
      hwaccess: "hrw",
      hwext: "true",
      hwre: "true",
      fields: [
        { bits: "31:0",
          name: "GENBITS",
          desc: '''
                Reading this register will get the generated bits that were requested with
                the generate request. This register must be read four times for each request
                made. For example, an application command generate request with
                a `clen` value of 4 requires this register to be read 16 times to get all
                of the data out of the FIFO path.
                Note that for !!GENBITS to be able to deliver random numbers, also !!CTRL.SW_APP_ENABLE needs to be set to `kMultiBitBool4True`.
                Otherwise, the register reads as 0.
                '''
        }
      ]
    },
    {
      name: "INT_STATE_READ_ENABLE_REGWEN",
      desc: "Internal state read enable REGWEN register",
      swaccess: "rw0c",
      hwaccess: "none",
      fields: [
        { bits: "0",
          desc: '''
                INT_STATE_READ_ENABLE register configuration enable bit.
                If this is cleared to 0, the INT_STATE_READ_ENABLE register cannot be written anymore.
                '''
          resval: 1,
        }
      ]
    },
    {
      name: "INT_STATE_READ_ENABLE",
      desc: "Internal state read enable register",
      swaccess: "rw",
      hwaccess: "hro",
      regwen: "INT_STATE_READ_ENABLE_REGWEN",
      fields: [
        { bits: "2:0",
          name: "INT_STATE_READ_ENABLE",
          desc: '''
                Per-instance internal state read enable.
                Defines whether the internal state of the corresponding instance can be read via !!INT_STATE_VAL.
                Reads for an instance whose bit is cleared return 0.
                Note that reading additionally requires !!CTRL.READ_INT_STATE to be set to `kMultiBitBool4True`.
                '''
          resval: 0x7
        }
      ]
    },
    { name: "INT_STATE_NUM_REGWEN",
      desc: "Internal state instance index REGWEN register",
      swaccess: "ro",
      hwaccess: "hwo",
      hwext: "true",
      tags: [// This regwen is completely under HW management and thus cannot be manipulated
             // by software.
             "excl:CsrNonInitTests:CsrExclCheck"]
      fields: [
        { bits: "0",
          desc: '''
                INT_STATE_NUM register configuration enable bit.
                This bit is cleared while !!INT_STATE_HALT is set to kMultiBitBool4True, so the selected instance cannot be changed while it is halted.
                '''
          resval: 1,
        }
      ]
    },
    { name: "INT_STATE_NUM",
      desc: "Internal state instance index register",
      swaccess: "rw",
      hwaccess: "hrw",
      hwext: "true",
      hwqe: "true",
      regwen: "INT_STATE_NUM_REGWEN",
      tags: [// Writes of reserved instance indices are ignored and affect RECOV_ALERT_STS.
             "excl:CsrAllTests:CsrExclWrite"]
      fields: [
        {
            bits: "3:0",
            name: "INT_STATE_NUM",
            desc: '''
                  Index of the CSRNG instance whose internal state is targeted via !!INT_STATE_VAL.
                  Valid indices are 0 to NumApps-1 (number of HW interfaces plus one for the SW interface).
                  Writes of a larger index are ignored and set !!RECOV_ALERT_STS.INT_STATE_NUM_INVALID_ALERT.
                  This register cannot be written while !!INT_STATE_NUM_REGWEN is cleared.
                  Writing this register also resets the read/write pointer of !!INT_STATE_VAL to the first word of the selected state.
                  This field also selects the instance targeted by !!INT_STATE_HALT and !!INT_STATE_STS.
                  '''
        },
      ]
    },
    {
      name: "INT_STATE_VAL",
      desc: "Internal state read/write access register",
      swaccess: "rw",
      hwaccess: "hrw",
      hwext: "true",
      hwre: "true",
      hwqe: "true",
      tags: [// Reads return the internal state and advance the word pointer, so they are not
             // predictable by the CSR tests.
             "excl:CsrNonInitTests:CsrExclCheck"]
      fields: [
        { bits: "31:0",
          name: "INT_STATE_VAL",
          desc: '''
                Reading this register will dump out the contents of the selected instance's internal state.
                Writing this register overwrites the state word by word as the writes arrive.
                Stopping before all 26 words have been written leaves the instance with a mix of restored and previous state words.
                The internal state comprises the CTR_DRBG state (key/V/reseed counter/fips/instantiated) as well as the state of a Generate command paused mid-sequence (remaining block count, Generate flag and additional data).
                Since this field is 816 bits wide, it will require 26 reads or writes of this register to access the entire field.
                Every read and every write advances the internal read/write pointer (selects 32 bits of the 816 bit field), which wraps around to zero after 26 accesses.
                Reads and writes share this pointer.
                Writing !!INT_STATE_NUM resets the pointer to zero, so every read or write sequence should be started by writing !!INT_STATE_NUM.

                Reserved bits are ignored on writes and read as 0.

                Reads are accepted regardless of whether the instance is halted.
                Restoring the state is only possible while the instance is halted.
                If the state is internally updated while an access sequence is in progress, !!RECOV_ALERT_STS.INT_STATE_OVERWRITE_ALERT is raised.
                To get a consistent snapshot, halt the instance via !!INT_STATE_HALT first.

                Note that for !!INT_STATE_VAL to provide read access to the internal state, !!CTRL.READ_INT_STATE needs to be set to `kMultiBitBool4True` and the !!INT_STATE_READ_ENABLE bit of the selected instance needs to be set.
                For write access, !!CTRL.WRITE_INT_STATE needs to be set to `kMultiBitBool4True`, the !!INT_STATE_WRITE_ENABLE bit of the selected instance needs to be set and !!INT_STATE_STS.HALTED needs to be set.
                Otherwise, the register reads as 0, writes are dropped and the pointer does not advance.
                '''
        }
      ]
    },
    {
      name: "FIPS_FORCE",
      desc: "FIPS/CC compliance flag forcing register",
      swaccess: "rw",
      hwaccess: "hro",
      regwen: "REGWEN",
      fields: [
        { bits: "2:0",
          name: "FIPS_FORCE",
          desc: '''
                Force the FIPS/CC compliance flag of individual instances to true.
                This allows CSRNG to set the output FIPS/CC compliance flag to true despite running in fully deterministic mode (flag0 being true).
                This can be useful e.g. for known-answer testing through entropy consumers accepting FIPS/CC compliant entropy only, or when firmware is used to derive FIPS/CC compliant entropy seeds.
                After setting a particular bit to 1, the FIPS/CC compliance flag of the corresponding instance will be forced to true upon the next Instantiate or Reseed command.

                Note that for this to work, !!CTRL.FIPS_FORCE_ENABLE needs to be set to kMultiBitBool4True.
                '''
        }
      ]
    },
    { name: "GEN_ABORT_REGWEN",
      desc: "Register write enable for !!GEN_ABORT",
      swaccess: "rw0c",
      hwaccess: "none",
      fields: [
        { bits: "0",
          desc: '''
                When true, the !!GEN_ABORT register can be written.
                When false, it becomes read-only until the next reset.
                '''
          resval: 1
        }
      ]
    },
    { multireg: {
      name: "GEN_ABORT",
      desc: "Generate command abort request register",
      count: "NumApps",
      cname: "GEN_ABORT",
      compact: false,
      swaccess: "rw1s",
      hwaccess: "hrw",
      regwen: "GEN_ABORT_REGWEN",
      tags: [// This register self-clears every cycle and a write can affect RECOV_ALERT_STS.
                 "excl:CsrAllTests:CsrExclWrite"]
      fields: [
        { bits: "3:0",
          name: "GEN_ABORT",
          mubi: true,
          resval: false,
          desc: '''
                Setting this field to kMultiBitBool4True requests aborting a Generate command that is currently in progress for this instance.
                The instance is zeroed as a result.
                It must be instantiated again before further Reseed, Update, or Generate commands can succeed.

                This request is only accepted while a Generate command is actually in progress for this instance.
                If no Generate command is in progress, the write is ignored and !!RECOV_ALERT_STS.GEN_ABORT_INVALID_ALERT is set instead.
                If the instance is halted via !!INT_STATE_HALT, the abort only takes effect once the instance is resumed.
                '''
        }
      ]
      }
    },
    { multireg: {
      name: "GEN_ABORT_STATUS",
      desc: "Generate command abort completion status register",
      count: "NumApps",
      cname: "GEN_ABORT_STATUS",
      compact: false,
      swaccess: "rw1c",
      hwaccess: "hwo",
      fields: [
        { bits: "0",
          name: "GEN_ABORT_STATUS",
          resval: false,
          desc: '''
                This bit is set when a Generate command abort requested via !!GEN_ABORT for this instance has completed.
                Write 1 to clear.
                '''
        }
      ]
      }
    },
    {
      name: "HW_EXC_STS",
      desc: "Hardware instance exception status register",
      swaccess: "rw0c",
      hwaccess: "hwo",
      fields: [
        { bits: "15:0",
          name: "HW_EXC_STS",
          desc: '''
                Reading this register indicates whether one of the CSRNG HW instances has
                encountered an exception.  Each bit corresponds to a particular hardware
                instance, with bit 0 corresponding to instance HW0, bit 1 corresponding
                to instance HW1, and so forth. (To monitor the status of requests made
                to the SW instance, check the !!SW_CMD_STS register). Writing a zero to this register
                resets the status bits.
                '''
        }
      ]
    },
    {
      name: "RECOV_ALERT_STS",
      desc: "Recoverable alert status register",
      swaccess: "rw0c",
      hwaccess: "hwo",
      fields: [
        { bits: "0",
          name: "ENABLE_FIELD_ALERT",
          desc: '''
                This bit is set when the ENABLE field in the !!CTRL register is set to
                a value other than kMultiBitBool4True or kMultiBitBool4False.
                Writing a zero resets this status bit.
                '''
        }
        { bits: "1",
          name: "SW_APP_ENABLE_FIELD_ALERT",
          desc: '''
                This bit is set when the SW_APP_ENABLE field in the !!CTRL register is set to
                a value other than kMultiBitBool4True or kMultiBitBool4False.
                Writing a zero resets this status bit.
                '''
        }
        { bits: "2",
          name: "READ_INT_STATE_FIELD_ALERT",
          desc: '''
                This bit is set when the READ_INT_STATE field in the !!CTRL register is set to
                a value other than kMultiBitBool4True or kMultiBitBool4False.
                Writing a zero resets this status bit.
                '''
        }
        { bits: "3",
          name: "WRITE_INT_STATE_FIELD_ALERT",
          desc: '''
                This bit is set when the WRITE_INT_STATE field in the !!CTRL register is set to
                a value other than kMultiBitBool4True or kMultiBitBool4False.
                Writing a zero resets this status bit.
                '''
        }
        { bits: "4",
          name: "FIPS_FORCE_ENABLE_FIELD_ALERT",
          desc: '''
                This bit is set when the FIPS_FORCE_ENABLE field in the !!CTRL register is set to a value other than kMultiBitBool4True or kMultiBitBool4False.
                Writing a zero resets this status bit.
                '''
        }
        { bits: "5",
          name: "ACMD_FLAG0_FIELD_ALERT",
          desc: '''
                This bit is set when the FLAG0 field in the Application Command is set to
                a value other than kMultiBitBool4True or kMultiBitBool4False.
                Writing a zero resets this status bit.
                '''
        }
        { bits: "6",
          name: "GEN_ABORT_INVALID_ALERT",
          desc: '''
                This bit is set when a field of the !!GEN_ABORT register is set to kMultiBitBool4True for an instance that does not currently have a Generate command in progress.
                The write is ignored and CSRNG continues to operate.
                Writing a zero resets this status bit.
                '''
        }
        { bits: "7",
          name: "GEN_ABORT_FIELD_ALERT",
          desc: '''
                This bit is set when a field of the !!GEN_ABORT register is set to a value other than kMultiBitBool4True or kMultiBitBool4False.
                Writing a zero resets this status bit.
                '''
        }
        { bits: "8",
          name: "INT_STATE_HALT_FIELD_ALERT",
          desc: '''
                This bit is set when the !!INT_STATE_HALT register is set to a value other than
                kMultiBitBool4True or kMultiBitBool4False.
                Writing a zero resets this status bit.
                '''
        }
        { bits: "9",
          name: "INT_STATE_OVERWRITE_ALERT",
          desc: '''
                This bit is set when CSRNG internally updates the state of the instance selected by !!INT_STATE_NUM while an access sequence via !!INT_STATE_VAL is in progress.
                A sequence starts with the first access to !!INT_STATE_VAL and ends with the 26th access, or earlier when it is aborted, e.g., when !!INT_STATE_NUM is written.
                The words read or written in that sequence may therefore be inconsistent.
                Writing a zero resets this status bit.
                '''
        }
        { bits: "10",
          name: "INT_STATE_NUM_INVALID_ALERT",
          desc: '''
                This bit is set when !!INT_STATE_NUM is written with the index of a reserved instance.
                The write is ignored and CSRNG continues to operate.
                This bit is also set if the selected instance is invalid, which can only be caused by a fault.
                Writing a zero resets this status bit.
                '''
        }
        { bits: "12",
          name: "CS_BUS_CMP_ALERT",
          desc: '''
                This bit is set when the software application port genbits bus value is equal
                to the prior valid value on the bus, indicating a possible attack.
                Writing a zero resets this status bit.
                '''
        }
        { bits: "13",
          name: "CMD_STAGE_INVALID_ACMD_ALERT",
          desc: '''
                This bit is set when an unsupported/illegal CSRNG command is received by the
                main state machine.
                The invalid command is ignored and CSRNG continues to operate.
                Writing a zero resets this status bit.
                '''
        }
        { bits: "14",
          name: "CMD_STAGE_INVALID_GEN_CMD_ALERT",
          desc: '''
                This bit is set when a Generate command is received with a `glen` field of zero.
                The invalid command is ignored and CSRNG continues to operate.
                Writing a zero resets this status bit.
                '''
        }
        { bits: "15",
          name: "CMD_STAGE_INVALID_CMD_SEQ_ALERT",
          desc: '''
                This bit is set when an out of order command is received by the main state machine.
                This happens when an instantiate command is sent for a state that was already
                instantiated or when any command other than instantiate is sent for a state that
                wasn't instantiated yet.
                The invalid command is ignored and CSRNG continues to operate.
                Writing a zero resets this status bit.
                '''
        }
        { bits: "16",
          name: "CMD_STAGE_RESEED_CNT_ALERT",
          desc: '''
                This bit is set when the maximum number of generate requests between reseeds is
                exceeded.
                The invalid generate command is ignored and CSRNG continues to operate.
                Writing a zero resets this status bit.
                '''
        }
      ]
    },
    {
      name: "ERR_CODE",
      desc: "Hardware detection of error conditions status register",
      swaccess: "ro",
      hwaccess: "hwo",
      fields: [
        { bits: "0",
          name: "SFIFO_CMD_ERR",
          desc: '''
                This bit will be set to one when an error has been detected for the
                command stage command FIFO. The type of error is reflected in the type status
                bits (bits 28 through 30 of this register).
                This includes words written to !!CMD_REQ while !!SW_CMD_STS.CMD_RDY is low.
                This bit will stay set until the next reset.
                '''
        }
        { bits: "1",
          name: "SFIFO_GENBITS_ERR",
          desc: '''
                This bit will be set to one when an error has been detected for the
                command stage genbits FIFO. The type of error is reflected in the type status
                bits (bits 28 through 30 of this register).
                This bit will stay set until the next reset.
                '''
        }
        { bits: "20",
          name: "CMD_STAGE_SM_ERR",
          desc: '''
                This bit will be set to one when an illegal state has been detected for the
                command stage state machine. This error will signal a fatal alert, and also
                an interrupt if enabled.
                This bit will stay set until the next reset.
                '''
        }
        { bits: "21",
          name: "MAIN_SM_ERR",
          desc: '''
                This bit will be set to one when an illegal state has been detected for the
                main state machine. This error will signal a fatal alert, and also
                an interrupt if enabled.
                This bit will stay set until the next reset.
                '''
        }
        { bits: "22",
          name: "CTR_DRBG_SM_ERR",
          desc: '''
                This bit will be set to one when an illegal state has been detected for the
                ctr_drbg state machine. This error will signal a fatal alert, and also
                an interrupt if enabled.
                This bit will stay set until the next reset.
                '''
        }
        { bits: "25",
          name: "AES_CIPHER_SM_ERR",
          desc: '''
                This bit will be set to one when an AES fatal error has been detected.
                This error will signal a fatal alert, and also an interrupt if enabled.
                This bit will stay set until the next reset.
                '''
        }
        { bits: "26",
          name: "CTR_ERR",
          desc: '''
                This bit will be set to one when a mismatch in any of the hardened counters
                has been detected.
                This error will signal a fatal alert, and also an interrupt if enabled.
                This bit will stay set until the next reset.
                '''
        }
        { bits: "28",
          name: "FIFO_WRITE_ERR",
          desc: '''
                This bit will be set to one when any of the source bits (bits 0 through 15 of this
                this register) are asserted as a result of an error pulse generated from
                any full FIFO that has received a write pulse, or from a word written to
                !!CMD_REQ while !!SW_CMD_STS.CMD_RDY is low.
                This bit will stay set until the next reset.
                '''
        }
        { bits: "29",
          name: "FIFO_READ_ERR",
          desc: '''
                This bit will be set to one when any of the source bits (bits 0 through 15 of this
                this register) are asserted as a result of an error pulse generated from
                any empty FIFO that has received a read pulse.
                This bit will stay set until the next reset.
                '''
        }
        { bits: "30",
          name: "FIFO_STATE_ERR",
          desc: '''
                This bit will be set to one when any of the source bits (bits 0 through 15 of this
                this register) are asserted as a result of an error pulse generated from
                any FIFO where both the empty and full status bits are set.
                This bit will stay set until the next reset.
                '''
        }
      ]
    },
    { name: "ERR_CODE_TEST",
      desc: "Test error conditions register",
      swaccess: "rw",
      hwaccess: "hro",
      hwqe: "true",
      regwen: "REGWEN",
      tags: [// Keep HW from affecting other registers.
                "excl:CsrAllTests:CsrExclWrite"]
      fields: [
        {
            bits: "4:0",
            name: "ERR_CODE_TEST",
            desc: '''
                  Setting this field will set the bit number for which an error
                  will be forced in the hardware. This bit number is that same one
                  found in the !!ERR_CODE register. The action of writing this
                  register will force an error pulse. The sole purpose of this
                  register is to test that any error properly propagates to either
                  an interrupt or an alert.
                  '''
        },
      ]
    },
    { name: "MAIN_SM_STATE",
      desc: "Main state machine state debug register",
      swaccess: "ro",
      hwaccess: "hwo",
      fields: [
        { bits: "5:0",
          name: "MAIN_SM_STATE",
          desc: '''This is the state of the CSRNG main state machine.
                See the RTL file `csrng_main_sm` for the meaning of the values.
                '''
          resval: 0x17
        }
      ]
    },
    {
      name: "INT_STATE_WRITE_ENABLE_REGWEN",
      desc: "Internal state write enable REGWEN register",
      swaccess: "rw0c",
      hwaccess: "none",
      fields: [
        { bits: "0",
          desc: '''
                INT_STATE_WRITE_ENABLE register configuration enable bit.
                If this is cleared to 0, the INT_STATE_WRITE_ENABLE register cannot be written anymore.
                '''
          resval: 1,
        }
      ]
    },
    {
      name: "INT_STATE_WRITE_ENABLE",
      desc: "Internal state write enable register",
      swaccess: "rw",
      hwaccess: "hro",
      regwen: "INT_STATE_WRITE_ENABLE_REGWEN",
      fields: [
        { bits: "2:0",
          name: "INT_STATE_WRITE_ENABLE",
          desc: '''
                Per-instance internal state write enable.
                Defines whether the internal state of the corresponding instance can be written via !!INT_STATE_VAL.
                Writes for an instance whose bit is cleared are dropped.
                Note that writing additionally requires !!CTRL.WRITE_INT_STATE to be set to `kMultiBitBool4True`.
                '''
          resval: 0x7
        }
      ]
    },
    {
      name: "INT_STATE_HALT_ENABLE_REGWEN",
      desc: "Internal state halt enable REGWEN register",
      swaccess: "rw0c",
      hwaccess: "none",
      fields: [
        { bits: "0",
          desc: '''
                INT_STATE_HALT_ENABLE register configuration enable bit.
                If this is cleared to 0, the INT_STATE_HALT_ENABLE register cannot be written anymore.
                '''
          resval: 1,
        }
      ]
    },
    {
      name: "INT_STATE_HALT_ENABLE",
      desc: "Internal state halt enable register",
      swaccess: "rw",
      hwaccess: "hro",
      regwen: "INT_STATE_HALT_ENABLE_REGWEN",
      fields: [
        { bits: "2:0",
          name: "INT_STATE_HALT_ENABLE",
          desc: '''
                Per-instance internal state halt enable.
                Defines whether the corresponding instance can be halted via !!INT_STATE_HALT.
                Setting !!INT_STATE_HALT has no effect on an instance whose bit is cleared.
                '''
          resval: 0x7
        }
      ]
    },
    {
      name: "INT_STATE_HALT",
      desc: "Internal state halt register",
      swaccess: "rw",
      hwaccess: "hro",
      tags: [// A write can halt an instance and affect RECOV_ALERT_STS.
             "excl:CsrAllTests:CsrExclWrite"]
      fields: [
        { bits: "3:0",
          name: "INT_STATE_HALT",
          mubi: true,
          resval: false,
          desc: '''
                While this field is set to kMultiBitBool4True, the instance selected by !!INT_STATE_NUM halts and !!INT_STATE_NUM cannot be written.
                The instance first completes the command in progress and any commands already queued for it.
                A Generate command is instead halted as soon as the block currently being generated is complete.
                If this is the final block, the command is acknowledged after resuming, once the block has been read out.
                While halted, the instance accepts no new commands: EDN requests are back-pressured and !!SW_CMD_STS.CMD_RDY is low for the software instance.
                This requires the bit of the selected instance in !!INT_STATE_HALT_ENABLE to be set, otherwise the instance is not halted.
                Poll !!INT_STATE_STS.HALTED, or wait for !!INTR_STATE.CS_CMD_REQ_DONE, to know when the instance has halted.
                Setting this field to kMultiBitBool4False resumes the command processing of the instance.
                '''
        }
      ]
    },
    {
      name: "INT_STATE_STS",
      desc: "Internal state halt status register",
      swaccess: "ro",
      hwaccess: "hwo",
      tags: ["excl:CsrNonInitTests:CsrExclCheck"]
      fields: [
        { bits: "0",
          name: "HALTED",
          desc: '''
                Reflects whether the instance selected by !!INT_STATE_NUM has quiesced following !!INT_STATE_HALT, such that its internal state stays constant while it is read/written via !!INT_STATE_VAL.
                Also see !!INTR_STATE.CS_CMD_REQ_DONE, which fires when an instance has halted.
                '''
          resval: 0
        }
        { bits: "1",
          name: "GENBITS_VLD",
          desc: '''
                Reflects whether generated bits of the instance selected by !!INT_STATE_NUM are waiting to be read by the consumer.
                The consumer can still read these bits while the instance is halted.
                Restoring the internal state via !!INT_STATE_VAL discards any generated bits that have not been read yet.
                '''
          resval: 0
        }
        { bits: "2",
          name: "GEN_IN_PROGRESS",
          desc: '''
                Reflects whether a Generate command is in progress for the instance selected by !!INT_STATE_NUM.
                While the instance is halted, this bit stays constant and indicates whether a Generate command can be aborted via !!GEN_ABORT.
                '''
          resval: 0
        }
      ]
    },
    {
      name: "SEED_CLEAR",
      desc: "Seed clear register",
      swaccess: "rw1s",
      hwaccess: "hrw",
      tags: [// This register self-clears every cycle and a write discards the held seed.
             "excl:CsrAllTests:CsrExclWrite"]
      fields: [
        { bits: "0",
          name: "SEED_CLEAR",
          resval: 0
          desc: '''
                Writing 1 discards the seed held by CSRNG, after which CSRNG requests a new seed from ENTROPY_SRC if CSRNG is enabled.
                This is needed after reconfiguring ENTROPY_SRC while CSRNG stays enabled, as the held seed was produced with the old configuration.
                A seed that has already been granted to an instantiate or reseed command is not discarded and is used by that command.
                If CSRNG holds no seed, the write has no effect.
                '''
        }
      ]
    },
  ]
}
