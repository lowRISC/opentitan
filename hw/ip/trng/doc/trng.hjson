// Copyright lowRISC contributors.
// Licensed under the Apache License, Version 2.0, see LICENSE for details.
// SPDX-License-Identifier: Apache-2.0
{ name: "trng",
  clock_primary: "clk_fixed",
  bus_device: "tlul",
  bus_host: "none",
//  mwb: no chip IO pins expected yet
//  available_input_list: [
//    { name: "rx", desc: "Serial receive bit" }
//  ],
//  available_output_list: [
//    { name: "tx", desc: "Serial transmit bit" }
//  ],
  interrupt_list: [
    { name: "no_random_num"
      desc: "raised if no random numbers are being generated."}
    { name: "stub_err"
      desc: "exists for testing only."}
  ]
  regwidth: "32",
  registers: [
    { name: "CTRL",
      desc: "TRNG control register",
      swaccess: "rw",
      hwaccess: "hro",
      fields: [
        { bits: "0",
          name: "PRNG",
          desc: "Enable PRNG function."
        }
        { bits: "1",
          name: "TRNG",
          desc: "Enable TRNG function."
        }
      ]
    },
    { name:     "STATUS"
      desc:     "TRNG live status register"
      swaccess: "ro"
      hwaccess: "hrw"
      hwext:    "true"
      hwre:     "true"
      fields: [
        { bits: "0"
          name: "PRNG"
          desc: "PRNG numbers are being generated."
        }
        { bits: "1"
          name: "TRNG"
          desc: "TRNG numbers are being generated."
        }
      ]
    }
    { name: "RNUM",
      desc: "TRNG random number",
      swaccess: "ro",
      hwaccess: "hrw",
      hwext: "true",
      hwre: "true",
      fields: [
        { bits: "31:0" 
          desc: "Random number returned as generated by the mode set."
        }
      ]
    }
    { name: "SEED",
      desc: "TRNG seed register",
      swaccess: "rw",
      hwaccess: "hrw",
      hwqe:     "true",
      fields: [
        { bits: "31:0",
          desc: "Seed for LFSR to use for the initial state."
        }
      ]
    }
  ]
}
