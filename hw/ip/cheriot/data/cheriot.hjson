// Copyright lowRISC contributors (OpenTitan project).
// Licensed under the Apache License, Version 2.0, see LICENSE for details.
// SPDX-License-Identifier: Apache-2.0
{
  name:               "cheriot",
  human_name:         "CHERIoT Memory Subsystem",
  one_line_desc:      "CHERIoT-aware memory subsystem",
  one_paragraph_desc: '''
    The CHERIoT memory subsystem sits between a CHERIoT-capable Ibex core and the system
    interconnect.  It enforces capability tag semantics on data-memory accesses, transparently
    remapping capability accesses and revocation bitmap reads into a dedicated meta SRAM.
  '''
  // Unique comportable IP identifier defined under KNOWN_CIP_IDS in the regtool.
  cip_id:             "48",
  design_spec:        "../doc",
  dv_doc:             "../doc/dv",
  hw_checklist:       "../doc/checklist",
  version:            "1.0.0",
  life_stage:         "L1",
  design_stage:       "D0",
  verification_stage: "V0",

  clocking: [
    {clock: "clk_i", reset: "rst_ni", primary: true}
  ],

  bus_interfaces: [
    {protocol: "tlul", direction: "device", name: "regs"},
    {protocol: "tlul", direction: "device", name: "revbm"},
    {protocol: "tlul", direction: "host", name: "cored"},
    {protocol: "tlul", direction: "host", name: "trbe"}
  ],

  ///////////////////////////
  // Interrupts and Alerts //
  ///////////////////////////

  alert_list: [
    { name: "fatal_fault",
      desc: '''
            This fatal alert is triggered when an integrity fault is detected, when the meta
            SRAM path returns a device error, or when the revocation engine reports an error.
            '''
    }
  ],

  ////////////////
  // Parameters //
  ////////////////

  param_list: [

    /////////////////////
    // Address map     //
    /////////////////////

    { name:    "MainSramBaseAddr",
      desc:    "Base address of the main SRAM region (inclusive).",
      type:    "logic [top_pkg::TL_AW-1:0]",
      default: "32'h1000_0000",
      local:   "false",
      expose:  "true"
    },
    { name:    "MainSramTopAddr",
      desc:    "Top address of the main SRAM region (exclusive).",
      type:    "logic [top_pkg::TL_AW-1:0]",
      default: "32'h1003_0000",
      local:   "false",
      expose:  "true"
    },
    { name:    "NvmBaseAddr",
      desc:    "Base address of the NVM region (inclusive).",
      type:    "logic [top_pkg::TL_AW-1:0]",
      default: "32'h3000_0000",
      local:   "false",
      expose:  "true"
    },
    { name:    "NvmTopAddr",
      desc:    "Top address of the NVM region (exclusive).",
      type:    "logic [top_pkg::TL_AW-1:0]",
      default: "32'h3020_0000",
      local:   "false",
      expose:  "true"
    },
    { name:    "MetaSramBaseAddr",
      desc:    '''
               Base address of the CHERIoT meta SRAM region.
               ''',
      type:    "logic [top_pkg::TL_AW-1:0]",
      default: "32'h1100_0000",
      local:   "false",
      expose:  "true"
    },
    // Overridden by topgen with the size of the `revbm` memory window.
    { name:    "MemSizeRevbm",
      desc:    '''
               Size of the revocation bitmap window (in bytes).
               Must match the size derived from the main SRAM region; this is checked by an
               assertion in the RTL.
               ''',
      type:    "int",
      default: "3072"
    },
  ],

  //////////////
  // Features //
  //////////////

  features: [
    { name: "CHERIOT.TAG_SPLIT",
      desc: '''
        A data access from the core is split into the data access towards the interconnect and a
        capability tag access towards the meta SRAM. Their responses are joined so that data and
        tag are returned together.
      '''
    },
    { name: "CHERIOT.TAG_READ",
      desc: '''
        On a hinted capability load, the tag bit of the addressed capability is looked up in the
        meta SRAM and returned.
      '''
    },
    { name: "CHERIOT.TAG_WRITE_RMW",
      desc: '''
        Because tags are stored at bit granularity, a write performs a read-modify-write on the
        addressed meta SRAM word.
      '''
    },
    { name: "CHERIOT.TAG_CLEAR_ON_DATA_WRITE",
      desc: '''
        Any non-capability write clears the tag bit of the addressed location, so that data stores
        cannot modify a valid capability.
      '''
    },
    { name: "CHERIOT.REVOCATION_BITMAP",
      desc: '''
        The revocation bitmap is exposed as a memory window on the `revbm` device interface and is
        read by the core's TRVK filter through the `corerevbm` port.
      '''
    },
    { name: "CHERIOT.ACCESS_CHECK",
      desc: '''
        Every meta SRAM access is checked against the region and the operations permitted for its
        originating port.
      '''
    },
    { name: "CHERIOT.MODE_GATING",
      desc: '''
        In ePMP mode the entire meta SRAM is inaccessible through all three ports of the
        subsystem. No tag lookups are issued.
      '''
    },
  ],

  /////////////////////////////
  // Intermodule Connections //
  /////////////////////////////

  inter_signal_list: [
    // CHERIoT mode enable
    { struct:  "mubi4",
      type:    "uni",
      name:    "cheriot_ena",
      act:     "rcv",
      package: "prim_mubi_pkg",
      default: "prim_mubi_pkg::MuBi4False",
      desc:    "CHERIoT mode enable."
    },
    // Data TL-UL interface from the core
    { struct:  "tl",
      type:    "req_rsp",
      name:    "cored_tl_d",
      act:     "rsp",
      package: "tlul_pkg",
      desc:    "Data port from the core."
    },
    // Capability tag sideband - write direction (from core to subsystem)
    { struct:  "logic",
      type:    "uni",
      name:    "cored_tag_h2d",
      act:     "rcv",
      width:   "1",
      package: "",
      default: "1'b0",
      desc:    "CHERIoT capability tag carried with the A-channel of cored_tl_h."
    },
    // Capability tag sideband - read response direction (from subsystem to core)
    { struct:  "logic",
      type:    "uni",
      name:    "cored_tag_d2h",
      act:     "req",
      width:   "1",
      package: "",
      default: "1'b0",
      desc:    "Capability tag returned on the D-channel of cored_tl_h."
    },
    // TRVK revocation bitmap TL-UL host port
    { struct:  "tl",
      type:    "req_rsp",
      name:    "corerevbm_tl",
      act:     "rsp",
      package: "tlul_pkg",
      desc:    "TRVK (tag revocation) revocation bitmap port from the core."
    },
    // Meta SRAM host TL-UL port (to external sram_ctrl RAM interface)
    { struct:  "tl",
      type:    "req_rsp",
      name:    "meta_sram_tl",
      act:     "req",
      package: "tlul_pkg",
      desc:    "Host TL-UL port to the external meta SRAM controller's RAM interface."
    },
  ],

  /////////////////////
  // Countermeasures //
  /////////////////////

  countermeasures: [
    { name: "BUS.INTEGRITY",
      desc: '''
        End-to-end bus integrity between the Ibex lockstep and the storage cells.
        Relies on LOGIC.SHADOW, which is not implemented yet.
      '''
    },
    { name: "LOGIC.SHADOW",
      desc: '''
        The CHERIoT subsystem is instantiated in lockstep. Not implemented yet.
      '''
    },
    { name: "MEM.SW_NOACCESS",
      desc: '''
        The capability tag store is not memory mapped.
      '''
    },
    { name: "INTERSIG.MUBI",
      desc: '''
        The CHERIoT mode enable is multi-bit encoded.
      '''
    },
  ],

  ///////////
  // Memory //
  ///////////

  memory: {
    revbm: {}
  }

  ///////////////
  // Registers //
  ///////////////

  regwidth: "32",
  registers: {
    regs: [
      { name: "TRBE_REGWEN",
        desc: "Write enable for the revocation engine registers.",
        swaccess: "ro",
        hwaccess: "hwo",
        hwext: "true",
        fields: [
          { bits: "0",
            name: "en",
            desc: '''
              Low while !!TRBE_BUSY is set, locking !!TRBE_BASE_ADDR, !!TRBE_NUM_CAPS and
              !!TRBE_START.
            ''',
            resval: "1"
          }
        ]
      },
      { name: "TRBE_BASE_ADDR",
        desc: "Address of the first capability the revocation engine sweeps.",
        regwen: "TRBE_REGWEN",
        swaccess: "rw",
        hwaccess: "hro",
        fields: [
          { bits: "31:3",
            name: "addr",
            desc: '''
              Bits 31:3 of the address. The sweep starts at a capability boundary; bits 2:0 read as
              zero. The address must lie in the tagged SRAM range; the sweep stops at the top of it.
            ''',
            resval: "0"
          }
        ]
      },
      { name: "TRBE_NUM_CAPS",
        desc: "Number of capabilities the revocation engine sweeps, each of them two 32-bit words.",
        regwen: "TRBE_REGWEN",
        swaccess: "rw",
        hwaccess: "hro",
        fields: [
          { bits: "30:0",
            name: "num",
            desc: '''
              Number of capabilities. A sweep reaching past the top of the tagged SRAM range ends at
              its top; the register keeps the value written.
            ''',
            resval: "0"
          }
        ]
      },
      { name: "TRBE_START",
        desc: '''
          Starts a sweep over the capabilities !!TRBE_BASE_ADDR and !!TRBE_NUM_CAPS describe.
          !!TRBE_BUSY reflects the sweep in progress. A start outside CHERIoT mode, with
          !!TRBE_NUM_CAPS zero, or with !!TRBE_BASE_ADDR outside the tagged SRAM range, is ignored.
        ''',
        regwen: "TRBE_REGWEN",
        swaccess: "wo",
        hwaccess: "hro",
        hwext: "true",
        hwqe: "true",
        // Writing it starts a sweep over whatever the other registers hold.
        tags: ["excl:CsrAllTests:CsrExclWrite"],
        fields: [
          { bits: "0",
            name: "start",
            desc: "Write 1 to start a sweep.",
            resval: "0"
          }
        ]
      },
      { name: "TRBE_BUSY",
        desc: "Status of the revocation engine.",
        swaccess: "ro",
        hwaccess: "hwo",
        hwext: "true",
        fields: [
          { bits: "0",
            name: "busy",
            desc: '''
              The revocation engine is sweeping; it is low once every capability of the sweep is
              resolved.
            ''',
            resval: "0"
          }
        ]
      }
    ]
  }
}
