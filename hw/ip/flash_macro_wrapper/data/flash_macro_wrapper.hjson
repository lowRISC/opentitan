// Copyright lowRISC contributors (OpenTitan project).
// Licensed under the Apache License, Version 2.0, see LICENSE for details.
// SPDX-License-Identifier: Apache-2.0
{
  name:               "flash_macro_wrapper",
  human_name:         "FLASH Macro Wrapper",
  one_line_desc:      "FLASH macro simulation model and CSR block",
  one_paragraph_desc: '''
  FLASH macro has flash memory arrays for non-volatile data storage.
  It is tightly coupled to the FLASH controller, but placed at the top for
  ease of integration. It contains a CSR block for testing and macro specific
  functionality.
  '''
  // Unique comportable IP identifier defined under KNOWN_CIP_IDS in the regtool.
  cip_id:             "45",
  design_spec:        "../doc",
#  dv_doc:             "../doc/dv",
#  hw_checklist:       "../doc/checklist",
#  sw_checklist:       "/sw/device/lib/dif/dif_pwm",
  revisions: [
    {
      version:            "2.0.0",
      life_stage:         "L1",
      design_stage:       "D2S",
      verification_stage: "V2S",
      dif_stage:          "S2",
      notes:              "Use FLASH_CTRL to perform block level verification.",
    }
  ]
  clocking: [
    {clock: "clk_i", reset: "rst_ni", primary: true},
  ]
  bus_interfaces: [
    { protocol: "tlul", direction: "device" }
  ],
  scan: "true", // Enable `scanmode_i` port
  scan_reset: "true", // Enable `scan_rst_ni` port
  scan_en: "true",    // Enable `scan_en_i` port
  available_input_list: [
    { name: "tck", desc: "jtag clock" },
    { name: "tms", desc: "jtag tms" },
    { name: "tdi", desc: "jtag input" },
  ],
  available_output_list: [
    { name: "tdo", desc: "jtag output" },
  ],
/*
  available_output_list: [
    { name: "test",
      width: 8,
      desc: "Test-related GPIOs. Only active in DFT-enabled life cycle states."
    }
  ],
*/
  regwidth: "32",
  param_list: [
    { name: "NumBanks",
      desc: "Number of flash banks",
      type: "int",
      default: "2",
      local: "false",
    },
    { name: "InfosPerBank",
      desc: "Info pages per bank",
      type: "int",
      default: "10",
      local: "false",
    },
    { name: "InfoTypes",
      desc: "Number of different info page types per bank",
      type: "int",
      default: "3",
      local: "false",
    },
    { name: "InfoTypesWidth",
      desc: "Number of bits to encode the info page types",
      type: "int",
      default: "2",
      local: "false",
    },
    { name: "PagesPerBank",
      desc: "Number of data pages per bank",
      type: "int",
      default: "256",
      local: "false",
    },
    { name: "WordsPerPage",
      desc: "Number of words per data page",
      type: "int",
      default: "256",
      local: "false",
    },
    { name: "DataWidth",
      desc: "Number of bits per data word",
      type: "int",
      default: "72",
      local: "false",
    },
    { name: "TestModeWidth",
      desc: "Number of bits to encode test mode",
      type: "int",
      default: "2",
      local: "false",
    },
  ],
  alert_list: [],
  features: []
  countermeasures: [
    { name: "REG.BUS.INTEGRITY",
      desc: '''
            End-to-end bus integrity scheme.
            '''
    },
    { name: "LC_CTRL.INTERSIG.MUBI",
      desc: '''
            Life cycle control signals are used enable jtag access to the flash macro.
            '''
    }
  ],
  inter_signal_list: [
    { struct:  "flash_phy_macro",
      type:    "req_rsp",
      name:    "flash",
      act:     "rsp",
      package: "flash_phy_macro_pkg",
      desc:    "Data interface to the flash controller"
    },

    { struct:  "flash_macro_status",
      type:    "uni",
      name:    "status",
      act:     "req",
      package: "flash_phy_macro_pkg",
    },

    { struct: "lc_tx",
      package: "lc_ctrl_pkg",
      type: "uni"
      act: "rcv"
      name: "lc_nvm_debug_en"
    },

    { struct: "mubi4"
      package: "prim_mubi_pkg"
      type: "uni"
      act: "rcv"
      name: "bist_enable"
    },

    { struct: "logic"
      package: ""
      type: "uni"
      act: "rcv"
      name: "power_down_h"
    },
    { struct: "logic"
      package: ""
      type: "uni"
      act: "rcv"
      name: "power_ready_h"
    },
    { struct: "",
      package: "",
      width: "2",
      type: "io"
      act: "none"
      name: "test_mode_a"
    },
    { struct: "",
      package: "",
      type: "io"
      act: "none"
      name: "test_voltage_h"
    },
    { struct: "ast_obs_ctrl",
      type: "uni",
      name: "obs_ctrl",
      act: "rcv",
      package: "ast_pkg"
    }

    { struct: "logic",
      type: "uni",
      name: "fla_obs",
      act: "req",
      width: "8",
      package: ""
    }
  ],

  registers: [
    {
      name: "CSR0_REGWEN",
      desc: "",
      fields: [
        {
          bits: "0",
          name: "field0",
          swaccess: "rw0c",
          hwaccess: "none",
          resval: "1",
          tags: [],
          desc: "",
          enum: []
        }
      ],
      hwext: "False",
      hwqe: "False",
      hwre: "False",
      tags: [],
      shadowed: "False"
    },
    {
      name: "CSR1",
      desc: "",
      fields: [
        {
          bits: "7:0",
          name: "field0",
          swaccess: "rw",
          hwaccess: "hro",
          resval: "0",
          tags: [],
          desc: "",
          enum: []
        },
        {
          bits: "12:8",
          name: "field1",
          swaccess: "rw",
          hwaccess: "hro",
          resval: "0",
          tags: [],
          desc: "",
          enum: []
        }
      ],
      hwext: "False",
      hwqe: "False",
      hwre: "False",
      tags: [],
      shadowed: "False",
      regwen: "CSR0_REGWEN"
    },
    {
      name: "CSR2",
      desc: "",
      fields: [
        {
          bits: "0",
          name: "field0",
          swaccess: "rw1c",
          hwaccess: "hrw",
          resval: "0",
          tags: [],
          desc: "",
          enum: []
        },
        {
          bits: "1",
          name: "field1",
          swaccess: "rw1c",
          hwaccess: "hrw",
          resval: "0",
          tags: [],
          desc: "",
          enum: []
        },
        {
          bits: "2",
          name: "field2",
          swaccess: "rw1c",
          hwaccess: "hrw",
          resval: "0",
          tags: [],
          desc: "",
          enum: []
        },
        {
          bits: "3",
          name: "field3",
          swaccess: "rw",
          hwaccess: "hrw",
          resval: "0",
          tags: [],
          desc: "",
          enum: []
        },
        {
          bits: "4",
          name: "field4",
          swaccess: "rw1c",
          hwaccess: "hrw",
          resval: "0",
          tags: [],
          desc: "",
          enum: []
        },
        {
          bits: "5",
          name: "field5",
          swaccess: "rw1c",
          hwaccess: "hrw",
          resval: "0",
          tags: [],
          desc: "",
          enum: []
        },
        {
          bits: "6",
          name: "field6",
          swaccess: "rw1c",
          hwaccess: "hrw",
          resval: "0",
          tags: [],
          desc: "",
          enum: []
        },
        {
          bits: "7",
          name: "field7",
          swaccess: "rw",
          hwaccess: "hrw",
          resval: "0",
          tags: [],
          desc: "",
          enum: []
        }
      ],
      hwext: "False",
      hwqe: "False",
      hwre: "False",
      tags: [],
      shadowed: "False"
    },
    {
      name: "CSR3",
      desc: "",
      fields: [
        {
          bits: "3:0",
          name: "field0",
          swaccess: "rw",
          hwaccess: "hro",
          resval: "0",
          tags: [],
          desc: "",
          enum: []
        },
        {
          bits: "7:4",
          name: "field1",
          swaccess: "rw",
          hwaccess: "hro",
          resval: "0",
          tags: [],
          desc: "",
          enum: []
        },
        {
          bits: "10:8",
          name: "field2",
          swaccess: "rw",
          hwaccess: "hro",
          resval: "0",
          tags: [],
          desc: "",
          enum: []
        },
        {
          bits: "13:11",
          name: "field3",
          swaccess: "rw",
          hwaccess: "hro",
          resval: "0",
          tags: [],
          desc: "",
          enum: []
        },
        {
          bits: "16:14",
          name: "field4",
          swaccess: "rw",
          hwaccess: "hro",
          resval: "0",
          tags: [],
          desc: "",
          enum: []
        },
        {
          bits: "19:17",
          name: "field5",
          swaccess: "rw",
          hwaccess: "hro",
          resval: "0",
          tags: [],
          desc: "",
          enum: []
        },
        {
          bits: "20",
          name: "field6",
          swaccess: "rw",
          hwaccess: "hro",
          resval: "0",
          tags: [],
          desc: "",
          enum: []
        },
        {
          bits: "23:21",
          name: "field7",
          swaccess: "rw",
          hwaccess: "hro",
          resval: "0",
          tags: [],
          desc: "",
          enum: []
        },
        {
          bits: "25:24",
          name: "field8",
          swaccess: "rw",
          hwaccess: "hro",
          resval: "0",
          tags: [],
          desc: "",
          enum: []
        },
        {
          bits: "27:26",
          name: "field9",
          swaccess: "rw",
          hwaccess: "hro",
          resval: "0",
          tags: [],
          desc: "",
          enum: []
        }
      ],
      hwext: "False",
      hwqe: "False",
      hwre: "False",
      tags: [],
      shadowed: "False",
      regwen: "CSR0_REGWEN"
    },
    {
      name: "CSR4",
      desc: "",
      fields: [
        {
          bits: "2:0",
          name: "field0",
          swaccess: "rw",
          hwaccess: "hro",
          resval: "0",
          tags: [],
          desc: "",
          enum: []
        },
        {
          bits: "5:3",
          name: "field1",
          swaccess: "rw",
          hwaccess: "hro",
          resval: "0",
          tags: [],
          desc: "",
          enum: []
        },
        {
          bits: "8:6",
          name: "field2",
          swaccess: "rw",
          hwaccess: "hro",
          resval: "0",
          tags: [],
          desc: "",
          enum: []
        },
        {
          bits: "11:9",
          name: "field3",
          swaccess: "rw",
          hwaccess: "hro",
          resval: "0",
          tags: [],
          desc: "",
          enum: []
        }
      ],
      hwext: "False",
      hwqe: "False",
      hwre: "False",
      tags: [],
      shadowed: "False",
      regwen: "CSR0_REGWEN"
    },
    {
      name: "CSR5",
      desc: "",
      fields: [
        {
          bits: "2:0",
          name: "field0",
          swaccess: "rw",
          hwaccess: "hro",
          resval: "0",
          tags: [],
          desc: "",
          enum: []
        },
        {
          bits: "4:3",
          name: "field1",
          swaccess: "rw",
          hwaccess: "hro",
          resval: "0",
          tags: [],
          desc: "",
          enum: []
        },
        {
          bits: "13:5",
          name: "field2",
          swaccess: "rw",
          hwaccess: "hro",
          resval: "0",
          tags: [],
          desc: "",
          enum: []
        },
        {
          bits: "18:14",
          name: "field3",
          swaccess: "rw",
          hwaccess: "hro",
          resval: "0",
          tags: [],
          desc: "",
          enum: []
        },
        {
          bits: "22:19",
          name: "field4",
          swaccess: "rw",
          hwaccess: "hro",
          resval: "0",
          tags: [],
          desc: "",
          enum: []
        }
      ],
      hwext: "False",
      hwqe: "False",
      hwre: "False",
      tags: [],
      shadowed: "False",
      regwen: "CSR0_REGWEN"
    },
    {
      name: "CSR6",
      desc: "",
      fields: [
        {
          bits: "2:0",
          name: "field0",
          swaccess: "rw",
          hwaccess: "hro",
          resval: "0",
          tags: [],
          desc: "",
          enum: []
        },
        {
          bits: "5:3",
          name: "field1",
          swaccess: "rw",
          hwaccess: "hro",
          resval: "0",
          tags: [],
          desc: "",
          enum: []
        },
        {
          bits: "13:6",
          name: "field2",
          swaccess: "rw",
          hwaccess: "hro",
          resval: "0",
          tags: [],
          desc: "",
          enum: []
        },
        {
          bits: "16:14",
          name: "field3",
          swaccess: "rw",
          hwaccess: "hro",
          resval: "0",
          tags: [],
          desc: "",
          enum: []
        },
        {
          bits: "18:17",
          name: "field4",
          swaccess: "rw",
          hwaccess: "hro",
          resval: "0",
          tags: [],
          desc: "",
          enum: []
        },
        {
          bits: "20:19",
          name: "field5",
          swaccess: "rw",
          hwaccess: "hro",
          resval: "0",
          tags: [],
          desc: "",
          enum: []
        },
        {
          bits: "22:21",
          name: "field6",
          swaccess: "rw",
          hwaccess: "hro",
          resval: "0",
          tags: [],
          desc: "",
          enum: []
        },
        {
          bits: "23",
          name: "field7",
          swaccess: "rw",
          hwaccess: "hro",
          resval: "0",
          tags: [],
          desc: "",
          enum: []
        },
        {
          bits: "24",
          name: "field8",
          swaccess: "rw",
          hwaccess: "hro",
          resval: "0",
          tags: [],
          desc: "",
          enum: []
        }
      ],
      hwext: "False",
      hwqe: "False",
      hwre: "False",
      tags: [],
      shadowed: "False",
      regwen: "CSR0_REGWEN"
    },
    {
      name: "CSR7",
      desc: "",
      fields: [
        {
          bits: "7:0",
          name: "field0",
          swaccess: "rw",
          hwaccess: "hro",
          resval: "0",
          tags: [],
          desc: "",
          enum: []
        },
        {
          bits: "16:8",
          name: "field1",
          swaccess: "rw",
          hwaccess: "hro",
          resval: "0",
          tags: [],
          desc: "",
          enum: []
        }
      ],
      hwext: "False",
      hwqe: "False",
      hwre: "False",
      tags: [],
      shadowed: "False",
      regwen: "CSR0_REGWEN"
    },
    {
      name: "CSR8",
      desc: "",
      fields: [
        {
          bits: "31:0",
          name: "field0",
          swaccess: "rw",
          hwaccess: "hro",
          resval: "0",
          tags: [],
          desc: "",
          enum: []
        }
      ],
      hwext: "False",
      hwqe: "False",
      hwre: "False",
      tags: [],
      shadowed: "False",
      regwen: "CSR0_REGWEN"
    },
    {
      name: "CSR9",
      desc: "",
      fields: [
        {
          bits: "31:0",
          name: "field0",
          swaccess: "rw",
          hwaccess: "hro",
          resval: "0",
          tags: [],
          desc: "",
          enum: []
        }
      ],
      hwext: "False",
      hwqe: "False",
      hwre: "False",
      tags: [],
      shadowed: "False",
      regwen: "CSR0_REGWEN"
    },
    {
      name: "CSR10",
      desc: "",
      fields: [
        {
          bits: "31:0",
          name: "field0",
          swaccess: "rw",
          hwaccess: "hro",
          resval: "0",
          tags: [],
          desc: "",
          enum: []
        }
      ],
      hwext: "False",
      hwqe: "False",
      hwre: "False",
      tags: [],
      shadowed: "False",
      regwen: "CSR0_REGWEN"
    },
    {
      name: "CSR11",
      desc: "",
      fields: [
        {
          bits: "31:0",
          name: "field0",
          swaccess: "rw",
          hwaccess: "hro",
          resval: "0",
          tags: [],
          desc: "",
          enum: []
        }
      ],
      hwext: "False",
      hwqe: "False",
      hwre: "False",
      tags: [],
      shadowed: "False",
      regwen: "CSR0_REGWEN"
    },
    {
      name: "CSR12",
      desc: "",
      fields: [
        {
          bits: "9:0",
          name: "field0",
          swaccess: "rw",
          hwaccess: "hro",
          resval: "0",
          tags: [],
          desc: "",
          enum: []
        }
      ],
      hwext: "False",
      hwqe: "False",
      hwre: "False",
      tags: [],
      shadowed: "False",
      regwen: "CSR0_REGWEN"
    },
    {
      name: "CSR13",
      desc: "",
      fields: [
        {
          bits: "19:0",
          name: "field0",
          swaccess: "rw",
          hwaccess: "hro",
          resval: "0",
          tags: [],
          desc: "",
          enum: []
        },
        {
          bits: "20",
          name: "field1",
          swaccess: "rw",
          hwaccess: "hro",
          resval: "0",
          tags: [],
          desc: "",
          enum: []
        }
      ],
      hwext: "False",
      hwqe: "False",
      hwre: "False",
      tags: [],
      shadowed: "False",
      regwen: "CSR0_REGWEN"
    },
    {
      name: "CSR14",
      desc: "",
      fields: [
        {
          bits: "7:0",
          name: "field0",
          swaccess: "rw",
          hwaccess: "hro",
          resval: "0",
          tags: [],
          desc: "",
          enum: []
        },
        {
          bits: "8",
          name: "field1",
          swaccess: "rw",
          hwaccess: "hro",
          resval: "0",
          tags: [],
          desc: "",
          enum: []
        }
      ],
      hwext: "False",
      hwqe: "False",
      hwre: "False",
      tags: [],
      shadowed: "False",
      regwen: "CSR0_REGWEN"
    },
    {
      name: "CSR15",
      desc: "",
      fields: [
        {
          bits: "7:0",
          name: "field0",
          swaccess: "rw",
          hwaccess: "hro",
          resval: "0",
          tags: [],
          desc: "",
          enum: []
        },
        {
          bits: "8",
          name: "field1",
          swaccess: "rw",
          hwaccess: "hro",
          resval: "0",
          tags: [],
          desc: "",
          enum: []
        }
      ],
      hwext: "False",
      hwqe: "False",
      hwre: "False",
      tags: [],
      shadowed: "False",
      regwen: "CSR0_REGWEN"
    },
    {
      name: "CSR16",
      desc: "",
      fields: [
        {
          bits: "7:0",
          name: "field0",
          swaccess: "rw",
          hwaccess: "hro",
          resval: "0",
          tags: [],
          desc: "",
          enum: []
        },
        {
          bits: "8",
          name: "field1",
          swaccess: "rw",
          hwaccess: "hro",
          resval: "0",
          tags: [],
          desc: "",
          enum: []
        }
      ],
      hwext: "False",
      hwqe: "False",
      hwre: "False",
      tags: [],
      shadowed: "False",
      regwen: "CSR0_REGWEN"
    },
    {
      name: "CSR17",
      desc: "",
      fields: [
        {
          bits: "7:0",
          name: "field0",
          swaccess: "rw",
          hwaccess: "hro",
          resval: "0",
          tags: [],
          desc: "",
          enum: []
        },
        {
          bits: "8",
          name: "field1",
          swaccess: "rw",
          hwaccess: "hro",
          resval: "0",
          tags: [],
          desc: "",
          enum: []
        }
      ],
      hwext: "False",
      hwqe: "False",
      hwre: "False",
      tags: [],
      shadowed: "False",
      regwen: "CSR0_REGWEN"
    },
    {
      name: "CSR18",
      desc: "",
      fields: [
        {
          bits: "0",
          name: "field0",
          swaccess: "rw",
          hwaccess: "hro",
          resval: "0",
          tags: [],
          desc: "",
          enum: []
        }
      ],
      hwext: "False",
      hwqe: "False",
      hwre: "False",
      tags: [],
      shadowed: "False",
      regwen: "CSR0_REGWEN"
    },
    {
      name: "CSR19",
      desc: "",
      fields: [
        {
          bits: "0",
          name: "field0",
          swaccess: "rw",
          hwaccess: "hro",
          resval: "0",
          tags: [],
          desc: "",
          enum: []
        }
      ],
      hwext: "False",
      hwqe: "False",
      hwre: "False",
      tags: [],
      shadowed: "False",
      regwen: "CSR0_REGWEN"
    },
    {
      name: "CSR20",
      desc: "",
      fields: [
        {
          bits: "0",
          name: "field0",
          swaccess: "rw1c",
          hwaccess: "hrw",
          resval: "0",
          tags: [],
          desc: "",
          enum: []
        },
        {
          bits: "1",
          name: "field1",
          swaccess: "rw1c",
          hwaccess: "hrw",
          resval: "0",
          tags: [],
          desc: "",
          enum: []
        },
        {
          bits: "2",
          name: "field2",
          swaccess: "ro",
          hwaccess: "hrw",
          resval: "0",
          tags: [],
          desc: "",
          enum: []
        }
      ],
      hwext: "False",
      hwqe: "False",
      hwre: "False",
      tags: [],
      shadowed: "False"
    }
  ]
}
