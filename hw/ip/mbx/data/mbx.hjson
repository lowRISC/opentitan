// Copyright lowRISC contributors.
// Licensed under the Apache License, Version 2.0, see LICENSE for details.
// SPDX-License-Identifier: Apache-2.0
//
# DOE register template
{
  name:               "mbx"
  human_name:         "DOE Mailbox"
  one_line_desc:      "DOE mailbox for use as an integrated OpenTitan communication channel."
  one_paragraph_desc: '''
  The SoC Host (or other SoC Execution Engines) may request security services from the OpenTitan RoT.
  This means that pre-defined control information must be passed to OpenTitan from the security service requester.
  A secure inbound/outbound mailbox can be used to implement a secure channel for these request/response transactions between the Host and the RoT.
  '''
  cip_id:             "37"
  design_spec:        "../doc"
  dv_doc:             "../doc/dv"
  version:            "0.1.0"

  clocking: [{clock: "clk_i", reset: "rst_ni", primary: true}]
  bus_interfaces: [
    { protocol: "tlul", direction: "device", name: "host" }
    { protocol: "tlul", direction: "host",   name: "sram" }
    { protocol: "tlul", direction: "device", name: "sys" }
  ]
  interrupt_list: [
    { name: "mbx_ready"
      desc: "A new object was received in the inbound mailbox."
    }
  ]
  alert_list: [
    { name: "fatal_fault"
      desc: "This fatal alert is triggered when a fatal TL-UL bus integrity fault is detected."
    }
  ]
  countermeasures: [
    { name: "BUS.INTEGRITY"
      desc: "End-to-end bus integrity scheme."
    }
  ]
  regwidth: "32"
  registers: {
    host: [
      { name: "CONTROL"
        desc: "DOE mailbox control register visible to the mailbox host"
        fields: [
          { name: "abort"
            desc: "Alias of the DoE mailbox abort bit"
            bits: "0"
            resval: "0x0"
            swaccess: "rw"
            hwaccess: "hrw"
            hwqe: "true"
          }
        ]
        hwext: "true"
      }
      { name: "STATUS"
        desc: "DOE mailbox status register visible to the mailbox host"
        fields: [
          { name: "busy"
            desc: "Alias of the DoE mailbox busy bit"
            bits: "0"
            resval: "0x1"
            swaccess: "rw"
            hwaccess: "hrw"
            hwqe: "true"
          }
          { name: "error"
           desc: "Alias of the DoE mailbox error bit"
            bits: "2"
            resval: "0x0"
            swaccess: "rw"
            hwaccess: "hrw"
            hwqe: "true"
          }
          { name: "async_msg_status"
            desc: '''
                  When Set, this bit indicates the DOE instance has one or more asynchronous messages to transfer
                  The transition of this bit from Clear to Set is an interrupt triggering event
                  '''
            bits: "3"
            resval: "0x0"
            swaccess: "rw"
            hwaccess: "hrw"
            hwqe: "true"
          }
          {
            name: "ready"
            desc: "Alias of the DoE mailbox ready bit"
            bits: "31"
            resval: "0x0"
            swaccess: "rw"
            hwaccess: "hrw"
            hwqe: "true"
          }
          ]
        hwext: "true"
      }
      { name: "ADDRESS_RANGE_REGWEN"
        desc: "Used to lock the inound/outbound base/limit configuration registers."
        swaccess: "rw0c"
        fields: [
          { name: "regwen"
            desc: "Once cleared the mailbox inbound/outbound base/limit registers will be locked until the next reset."
            bits: "0"
            resval: "1"
          }
        ]
      }
      { name: "ADDRESS_RANGE_VALID"
        desc: "Used to lock the inound/outbound base/limit configuration registers."
        swaccess: "rw"
        hwaccess: "hro"
        fields: [
          { name: "range_valid"
            desc: "Once set the mailbox inbound/outbound base/limit registers are valid."
            bits: "0"
            resval: "0"
          }
        ]
      }
      { name: "INBOUND_BASE_ADDRESS"
        desc: '''Base address of SRAM region, which is used to back up the inbound mailbox data.
              This address is 4-byte aligned, the lower 2-bits are ignored.
              '''
        regwen: "ADDRESS_RANGE_REGWEN"
        fields: [
          { name: "base_address"
            desc: "Base address of SRAM region, which is used to back up the inbound mailbox data."
            bits: "31:2"
            resval: "0x0"
            swaccess: "rw"
            hwqe: "true"
          }
        ]
      }
      {
        name: "INBOUND_LIMIT_ADDRESS"
        desc: '''Limit Address to mark the end of the inbound mailbox memory range in the private SRAM..
              This address is 4-byte aligned, the lower 2-bits are ignored.
              '''
        regwen: "ADDRESS_RANGE_REGWEN"
        fields: [
          { name: "limit"
            desc: "Limit Address to mark the end of the inbound mailbox memory range in the private SRAM."
            bits: "31:2"
            resval: "0x0"
            swaccess: "rw"
            hwqe: "true"
          }
        ]
      }
      { name: "INBOUND_WRITE_PTR"
        desc: '''Write pointer for the next inbound data write.
              This pointer is 4-byte aligned, the lower 2-bits are always zero.
              '''
        fields: [
          { name: "inbound_read_ptr"
            desc: "Write pointer for the next inbound data write."
            bits: "31:2"
            resval: "0x0"
            swaccess: "ro"
            hwaccess: "hrw"
            hwqe: "true"
          }
        ]
        hwext: "true"
      }
      { name: "OUTBOUND_BASE_ADDRESS"
        desc: '''Base address of SRAM region, which is used to buffer the outbound mailbox data.
              This address is 4-byte aligned, the lower 2-bits are ignored.
              '''
        regwen: "ADDRESS_RANGE_REGWEN"
        fields: [
          { name: "base_address"
            desc: "Base address of SRAM region, which is used to buffer the outbound mailbox data."
            bits: "31:2"
            resval: "0x0"
            swaccess: "rw"
            hwqe: "true"
          }
        ]
      }
      { name: "OUTBOUND_LIMIT_ADDRESS"
        desc: '''Limit Address to mark the end of the outbound mailbox memory range in the private SRAM.
              This address is 4-byte aligned, the lower 2-bits are ignored.
              '''
        regwen: "ADDRESS_RANGE_REGWEN"
        fields: [
          { name: "limit"
            desc: "Limit Address to mark the end of the outbound mailbox memory range in the private SRAM."
            bits: "31:2"
            resval: "0x0"
            swaccess: "rw"
            hwqe: "true"
          }
        ]
      }
      { name: "OUTBOUND_READ_PTR"
        desc: '''Read pointer for the next outbound data read.
              This pointer is 4-byte aligned, the lower 2-bits are always zero.
              '''
        fields: [
          { name: "outbound_write_ptr"
            desc: "Read pointer for the next outbound data read."
            bits: "31:2"
            resval: "0x0"
            swaccess: "ro"
            hwaccess: "hrw"
            hwqe: "true"
          }
        ]
        hwext: "true"
      }
      { name: "OUTBOUND_OBJECT_SIZE"
        desc: '''Indicates the size of the data object to be transferred out.
              Note that this size specifies the number of 4-byte words (DWORD).
              Maximum size supported by any OT DOE instance is 1K DWORDS.
              '''
        fields: [
          { name: "cnt"
            desc: "Indicates the size of the data object to be transferred out in 4-byte words."
            bits: "10:0"
            resval: "0x0"
            swaccess: "rw"
            hwaccess: "hrw"
            hwqe: "true"
          }
        ]
      }
    ]
    sys: [
    ]
  }
}
