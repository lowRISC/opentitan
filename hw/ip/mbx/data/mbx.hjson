// Copyright lowRISC contributors.
// Licensed under the Apache License, Version 2.0, see LICENSE for details.
// SPDX-License-Identifier: Apache-2.0
//
# DOE register template
{
  name:               "mbx"
  human_name:         "DOE Mailbox"
  one_line_desc:      "DOE mailbox for use as an integrated OpenTitan communication channel."
  one_paragraph_desc: '''
  The SoC (i.e., the SoC Host CPU or other SoC Execution Engines) may request security services from OpenTitan.
  This means that pre-defined control information must be passed to OpenTitan from the security service requester.
  A secure inbound/outbound mailbox can be used to implement a secure channel for these request/response transactions between the SoC and OpenTitan.
  '''
  cip_id:             "37"
  design_spec:        "../doc"
  dv_doc:             "../doc/dv"
  version:            "0.1.0"

  clocking: [{clock: "clk_i", reset: "rst_ni", primary: true}]
  bus_interfaces: [
    { protocol: "tlul", direction: "device", name: "core" }
    { protocol: "tlul", direction: "host",   name: "sram" }
    { protocol: "tlul", direction: "device", name: "soc" }
  ]
  inter_signal_list: [
    { struct:  "logic",
      type:    "uni",
      name:    "doe_intr_support",
      act:     "req",
      package: "",
      default: "1'b0"
    }
    { struct:  "logic",
      type:    "uni",
      name:    "doe_intr_en",
      act:     "req",
      package: "",
      default: "1'b0"
    }
    { struct:  "logic",
      type:    "uni",
      name:    "doe_intr",
      act:     "req",
      package: "",
      default: "1'b0"
    }
  ]
  interrupt_list: [
    { name: "mbx_ready"
      desc: "A new object was received in the inbound mailbox."
    }
    { name: "mbx_abort"
      desc: "An abort request was received from the requester."
    }
  ]
  alert_list: [
    { name: "fatal_fault"
      desc: "This fatal alert is triggered when a fatal TL-UL bus integrity fault is detected."
    }
    { name: "recov_fault",
      desc: "This recoverable alert is triggered when memory with invalid ECC (e.g., uninitialized memory) or at an invalid address is accessed."
    }
  ]
  countermeasures: [
    { name: "BUS.INTEGRITY"
      desc: "End-to-end bus integrity scheme."
    }
    { name: "ADDRESS_RANGE.CONFIG.REGWEN_MUBI",
      desc: "Private SRAM memory range is software multibit lockable."
    }
  ]
  regwidth: "32"
  registers: {
    core: [
      { name: "CONTROL"
        desc: "DOE mailbox control register visible to OpenTitan"
        hwext: "true"
        fields: [
          { name: "abort"
            desc: "Alias of the DoE mailbox abort bit"
            bits: "0"
            resval: "0x0"
            swaccess: "rw"
            hwaccess: "hrw"
            hwqe: "true"
          }
          { name: "error"
            desc: '''
                  Set by firmware to signal an error, e.g. unable to provide a response to request.
                  Set by hardware, on SYS.WDATA or SYS.RDATA performing an invalid access.
                  Cleared by the hardware when SYS sets CONTROL.ABORT.
                  '''
            bits: "1"
            resval: "0x0"
            swaccess: "rw"
            hwaccess: "hrw"
            hwqe: "true"
          }
        ]
      }
      { name: "STATUS"
        desc: "DOE mailbox status register visible to OpenTitan"
        hwext: "true"
        fields: [
          { name: "busy"
            desc: "Alias of the DoE mailbox busy bit"
            bits: "0"
            resval: "0x1"
            swaccess: "ro"
            hwaccess: "hwo"
          }
          { name: "sys_intr_state"
            desc: "Alias of the DoE mailbox interrupt status bit"
            bits: "1"
            resval: "0x0"
            swaccess: "ro"
            hwaccess: "hwo"
          }
          { name: "sys_intr_enable"
            desc: "Alias of the DoE mailbox interrupt enable bit"
            bits: "2"
            resval: "0x0"
            swaccess: "ro"
            hwaccess: "hwo"
          }
        ]
      }
      { name: "ADDRESS_RANGE_REGWEN"
        desc: "Used to lock the inbound/outbound base/limit configuration registers."
        swaccess: "rw0c"
        hwaccess: "none"
        fields: [
          { name: "regwen"
            desc: '''
                  Once cleared the mailbox inbound/outbound base/limit registers will be locked until the next reset.

                  Default Value = kMultiBitBool4True -> Unlocked at reset.
                  '''
            bits: "3:0"
            mubi: "true"
            resval: true
          }
        ]
      }
      { name: "ADDRESS_RANGE_VALID"
        desc: "Used to mark the inbound/outbound base/limit configuration registers to have a valid configuration."
        swaccess: "rw"
        hwaccess: "hro"
        fields: [
          { name: "range_valid"
            desc: "Once set the mailbox inbound/outbound base/limit registers are valid."
            bits: "0"
            resval: "0"
          }
        ]
      }
      { name: "INBOUND_BASE_ADDRESS"
        desc: '''Base address of SRAM region, which is used to back up the inbound mailbox data.
              This address is 4-byte aligned, the lower 2-bits are ignored.
              '''
        regwen: "ADDRESS_RANGE_REGWEN"
        swaccess: "rw"
        hwaccess: "hro"
        fields: [
          { name: "base_address"
            desc: "Base address of SRAM region, which is used to back up the inbound mailbox data."
            bits: "31:2"
            resval: "0x0"
          }
        ]
      }
      { name: "INBOUND_LIMIT_ADDRESS"
        desc: '''Limit Address to mark the end of the inbound mailbox memory range in the private SRAM..
              This address is 4-byte aligned, the lower 2-bits are ignored.
              '''
        regwen: "ADDRESS_RANGE_REGWEN"
        swaccess: "rw"
        hwaccess: "hro"
        fields: [
          { name: "limit"
            desc: "Limit Address to mark the end of the inbound mailbox memory range in the private SRAM."
            bits: "31:2"
            resval: "0x0"
          }
        ]
      }
      { name: "INBOUND_WRITE_PTR"
        desc: '''Write pointer for the next inbound data write.
              This pointer is 4-byte aligned, the lower 2-bits are always zero.
              '''
        hwext: "true"
        fields: [
          { name: "inbound_read_ptr"
            desc: "Write pointer for the next inbound data write."
            bits: "31:2"
            resval: "0x0"
            swaccess: "ro"
            hwaccess: "hwo"
          }
        ]
      }
      { name: "OUTBOUND_BASE_ADDRESS"
        desc: '''Base address of SRAM region, which is used to buffer the outbound mailbox data.
              This address is 4-byte aligned, the lower 2-bits are ignored.
              '''
        regwen: "ADDRESS_RANGE_REGWEN"
        swaccess: "rw"
        hwaccess: "hro"
        fields: [
          { name: "base_address"
            desc: "Base address of SRAM region, which is used to buffer the outbound mailbox data."
            bits: "31:2"
            resval: "0x0"
          }
        ]
      }
      { name: "OUTBOUND_LIMIT_ADDRESS"
        desc: '''Limit Address to mark the end of the outbound mailbox memory range in the private SRAM.
              This address is 4-byte aligned, the lower 2-bits are ignored.
              '''
        regwen: "ADDRESS_RANGE_REGWEN"
        swaccess: "rw"
        hwaccess: "hro"
        fields: [
          { name: "limit"
            desc: "Limit Address to mark the end of the outbound mailbox memory range in the private SRAM."
            bits: "31:2"
            resval: "0x0"
          }
        ]
      }
      { name: "OUTBOUND_READ_PTR"
        desc: '''Read pointer for the next outbound data read.
              This pointer is 4-byte aligned, the lower 2-bits are always zero.
              '''
        hwext: "true"
        fields: [
          { name: "outbound_write_ptr"
            desc: "Read pointer for the next outbound data read."
            bits: "31:2"
            resval: "0x0"
            swaccess: "ro"
            hwaccess: "hwo"
          }
        ]
      }
      { name: "OUTBOUND_OBJECT_SIZE"
        desc: '''Indicates the size of the data object to be transferred out.
              Note that this size specifies the number of 4-byte words (DWORD).
              Maximum size supported by any OT DOE instance is 1K DWORDS.
              '''
        fields: [
          { name: "cnt"
            desc: "Indicates the size of the data object to be transferred out in 4-byte words."
            bits: "10:0"
            resval: "0x0"
            swaccess: "rw"
            hwaccess: "hrw"
            hwqe: "true"
          }
        ]
      }
      { name: "DOE_INTR_MSG_ADDR"
        desc: '''
              Software read-only alias of the DOE_INTR_MSG_ADDR register of the SoC interface for convenient access of the OT firmware.
              Defined only for FW-to-FW mailboxes.
              '''
        hwext: "true"
        hwaccess: "hwo"
        swaccess: "ro"
        fields: [
          { name: "doe_intr_msg_addr"
            desc: "Utilized by the mailbox responder to send an interrupt message to the requester via a write to the configured address."
            bits: "31:0"
            resval: "0x0"
          }
        ]
      }
      { name: "DOE_INTR_MSG_DATA"
        desc: '''
              Software read-only alias of the DOE_INTR_MSG_DATA register of the SoC interface for convenient access of the OT firmware.
              Defined only for FW-to-FW mailboxes.
              '''
        hwext: "true"
        hwaccess: "hwo"
        swaccess: "ro"
        fields: [
          { name: "doe_intr_msg_data"
            desc: "Interrupt message data to be sent to the address configured in the DOE_INTR_MSG_ADDR register."
            bits: "31:0"
            resval: "0x0"
          }
        ]
      }
    ]
    soc: [
      { name: "SOC_DOE_INTR_MSG_ADDR"
        desc: '''
              Utilized by the mailbox responder to send an interrupt message to the requester via a write to the configured address.
              Defined only for FW-to-FW mailboxes.
              '''
        swaccess: "rw"
        hwaccess: "hro"
        fields: [
          { name: "doe_intr_msg_addr"
            desc: "Utilized by the mailbox responder to send an interrupt message to the requester via a write to the configured address."
            bits: "31:0"
            resval: "0x0"
          }
        ]
      }
      { name: "SOC_DOE_INTR_MSG_DATA"
        desc: '''
              Interrupt message data to be sent to the address configured in the DOE_INTR_MSG_ADDR register.
              Defined only for FW-to-FW mailboxes.
              '''
        swaccess: "rw"
        hwaccess: "hro"
        fields: [
          { name: "doe_intr_msg_data"
            desc: "Interrupt message data to be sent to the address configured in the DOE_INTR_MSG_ADDR register."
            bits: "31:0"
            resval: "0x0"
          }
        ]
      }
      { name: "SOC_CONTROL"
        desc: "DOE mailbox control register."
        hwaccess: "hrw"
        hwqe: "true"
        hwext: "true"
        fields: [
          { name: "abort"
            desc: '''
                  A write of 1 to this bit causes all data object transfer operations associated with this DOE instance to be aborted.
                  '''
            bits: "0"
            resval: "0x0"
            swaccess: "wo"
          }
          { name: "doe_intr_en"
            desc: '''
                  If DOE interrupt support is set, when this bit is set and MSI/MSI-X is enabled in MSI capability registers, the DOE instance must issue an MSI/MSI-X interrupt.
                  '''
            bits: "1"
            resval: "0x0"
            swaccess: "rw"
          }
          { name: "go"
            desc: '''
                  A write of 1 to this bit indicates to the DOE instance that it can start consuming the data object transferred through the DOE Write Data Mailbox register.
                  '''
            bits: "31"
            resval: "0x0"
            swaccess: "wo"
          }
        ]
      }
      { name: "SOC_STATUS"
        desc: "DOE mailbox status register"
        fields: [
          { name: "busy"
            desc: '''
                  When Set, this bit indicates the DOE instance is temporarily unable to receive a new data object through the DOE Write Data Mailbox register.
                  '''
            bits: "0"
            resval: "0x1"
            swaccess: "ro"
            hwaccess: "hrw"
          }
          { name: "doe_intr_status"
            desc: "This bit is set when an interrupt event occurs."
            bits: "1"
            resval: "0x0"
            swaccess: "rw1c"
            hwaccess: "hrw"
          }
          { name: "error"
            desc: '''
                  When Set, this bit indicates that there has been an internal error associated with data object received, or that a data object has been received for which the DOE instance is unable to provide a response.
                  The transition of this bit from Clear to Set is an interrupt triggering event.
                  '''
            bits: "2"
            resval: "0x0"
            swaccess: "ro"
            hwaccess: "hrw"
          }
          { name: "ready"
            desc: '''
                  When Set, this bit indicates the DOE instance has a data object available to be read by SoC firmware/software.
                  The transition of this bit from Clear to Set is an interrupt triggering event.
                  '''
            bits: "31"
            resval: "0x0"
            swaccess: "ro"
            hwaccess: "hwo"
          }
        ]
      }
      { window: {
          name: "WDATA"
          items: "1"
          swaccess: "wo"
          desc: '''DOE mailbox write data register.
                The DOE instance receives data objects via writes to this register.
                A successful write adds one DWORD to the data object being assembled in the DOE instance.
                A write of 1 to the DOE Go bit in the DOE Control Register marks the completion of the data transfer, i.e, final DWORD for the object has been written.
                  '''
        }
      }
      { window: {
          name: "RDATA"
          desc: '''DOE mailbox read data register
                If the Data Object Ready bit is Set, a read of this register returns the current DW of the data object.
                A write of any value to this register indicates a successful read of the current DWORD.
                The next read to this register shall return to the next DW from the data object being read
                '''
          items: "1"
          swaccess: "rw"
        }
      }
    ]
  }
}
