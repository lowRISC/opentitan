// Copyright lowRISC contributors.
// Licensed under the Apache License, Version 2.0, see LICENSE for details.
// SPDX-License-Identifier: Apache-2.0
{
  name: "debug_mode_regs",
  clocking: [
    {clock: "clk_i", reset: "rst_ni", primary: true},
  ]
  bus_interfaces: [
        { protocol: "tlul", direction: "device"}
    ],
  regwidth: "32",
  registers: [
    { name: "Payload_1",
      desc: "[76:44] payload bits",
      swaccess: "rw",
      hwaccess: "hro",
      fields: [
        { bits: "31:0" }
      ],
    },
    { name: "Payload_2",
      desc: "[43:11] payload bits",
      swaccess: "rw",
      hwaccess: "hro",
      fields: [
        { bits: "31:0" },
      ],
    },
    { name: "Payload_3",
      desc: "[10:0] payload bits + 0 padding",
      swaccess: "rw",
      hwaccess: "hro",
      fields: [
        { bits: "31:0" }
      ],
    },
    { name: "Address",
      desc: "Destination address of Payload",
      swaccess: "rw",
      hwaccess: "hro",
      fields: [
        { bits: "31:0" }
      ],
    },
    { name: "Start",
      desc: "Start bit to initialize write into phy flash",
      swaccess: "rw",
      hwaccess: "hrw",
      fields: [
        { bits: "31:1" },
        { bits: "0",
          name: "start",
          desc: "Start physical write",
        }
      ],
    },
    { name: "Debug_mode",
      desc: "If 1 debug_mode, 0 secure mode",
      swaccess: "rw",
      hwaccess: "hro",
      fields: [
        { bits: "31:1" },
        { bits: "0",
          name: "debug_mode",
          desc: "if 1 debug mode",
        }
      ],
    },
  ],
}