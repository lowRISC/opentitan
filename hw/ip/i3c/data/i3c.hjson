// Copyright lowRISC contributors (OpenTitan project).
// Licensed under the Apache License, Version 2.0, see LICENSE for details.
// SPDX-License-Identifier: Apache-2.0
{
  name:               "i3c",
  human_name:         "I3C",
  one_line_desc:      "I3C Controller/Target",
  one_paragraph_desc: '''I3C block'''
  // Unique comportable IP identifier defined under KNOWN_CIP_IDS in the regtool.
  cip_id:             "45",
  design_spec:        "../doc",
  dv_doc:             "../doc/dv",
  hw_checklist:       "../doc/checklist",
  sw_checklist:       "/sw/device/lib/dif/dif_i3c",
  revisions: [
  {
    version:            "1.0.0",
    life_stage:         "L2",
    design_stage:       "D3",
    verification_stage: "V3",
    commit_id:          "",
    notes:              ""
  }
  ]
  clocking: [
    {clock: "clk_i", reset: "rst_ni", primary: true}
    {clock: "clk_aon_i", reset: "rst_aon_ni"},
    // The scan_rst_ni port isn't listed here because it's generated by the
    // "scan_reset: true" below.
    {clock: "scan_clk_i"}
  ],
  bus_interfaces: [
    { protocol: "tlul", direction: "device", racl_support: true }
  ],
  available_inout_list: [
    { name: "ctrl_scl", desc: "I3C Controller clock" }
    { name: "ctrl_sda", desc: "I3C Controller data" }
    { name: "targ_sda", desc: "I3C Target data" }
  ],
  available_input_list: [
    { name: "targ_scl", desc: "I3C Target clock input" }
  ],
  available_output_list: [
    { name: "ctrl_scl_pp_en", desc: "I3C Controller clock Push-pull enable output" }
    { name: "ctrl_sda_pp_en", desc: "I3C Controller data Push-pull enable output" }
    { name: "ctrl_sda_od_en", desc: "I3C Controller data Open Drain enable output" }
    { name: "ctrl_scl_pu_en", desc: "I3C Controller clock Pullup enable output" }
    { name: "ctrl_sda_pu_en", desc: "I3C Controller clock Pullup enable output" }
    { name: "scl_hk_en", desc: "I3C Controller clock High-keeper enable output" }
    { name: "sda_hk_en", desc: "I3C Controller clock High-keeper enable output" }

    { name: "targ_sda_pp_en", desc: "I3C Target data Push-pull enable output" }
    { name: "targ_sda_od_en", desc: "I3C Target data Open Drain enable output" }
  ],
  interrupt_list: [
    // Global HCI interrupt, asserted when any HCI interrupt is pending.
    { name:    "hci",
      type:    "status",
      default: "0",
      desc:    "HCI interrupt."
    }
    // Global Target interrupt, asserted when any Target interrupt is pending.
    { name:    "targ",
      type:    "status",
      default: "0",
      desc:    "Target interrupt."
    }
  ],
  alert_list: [
    { name: "fatal_fault",
      desc: "This fatal alert is triggered when a fatal TL-UL bus integrity fault is detected."
    }
  ],
  inter_signal_list: [
    { struct:  "logic",
      package: "",
      type:    "uni",
      name:    "rstdet_enable",
      act:     "req"
    }
    { struct:  "i3c_rstdet_req"
      package: "i3c_pkg"
      type:    "uni"
      name:    "rstdet_req"
      act:     "req"
    }
    { struct:  "i3c_rstdet_rsp"
      package: "i3c_pkg"
      type:    "uni"
      name:    "rstdet_rsp"
      act:     "rcv"
    }
    { struct:  "logic"
      package: ""
      type:    "uni"
      name:    "mbist_en"
      act:     "rcv"
    }
    // RAM configuration
    { struct:  "ram_1p_cfg"
      package: "prim_ram_1p_pkg"
      type:    "uni"
      name:    "ram_cfg"
      act:     "rcv"
    }
    { struct:  "ram_1p_cfg_rsp"
      package: "prim_ram_1p_pkg"
      type:    "uni"
      name:    "ram_cfg_rsp"
      act:     "req"
    }
    { struct:  "ram_1p_cfg"
      package: "prim_ram_1p_pkg"
      type:    "uni"
      name:    "dat_cfg"
      act:     "rcv"
    }
    { struct:  "ram_1p_cfg_rsp"
      package: "prim_ram_1p_pkg"
      type:    "uni"
      name:    "dat_cfg_rsp"
      act:     "req"
    }
    { struct:  "ram_1p_cfg"
      package: "prim_ram_1p_pkg"
      type:    "uni"
      name:    "dct_cfg"
      act:     "rcv"
    }
    { struct:  "ram_1p_cfg_rsp"
      package: "prim_ram_1p_pkg"
      type:    "uni"
      name:    "dct_cfg_rsp"
      act:     "req"
    }
    { struct:  "racl_policy_vec",
      type:    "uni",
      name:    "racl_policies",
      act:     "rcv",
      package: "top_racl_pkg",
      desc:    '''Incoming RACL policy vector from a racl_ctrl instance.
               The policy selection vector (parameter) selects the policy for each register.
               '''
    }
    { struct:  "racl_error_log",
      type:    "uni",
      name:    "racl_error",
      act:     "req",
      width:   "1"
      package: "top_racl_pkg",
      desc:    "RACL error log information of this module."
    }
  ]
  scan: "true",       // Enable `scanmode_i` port
  scan_reset: "true", // Enable `scan_rst_ni` port
  param_list: [
    // TODO: Resolve this duplication of word counts and entry counts.
    // Device Address Table size in bus words; each entry consumes 8 bytes of address space.
    { name:    "NumDATWords",
      type:    "int unsigned",
      default: "64",
      desc:    "Size of the Device Address Table in bus words."
    },
    // Device Characteristics Table size in bus words; each entry consumes 16 bytes of address space.
    { name:    "NumDCTWords",
      type:    "int unsigned",
      default: "128",
      desc:    "Size of the Device Characteristics Table in bus words."
    }
    { name:    "NumDXTWords",
      type:    "int unsigned",
      default: "256",
      desc:    "Size of the Device Address Table and Device Characteristics Table in bus words."
    }
    { name:    "MaxTargets",
      type:    "int unsigned",
      default: "4",
      desc:    "The maximumm number of Virtual Targets supported."
    }
    { name:    "MaxGroups",
      type:    "int unsigned",
      default: "8",
      desc:    "The maximum number of Group Addresses supported on the Target side."
    }
  ]
  regwidth: "32",
  registers: [
    { name:     "INFO",
      desc:     "IP block information.",
      swaccess: "ro",
      hwaccess: "hwo",
      hwext:    "true",
      fields: [
        { bits:   "28:18"
          name:   "BUF_DWORD_MAX",
          desc:   '''Index of the final DWORD of the shared Message Buffer.
                  i.e. one less than its size in DWORDs.
                  ''',
          resval: "0x3ff"
        }
        { bits:   "17:13",
          name:   "DCT_ENTRY_MAX",
          desc:   '''Index of the final entry of the Device Characteristics Table.
                  i.e. one less than the number of entries.
                  ''',
          resval: "31"
        }
        { bits:   "12:8",
          name:   "DAT_ENTRY_MAX",
          desc:   '''Index of the final entry of the Device Address Table.
                  i.e. one less than the number of entries.
                  ''',
          resval: "31"
        }
        { bits:   "7:4",
          name:   "VERSION",
          desc:   "Version number of the IP block.",
          resval: "1"
        }
        { bits:   "3:0",
          name:   "REVISION",
          desc:   "Revision number of the IP block.",
          resval: "0"
        }
      ]
    }
    { name:     "CTRL_CONTROL",
      desc:     "Controller-side Control register.",
      swaccess: "rw",
      hwaccess: "hro",
      fields: [
        { bits:   "0",
          name:   "DUMMY",
          desc:   "Dummy field; no IP control signals yet.",
          resval: "0"
        }
      ]
    }
    { name:     "CTRL_STATUS",
      desc:     "Controller-side Status register.",
      swaccess: "ro",
      hwaccess: "hwo",
      hwext:    "true",
      fields: [
        { bits:   "31",
          name:   "PRESENT",
          desc:   "Indicates the presence of Controller-side logic.",
          resval: "0"
        }
      ]
    }
    { name: "CTRL_ERROR",
      desc: "Controller Error counts."
      swaccess: "rw1c",
      hwaccess: "hrw",
      fields: [
        { bits:   "15:12",
          name:   "CE3",
          desc:   "Count of type 3 Controller Errors.",
          resval: "0"
        }
        { bits:   "11:8",
          name:   "CE2",
          desc:   "Count of type 2 Controller Errors.",
          resval: "0"
        }
        { bits:   "7:4",
          name:   "CE1",
          desc:   "Count of type 1 Controller Errors.",
          resval: "0"
        }
        { bits:   "3:0",
          name:   "CE0",
          desc:   "Count of type 0 Controller Errors.",
          resval: "0"
        }
      ]
    }
    { name: "TARG_CONTROL",
      desc: "Target Control register.",
      fields: [
        // TODO: Shall we need to reset individual Virtual Targets in any sense?
        { bits:     "31",
          name:     "RESET",
          desc:     '''Software reset of Target logic.

                    Iff the Standby Controller support is disabled by clearing `STBY_CR_SUPPORT`, writing '1' to this field will reset all of the Target-side logic.
                    To reset the Target-side logic when Standby Controller support is enabled, software shall instead use the `SOFT_RST` field of the HCI-specified `RESET_CONTROL` register, whether or not the Controller is currently the Active Controller.
                    ''',
          hwqe:     "true",
          swaccess: "wo",
          hwaccess: "hro",
          resval:   "0"
        }
        { bits:     "30",
          name:     "HJ_REQUEST",
          desc:     '''Issue Hot-Join request.

                    This applies to all Virtual Target since they share a single physical Target.
                    Software shall set this to '1' to issue the request, and the hardware will clear
                    it when the request has been sent and acknowledged.
                    ''',
          hwqe:     "true",
          swaccess: "rw",
          hwaccess: "hrw",
          resval:   "0"
        }
        { bits:     "4",
          name:     "CRHDLY1_SET_AS",
          desc:     "Set Bus Activity State.",
          swaccess: "rw",
          hwaccess: "hro",
          resval:   "0"
        }
        { bits:     "3:2",
          name:     "CRHDLY1_AS",
          desc:     "Controller Handoff Activity State.",
          swaccess: "rw",
          hwaccess: "hro",
          resval:   "0"
        }
        { bits:     "1",
          name:     "STBY_CR_SUPPORT",
          desc:     '''Standby Controller role supported.

                    When set the Controller shall have the option of performing Controller Role handoff and switching into Standby Controller mode.
                    If this field is clear the Controller will refuse to handoff the bus when requested and will instead remain the Active Controller,
                    thus freeing up the first Virtual Target to operate independently as a dedicated Target device.
                    '''
          swaccess: "rw",
          hwaccess: "hro",
          resval:   "1"
        }
        { bits:     "0",
          name:     "EN",
          desc:     '''Target enable.

                    Enable the Target-side logic as a separate I3C device, instead of supporting Standby Controller mode.
                    In this configuration the Controller-side logic must remain the Active Controller and cannot perform Controller Role handoff.
                    ''',
          swaccess: "rw",
          hwaccess: "hro",
          resval:   "0"
        }
      ]
    }
    { name:     "TARG_STATUS",
      desc:     "Target-side Status register",
      swaccess: "ro",
      hwext:    "true",
      fields: [
        { bits:     "31",
          name:     "PRESENT",
          desc:     "Indicates the presence of Target-side logic.",
          hwaccess: "hwo",
          resval:   "1"
        }
        { bits:     "26",
          name:     "PROTOCOL_ERROR",
          desc:     "Protocol error detected since the last GETSTATUS CCC to read this indicator.",
          hwaccess: "hrw",
          resval:   "0"
        }
        { bits:     "25",
          name:     "VTM",
          desc:     "Vendor Test Mode active, in response to ENTTM.",
          hwaccess: "hwo",
          resval:   "0"
        }
        { bits:     "24",
          name:     "RSTACT_VIRT_TARG_DET",
          desc:     "RSTACT Virtual Target Detect.",
          hwaccess: "hwo",
          resval:   "0"
        }
        { bits:     "23:16",
          name:     "RSTACT",
          desc:     "Configured Target Reset action.",
          hwaccess: "hwo",
          resval:   "0"
        }
      ]
    }
    { name:     "TARG_SINK_CONTROL",
      desc:     "Target data sink control.",
      swaccess: "rw",
      fields: [
        { bits:     "31",
          name:     "START",
          desc:     '''Initiate removal of DWORDs from a transmission buffer.

                    The 'data sink' logic is a mechanism for recovering from aborting or failed transmissions without impacting subsequent, already-queued transfers.
                    Software shall write '1' to this field to start the 'data sink' logic.
                    The ACTIVE field in the corresponding `TARG_SINK_STATUS` register shows whether the logic is still active.
                    '''
          hwqe:     "true",
          hwaccess: "hrw",
          resval:   "0"
        }
        { bits:     "27:16",
          name:     "LENGTH",
          desc:     '''Specifies the number of DWORDs to be removed, minus 1.

                    This field instructs the 'data sink' logic to remove a specified number of DWORDs of data from the specified source.
                    Software shall program 'n-1' into this field to remove 'n' DWORDs.
                    '''
          hwaccess: "hrw",
          resval:   "0"
        }
        { bits:     "14:12",
          name:     "SRC",
          desc:     '''Specifies the transmission buffer from which DWORDs are to be removed.

                    0 - IBI Data buffer.
                    1 - Virtual Target 0
                    2 - Virtual Target 1...
                    ''',
          hwaccess: "hro",
          resval:   "0"
        }
      ]
    }
    { name:     "TARG_SINK_STATUS",
      desc:     "Target data sink status.",
      swaccess: "ro",
      hwaccess: "hwo",
      hwext:    "true",
      fields: [
        { bits:   "1",
          name:   "ERROR",
          desc:   '''Indicates whether the data sink mechanism stopped prematurely.
                  If the specified source buffer did not contain sufficient data for the logic to remove the specified number of DWORDs it will set this bit when becoming inactive.
                  '''
          resval: "0"
        }
        { bits:   "0",
          name:   "ACTIVE",
          desc:   '''Indicates whether the data sink logic is active.
                  This bit becomes set when the operation is started and will be cleared at most a few tens of microseconds later when the operation is complete.
                  '''
          resval: "0"
        }
      ]
    }
    // TODO: The reset detector requires an asynchronous clock signal for its register interface;
    // even though the reset detector logic itself operates on the SCL signal this cannot be used
    // for the register interface because doing so could stall the CPU indefinitely.
    // We're using `clk_aon_i` for this purpose.
    { name:     "RESET_DET_CTRL",
      desc:     "Reset detector control.",
      swaccess: "wo",
      hwaccess: "hro",
      hwext:    "true",
      hwqe:     "true",
      async:    "clk_aon_i",
      fields: [
        { bits:   "21",
          name:   "RST_TARGET_EN",
          desc:   "Enable response to a Whole Target request request.",
          resval: "0"
        }
        { bits:   "20",
          name:   "RST_PERIPH_EN",
          desc:   "Enable response to a Peripheral reset request.",
          resval: "0"
        }
        { bits:   "16",
          name:   "WAKE_ACK",
          desc:   "Wake acknowledgement.",
          resval: "0"
        }
        { bits:   "1",
          name:   "SLEEP_REQ",
          desc:   "Activate the reset detector prior to entry into 'Deepest Sleep' state.",
          resval: "0",
          tags: [// Prevent usb wake functions from being turned on outside of directed tests
                 "excl:CsrNonInitTests:CsrExclWrite"]
        }
      ]
    }
    { name:     "RESET_DET_STATUS",
      desc:     "Reset detector status.",
      swaccess: "ro",
      hwaccess: "hwo",
      async:    "clk_aon_i",
      fields: [
        { bits:   "3",
          name:   "RST_TARGET",
          desc:   "Indicates that a Whole Target reset requst was received.",
          resval: "0"
        }
        { bits:   "2",
          name:   "RST_PERIPH",
          desc:   "Indicates that a Peripheral request request was received.",
          resval: "0"
        }
        { bits:   "1",
          name:   "WAKE_UP",
          desc:   "Indicates that a Wake Up request was received.",
          resval: "0"
        },
        { bits:   "0",
          name:   "ACTIVE",
          desc:   "Indicates whether the reset detector is active.",
          resval: "0"
        }
      ]
    }
    { name:     "CTRL_TIME0",
      desc:     "Controller Timing Parameters 0",
      swaccess: "rw",
      hwaccess: "hro"
      fields: [
        { bits:   "25:16",
          name:   "TCAS_DIV2",
          desc:   '''Half of the delay between SDA falling and SCL falling in START timing, minus 1.
                  This interval is in terms of the IP clock period.
                  '''
          resval: "0"
        }
        { bits:   "9:0",
          name:   "TCBP_DIV2",
          desc:   '''Half of the delay between SCL rising and SDA rising in STOP timing, minus 1.
                  This interval is in terms of the IP clock period.
                  '''
          resval: "0"
        }
      ]
    }
    { name:     "CTRL_TIME1",
      desc:     "Controller Timing Parameters 1",
      swaccess: "rw",
      hwaccess: "hro"
      fields: [
        { bits:   "25:16",
          name:   "OD_SCLHI_DIV2",
          desc:   '''Half of the SCL high interval during Open Drain signaling, minus 1.
                  This interval is in terms of the IP clock period.
                  '''
          resval: "0x3ff"
        }
        { bits:   "9:0",
          name:   "OD_SCLLO_DIV2",
          desc:   '''Half of the SCL low interval during Open Drain signaling, minus 1.
                  This interval is in terms of the IP clock period.
                  '''
          resval: "0x3ff"
        }
      ]
    }
    { name:     "CTRL_TIME2",
      desc:     "Controller Timing Parameters 2",
      swaccess: "rw",
      hwaccess: "hro"
      fields: [
        { bits:   "25:16",
          name:   "PP_SCLHI_DIV2",
          desc:   '''Half of the SCL high interval during Push-Pull signaling, minus 1.
                  This interval is in terms of the IP clock period.
                  '''
          resval: "0x3ff"
        }
      ]
    }
    { name:     "CTRL_TIME3",
      desc:     "Controller Timing Parameters 3",
      swaccess: "rw",
      hwaccess: "hro"
      fields: [
        { bits:   "25:16",
          name:   "SDR1_SCLLO_DIV2",
          desc:   '''Half of the SCL low interval during Push-Pull signaling at SDR1 rate, minus 1.
                  This interval is in terms of the IP clock period.

                  This value is scaled in hardware to achieve SDR2-SDR4 rates.
                  '''
          resval: "0x3ff"
        }
        { bits:   "9:0",
          name:   "SDR0_SCLLO_DIV2",
          desc:   '''Half of the SCL low interval during Push-Pull signaling at SDR0 rate, minus 1.
                  This interval is in terms of the IP clock period.
                  '''
          resval: "0x3ff"
        }
      ]
    }
    { name:     "CTRL_TIME4",
      desc:     "Controller Timing Parameters 4",
      swaccess: "rw",
      hwaccess: "hro"
      fields: [
        { bits:   "25:16",
          name:   "FMP_SCLHI_DIV2",
          desc:   '''Half of the SCL high interval during I2C Fast Mode Plus signaling, minus 1.
                  This interval is in terms of the IP clock period.
                  '''
          resval: "0x3ff"
        }
        { bits:   "9:0",
          name:   "FMP_SCLLO_DIV2",
          desc:   '''Half of the SCL low interval during I2C Fast Mode Plus signaling, minus 1.
                  This interval is in terms of the IP clock period.
                  '''
          resval: "0x3ff"
        }
      ]
    }
    { name:     "CTRL_TIME5",
      desc:     "Controller Timing Parameters 5",
      swaccess: "rw",
      hwaccess: "hro"
      fields: [
        { bits:   "25:16",
          name:   "FM_SCLHI_DIV2",
          desc:   '''Half of the SCL high interval during I2C Fast Mode signaling, minus 1.
                  This interval is in terms of the IP clock period.
                  '''
          resval: "0x3ff"
        }
        { bits:   "9:0",
          name:   "FM_SCLLO_DIV2",
          desc:   '''Half of the SCL low interval during I2C Fast Mode signaling, minus 1.
                  This interval is in terms of the IP clock period.
                  '''
          resval: "0x3ff"
        }
      ]
    }
    { name:     "INT_TIME0",
      desc:     '''Interval Timers 0 register.
                Time intervals are specified in microseconds.
                '''
      swaccess: "rw",
      hwaccess: "hro",
      fields: [
        { bits:   "31:16",
          name:   "DEAD_BUS",
          desc:   "Timer interval for Dead Bus condition.",
          resval: "0xc350"
        }
        { bits:   "15:12",
          name:   "CTRL_BUS_AVAIL",
          desc:   "Timer interval for Controller Bus Available condition.",
          resval: "1"
        }
        { bits:   "11:0",
          name:   "READ_STALLED",
          desc:   '''Timer interval for SDA read stalled detection
                  (no Controller SCL activity during Read Transfer).
                  '''
          resval: "0x96"
        }
      ]
    }
    { name:     "INT_TIME1",
      desc:     '''Interval Timers 1 register.
                Time intervals are specified in microseconds.
                '''
      swaccess: "rw",
      hwaccess: "hro",
      fields: [
        { bits:   "31:28",
          name:   "TARG_BUS_AVAIL",
          desc:   "Timer interval for Target Bus Available condition.",
          resval: "1"
        }
        { bits:   "27:24",
          name:   "TARG_TRX_RST",
          desc:   "",
          // TODO: This was set to 0x32; onerous for testing.
          resval: "1"
        }
        { bits:   "23:12",
          name:   "TE0_RECOV",
          desc:   "",
          resval: "0x3c"
        }
        { bits:   "11:0",
          name:   "TARG_BUS_IDLE",
          desc:   "Timer interval for Target Bus Idle condition.",
          resval: "0xc8"
        }
      ]
    }
    { name:     "PHY_CONFIG",
      desc:     "PHY configuration",
      swaccess: "rw",
      hwaccess: "hro",
      fields: [
        { bits:   "31",
          name:   "CTRL_DIRECT_DRIVE_EN",
          desc:   "Enable direct driving of SCL and SDA by software.",
          resval: "0"
        }
        // SCL-related Controller outputs in direct-driving mode.
        { bits:   "27",
          name:   "CTRL_SCL_PP_EN",
          desc:   "Enable push-pull driving of SCL in direct-driving mode, when open rain driving is not also enabled.",
          resval: "0"
        }
        { bits:   "26",
          name:   "CTRL_SCL_OD_EN",
          desc:   "Enable open drain driving of SCL in direct-driving mode.",
          resval: "0"
        }
        { bits:   "25",
          name:   "CTRL_SCL_PU_EN",
          desc:   "Enable pull-up on SCL in direct-driving mode.",
          resval: "0",
        }
        { bits:   "24",
          name:   "CTRL_SCL",
          desc:   "State of SCL line when direct-driving is enabled.",
          resval: "1"
        }
        // SDA-related Controller outputs in direct-driving mode.
        { bits:   "23",
          name:   "CTRL_SDA_PP_EN",
          desc:   "Enable push-pull driving of SDA in direct-driving mode, when open drain driving is not also enabled.",
          resval: "0"
        }
        { bits:   "22",
          name:   "CTRL_SDA_OD_EN",
          desc:   "Enable open drain driving of SDA in direct-driving mode.",
          resval: "0"
        }
        { bits:   "21",
          name:   "CTRL_SDA_PU_EN",
          desc:   "Enable pull-up on SDA in direct-driving mode.",
          resval: "0",
        }
        { bits:   "20",
          name:   "CTRL_SDA",
          desc:   "State of SDA line when direct-driving is enabled.",
          resval: "1"
        }
        { bits:   "1",
          name:   "SDA_HK_EN",
          desc:   "High-keeper enable for SDA.",
          resval: "1"
        }
        { bits:   "0",
          name:   "SCL_HK_EN",
          desc:   "High-keeper enable for SCL.",
          resval: "1"
        }
      ]
    }
    { name:     "BLOCKED_ADDR",
      desc:     '''Blocked target addresses.
                The controller will raise an error if any attempt is made to access a blocked target address.
                This feature is intended to safeguard against inadvertent accesses to any I2C device that may try to employ clock-stretching, but it may also be of use diagnostically.
                ''',
      swaccess: "rw",
      hwaccess: "hro",
      fields: [
        { bits:   "30:24",
          name:   "MASK1",
          desc:   '''Address mask for the second set of blocked addresses.
                  If this field is zero then 'ADDR1' is implicitly not used.
                  '''
          resval: "0"
        }
        { bits:   "22:16",
          name:   "ADDR1",
          desc:   "Second blocked address.",
          resval: "0"
        }
        { bits:   "14:8",
          name:   "MASK0",
          desc:   '''Address mask for the first set of blocked addresses.

                  This mask determines which bits of the device address will be tested and matched against the address in 'ADDR0'.
                  I2C devices are commonly configured with one of a small set of static addresses, differing in only one two address bits.
                  If this field is zero then 'ADDR0' is implicitly not used.
                  '''
          resval: "0"
        }
        { bits:   "6:0",
          name:   "ADDR0",
          desc:   "First blocked address.",
          resval: "0"
        }
      ]
    }
    { name:     "BUFFER_CTRL",
      desc:     "Buffer control",
      hwqe:     "true",
      hwext:    "true",
      fields: [
        { bits:     "31",
          name:     "CLEAR",
          desc:     '''Software clear of buffer state including the following:
                    - All `WPTR` and `RPTR` values are set to the corresponding
                    the `MIN` values, emptying all circular buffers.
                    '''
          swaccess: "wo",
          hwaccess: "hro",
          resval:   "0"
        }
        { bits:     "29:28",
          name:     "SW_ADDR_HI",
          desc:     '''Supplies the high address bits when software performs direct accesses to the
                    internal message buffer.
                    '''
          swaccess: "rw",
          hwaccess: "hrw",
          resval:   "0"
        }
      ]
    }
    { name:     "BUFFER_STATUS",
      desc:     "Buffer status",
      fields: [
        { bits:   "31",
          name:   "HCIQ_ERR",
          desc:   '''Diagnostic error indicator for the HCI queues.
                  The hardware sets this bit in the event of a write to a full or read-only queue, or a read from an empty or write-only queue.
                  Software shall clear this bit by writing '1'.
                  '''
          swaccess: "rw1c",
          hwaccess: "hwo",
          resval:   "0"
        }
        { bits:   "30",
          name:   "TTIQ_ERR",
          desc:   '''Diagnostic error indicator for the TTI queues.
                  The hardware sets this bit in the event of a write to a full or read-only queue, or a read from an empty or write-only queue.
                  Software shall clear this bit by writing '1'.
                  '''
          swaccess: "rw1c",
          hwaccess: "hwo",
          resval:   "0"
        }
      ]
    }
    // Controller Transmission Buffer.
    { name:     "CTRL_TXBUF_CONFIG",
      desc:     "Controller TX Buffer Configuration",
      swaccess: "rw",
      hwaccess: "hro",
      fields: [
        { bits:   "30:28",
          name:   "SIZE_VAL",
          desc:   '''Size value presented as `QUEUE_SIZE.TX_DATA_BUFFER_SIZE`.
                  This value is log2(size in DWORDs) - 1.
                  '''
          resval: "6"
        }
        { bits:   "25:16",
          name:   "MAX_ADDR",
          desc:   "Maximum address for Controller TX use (inclusive).",
          resval: "0x7f"
        }
        { bits:   "9:0",
          name:   "MIN_ADDR",
          desc:   "Minimum address for Controller TX use.",
          resval: "0"
        }
      ]
    }
    { name:     "CTRL_TXBUF_STATE",
      desc:     "Controller TX Buffer State.",
      swaccess: "ro",
      hwaccess: "hwo",
      hwext:    "true",
      fields: [
        { bits:   "31",
          name:   "FULL",
          desc:   "Indicates if the buffer is full.",
          resval: "0"
        }
        { bits:   "30",
          name:   "PRE",
          desc:   "Indicates if prefetched data is available.",
          resval: "0"
        }
        { bits:   "25:16",
          name:   "RPTR",
          desc:   "Current read pointer.",
          resval: "0"
        }
        { bits:   "9:0",
          name:   "WPTR",
          desc:   "Current write pointer.",
          resval: "0"
        }
      ]
    }
    // Controller Reception Buffer.
    { name:     "CTRL_RXBUF_CONFIG",
      desc:     "Controller RX Buffer Configuration",
      swaccess: "rw",
      hwaccess: "hro",
      fields: [
        { bits:    "30:28",
          name:    "SIZE_VAL",
          desc:    '''Size value presented as `QUEUE_SIZE.TX_DATA_BUFFER_SIZE`.
                   This value is log2(size in DWORDs) - 1.
                   '''
          resval:  "6"
        }
        { bits:   "25:16",
          name:   "MAX_ADDR",
          desc:   "Maximum address for Controller RX use (inclusive).",
          resval: "0xff"
        }
        { bits:   "9:0",
          name:   "MIN_ADDR",
          desc:   "Minimum address for Controller RX use.",
          resval: "0x80"
        }
      ]
    }
    { name:     "CTRL_RXBUF_STATE",
      desc:     "Controller RX Buffer State.",
      swaccess: "ro",
      hwaccess: "hwo",
      hwext:    "true",
      fields: [
        { bits:   "31",
          name:   "FULL",
          desc:   "Indicates if the buffer is full.",
          resval: "0"
        }
        { bits:   "30",
          name:   "PRE",
          desc:   "Indicates if prefetched data is available.",
          resval: "0"
        }
        { bits:   "25:16",
          name:   "RPTR",
          desc:   "Current read pointer.",
          resval: "0x80"
        }
        { bits:   "9:0",
          name:   "WPTR",
          desc:   "Current write pointer.",
          resval: "0x80"
        }
      ]
    }
    // Controller Command Queue.
    { name:     "COMMAND_QUEUE_CONFIG",
      desc:     "Command Queue Configuration.",
      swaccess: "rw",
      hwaccess: "hro",
      fields: [
        { bits:    "31:24",
          name:    "SIZE_VAL",
          desc:    '''Size value presented as `QUEUE_SIZE.CR_QUEUE_SIZE`.
                   '''
          resval:  "16"
        }
        { bits:   "21:12",
          name:   "MAX_ADDR",
          desc:   "Maximum address for Command Queue use (inclusive).",
          resval: "0x11f"
        }
        { bits:   "9:0",
          name:   "MIN_ADDR",
          desc:   "Minimum address for Command Queue use.",
          resval: "0x100"
        }
      ]
    }
    { name:     "COMMAND_QUEUE_STATE",
      desc:     "Command Queue State.",
      swaccess: "ro",
      hwaccess: "hwo",
      hwext:    "true",
      fields: [
        { bits:   "31",
          name:   "FULL",
          desc:   "Indicates if the queue is full.",
          resval: "0"
        }
        { bits:   "30",
          name:   "PRE",
          desc:   "Indicates if prefetched data is available.",
          resval: "0"
        }
        { bits:   "25:16",
          name:   "RPTR",
          desc:   "Current read pointer.",
          resval: "0x100"
        }
        { bits:   "9:0",
          name:   "WPTR",
          desc:   "Current write pointer.",
          resval: "0x100"
        }
      ]
    }
    // Controller Response Queue.
    { name:     "RESPONSE_QUEUE_CONFIG",
      desc:     "Response Queue Configuration.",
      swaccess: "rw",
      hwaccess: "hro",
      fields: [
        { bits:    "31:24",
          name:    "SIZE_VAL",
          desc:    '''Size value presented as `ALT_QUEUE_SIZE.ALT_RSP_QUEUE_SIZE`.
                   '''
          resval:  "16"
        }
        { bits:   "21:12",
          name:   "MAX_ADDR",
          desc:   "Maximum address for Response Queue use (inclusive).",
          resval: "0x12f"
        }
        { bits:   "9:0",
          name:   "MIN_ADDR",
          desc:   "Minimum address for Response Queue use.",
          resval: "0x120"
        }
      ]
    }
    { name:     "RESPONSE_QUEUE_STATE",
      desc:     "Response Queue State.",
      swaccess: "ro",
      hwaccess: "hwo",
      hwext:    "true",
      fields: [
        { bits:   "31",
          name:   "FULL",
          desc:   "Indicates if the queue is full.",
          resval: "0"
        }
        { bits:   "30",
          name:   "PRE",
          desc:   "Indicates if prefetched data is available.",
          resval: "0"
        }
        { bits:   "25:16",
          name:   "RPTR",
          desc:   "Current read pointer.",
          resval: "0x120"
        }
        { bits:   "9:0",
          name:   "WPTR",
          desc:   "Current write pointer.",
          resval: "0x120"
        }
      ]
    }
    // Controller IBI Data Buffer.
    { name:     "IBI_CONFIG",
      desc:     "In-Band Interrupt Queue Configuration.",
      swaccess: "rw",
      hwaccess: "hro",
      fields: [
        { bits:    "31:24",
          name:    "SIZE_VAL",
          desc:    '''Size value presented as `QUEUE_SIZE.IBI_STATUS_SIZE`.

                   This value represents the sum of the IBI Queue and the IBI Status Descriptor FIFO.
                   Since EXT_IBI_QUEUE_EN is set, the actual number of DWORDs is 8 times this value.
                   '''
          resval:  "12"
        }
        { bits:   "21:12",
          name:   "MAX_ADDR",
          desc:   "Maximum address for IBI Queue use (inclusive).",
          resval: "0x1af"
        }
        { bits:   "9:0",
          name:   "MIN_ADDR",
          desc:   "Minimum address for IBI Queue use.",
          resval: "0x130"
        }
      ]
    }
    { name:     "IBI_STATE",
      desc:     "In-Band Interrupt Queue State.",
      swaccess: "ro",
      hwaccess: "hwo",
      hwext:    "true",
      fields: [
        { bits:   "31",
          name:   "FULL",
          desc:   "Indicates if the queue is full.",
          resval: "0"
        }
        { bits:   "30",
          name:   "PRE",
          desc:   "Indicates if prefetched data is available.",
          resval: "0"
        }
        { bits:   "25:16",
          name:   "RPTR",
          desc:   "Current read pointer.",
          resval: "0x130"
        }
        { bits:   "9:0",
          name:   "WPTR",
          desc:   "Current write pointer.",
          resval: "0x130"
        }
      ]
    }
    // Controller IBI Status Descriptor Queue.
    { name:     "IBI_STAT_CONFIG",
      desc:     "In-Band Status Descriptor FIFO Configuration.",
      swaccess: "rw",
      hwaccess: "hro",
      fields: [
        { bits:   "21:12",
          name:   "MAX_ADDR",
          desc:   "Maximum address for IBI Status Descriptor FIFO use (inclusive).",
          resval: "0x1cf"
        }
        { bits:   "9:0",
          name:   "MIN_ADDR",
          desc:   "Minimum address for IBI Status Descriptor FIFO use.",
          resval: "0x1b0"
        }
      ]
    }
    { name:     "IBI_STAT_STATE",
      desc:     "In-Band Status Descriptor FIFO State.",
      swaccess: "ro",
      hwaccess: "hwo",
      hwext:    "true",
      fields: [
        { bits:   "31",
          name:   "FULL",
          desc:   "Indicates if the FIFO is full.",
          resval: "0"
        }
        { bits:   "30",
          name:   "PRE",
          desc:   "Indicates if prefetched data is available.",
          resval: "0"
        }
        { bits:   "25:16",
          name:   "RPTR",
          desc:   "Current read pointer.",
          resval: "0x1b0"
        }
        { bits:   "9:0",
          name:   "WPTR",
          desc:   "Current write pointer.",
          resval: "0x1b0"
        }
      ]
    }
    // TODO: These Target-side registers should be multireg and support 4 in order to keep
    // the register map unchanged!
    // Target 0 Transmission Buffer.
    { name:     "TARG0_TXBUF_CONFIG",
      desc:     "Target 0 TX Buffer Configuration",
      swaccess: "rw",
      hwaccess: "hro",
      fields: [
        { bits:   "25:16",
          name:   "MAX_ADDR",
          desc:   "Maximum address for Target 0 TX use (inclusive).",
          resval: "0x24f"
        }
        { bits:   "9:0",
          name:   "MIN_ADDR",
          desc:   "Minimum address for Target 0 TX use.",
          resval: "0x1d0"
        }
      ]
    }
    { name:     "TARG0_TXBUF_STATE",
      desc:     "Target 0 TX Buffer State.",
      swaccess: "ro",
      hwaccess: "hwo",
      hwext:    "true",
      fields: [
        { bits:   "31",
          name:   "FULL",
          desc:   "Indicates if the buffer is full.",
          resval: "0"
        }
        { bits:   "30",
          name:   "PRE",
          desc:   "Indicates if prefetched data is available.",
          resval: "0"
        }
        { bits:   "25:16",
          name:   "RPTR",
          desc:   "Current read pointer.",
          resval: "0x1d0"
        }
        { bits:   "9:0",
          name:   "WPTR",
          desc:   "Current write pointer.",
          resval: "0x1d0"
        }
      ]
    }
    // Target 1 Transmission Buffer.
    { name:     "TARG1_TXBUF_CONFIG",
      desc:     "Target 1 TX Buffer Configuration",
      swaccess: "rw",
      hwaccess: "hro",
      fields: [
        { bits:   "25:16",
          name:   "MAX_ADDR",
          desc:   "Maximum address for Target 1 TX use (inclusive).",
          resval: "0x2cf"
        }
        { bits:   "9:0",
          name:   "MIN_ADDR",
          desc:   "Minimum address for Target 1 TX use.",
          resval: "0x250"
        }
      ]
    }
    { name:     "TARG1_TXBUF_STATE",
      desc:     "Target 1 TX Buffer State.",
      swaccess: "ro",
      hwaccess: "hwo",
      hwext:    "true",
      fields: [
        { bits:   "31",
          name:   "FULL",
          desc:   "Indicates if the buffer is full.",
          resval: "0"
        }
        { bits:   "30",
          name:   "PRE",
          desc:   "Indicates if prefetched data is available.",
          resval: "0"
        }
        { bits:   "25:16",
          name:   "RPTR",
          desc:   "Current read pointer.",
          resval: "0x250"
        }
        { bits:   "9:0",
          name:   "WPTR",
          desc:   "Current write pointer.",
          resval: "0x250"
        }
      ]
    }
    // Target Reception Buffer.
    { name:     "TARG_RXBUF_CONFIG",
      desc:     "Target RX Buffer Configuration",
      swaccess: "rw",
      hwaccess: "hro",
      fields: [
        { bits:   "25:16",
          name:   "MAX_ADDR",
          desc:   "Maximum address for Target RX use (inclusive).",
          resval: "0x36f"
        }
        { bits:   "9:0",
          name:   "MIN_ADDR",
          desc:   "Minimum address for Target RX use.",
          resval: "0x2d0"
        }
      ]
    }
    { name:     "TARG_RXBUF_STATE",
      desc:     "Target RX Buffer State.",
      swaccess: "ro",
      hwaccess: "hwo",
      hwext:    "true",
      fields: [
        { bits:   "31",
          name:   "FULL",
          desc:   "Indicates if the buffer is full.",
          resval: "0"
        }
        { bits:   "30",
          name:   "PRE",
          desc:   "Indicates if prefetched data is available.",
          resval: "0"
        }
        { bits:   "25:16",
          name:   "RPTR",
          desc:   "Current read pointer.",
          resval: "0x2d0"
        }
        { bits:   "9:0",
          name:   "WPTR",
          desc:   "Current write pointer.",
          resval: "0x2d0"
        }
      ]
    }
    // Target In-Band Interrupt Payload Queue.
    { name:     "TARG_IBI_CONFIG",
      desc:     "Target In-Band Interrupt Payload Queue Configuration",
      swaccess: "rw",
      hwaccess: "hro",
      fields: [
        { bits:   "25:16",
          name:   "MAX_ADDR",
          desc:   "Maximum address for Target RX data use (inclusive).",
          resval: "0x3af"
        }
        { bits:   "9:0",
          name:   "MIN_ADDR",
          desc:   "Minimum address for Target IBI data use.",
          resval: "0x370"
        }
      ]
    }
    { name:     "TARG_IBI_STATE",
      desc:     "Target In-Band Interrupt Payload Queue State.",
      swaccess: "ro",
      hwaccess: "hwo",
      hwext:    "true",
      fields: [
        { bits:   "31",
          name:   "FULL",
          desc:   "Indicates if the buffer is full.",
          resval: "0"
        }
        { bits:   "30",
          name:   "PRE",
          desc:   "Indicates if prefetched data is available.",
          resval: "0"
        }
        { bits:   "25:16",
          name:   "RPTR",
          desc:   "Current read pointer.",
          resval: "0x370"
        }
        { bits:   "9:0",
          name:   "WPTR",
          desc:   "Current write pointer.",
          resval: "0x370"
        }
      ]
    }
    // Target 0 Transmission Descriptor Queue.
    { name:     "TARG0_TXDESC_CONFIG",
      desc:     "Target 0 Transmission Descriptor Queue Configuration.",
      swaccess: "rw",
      hwaccess: "hro",
      fields: [
        { bits:   "25:16",
          name:   "MAX_ADDR",
          desc:   "Maximum address for Target 0 Tx Descriptor Queue use (inclusive).",
          resval: "0x3bf"
        }
        { bits:   "9:0",
          name:   "MIN_ADDR",
          desc:   "Minimum address for Target 0 Tx Descriptor Queue use.",
          resval: "0x3b0"
        }
      ]
    }
    { name:     "TARG0_TXDESC_STATE",
      desc:     "Target 0 Transmission Descriptor Queue State.",
      swaccess: "ro",
      hwaccess: "hwo",
      hwext:    "true",
      fields: [
        { bits:   "31",
          name:   "FULL",
          desc:   "Indicates if the queue is full.",
          resval: "0"
        }
        { bits:   "30",
          name:   "PRE",
          desc:   "Indicates if prefetched data is available.",
          resval: "0"
        }
        { bits:   "25:16",
          name:   "RPTR",
          desc:   "Current read pointer.",
          resval: "0x3b0"
        }
        { bits:   "9:0",
          name:   "WPTR",
          desc:   "Current write pointer.",
          resval: "0x3b0"
        }
      ]
    }
    // Target 1 Transmission Descriptor Queue.
    { name:     "TARG1_TXDESC_CONFIG",
      desc:     "Target 1 Transmission Descriptor Queue Configuration.",
      swaccess: "rw",
      hwaccess: "hro",
      fields: [
        { bits:   "25:16",
          name:   "MAX_ADDR",
          desc:   "Maximum address for Target 1 Tx Descriptor Queue use (inclusive).",
          resval: "0x3cf"
        }
        { bits:   "9:0",
          name:   "MIN_ADDR",
          desc:   "Minimum address for Target 1 Tx Descriptor Queue use.",
          resval: "0x3c0"
        }
      ]
    }
    { name:     "TARG1_TXDESC_STATE",
      desc:     "Target 1 Transmission Descriptor Queue State.",
      swaccess: "ro",
      hwaccess: "hwo",
      hwext:    "true",
      fields: [
        { bits:   "31",
          name:   "FULL",
          desc:   "Indicates if the queue is full.",
          resval: "0"
        }
        { bits:   "30",
          name:   "PRE",
          desc:   "Indicates if prefetched data is available.",
          resval: "0"
        }
        { bits:   "25:16",
          name:   "RPTR",
          desc:   "Current read pointer.",
          resval: "0x3c0"
        }
        { bits:   "9:0",
          name:   "WPTR",
          desc:   "Current write pointer.",
          resval: "0x3c0"
        }
      ]
    }
    // Target Reception Descriptor Queue.
    { name:     "TARG_RXDESC_CONFIG",
      desc:     "Target Reception Descriptor Queue Configuration.",
      swaccess: "rw",
      hwaccess: "hro",
      fields: [
        { bits:   "25:16",
          name:   "MAX_ADDR",
          desc:   "Maximum address for Target Rx Descriptor Queue use (inclusive).",
          resval: "0x3df"
        }
        { bits:   "9:0",
          name:   "MIN_ADDR",
          desc:   "Minimum address for Target Rx Descriptor Queue use.",
          resval: "0x3d0"
        }
      ]
    }
    { name:     "TARG_RXDESC_STATE",
      desc:     "Target Reception Descriptor Queue State.",
      swaccess: "ro",
      hwaccess: "hwo",
      hwext:    "true",
      fields: [
        { bits:   "31",
          name:   "FULL",
          desc:   "Indicates if the queue is full.",
          resval: "0"
        }
        { bits:   "30",
          name:   "PRE",
          desc:   "Indicates if prefetched data is available.",
          resval: "0"
        }
        { bits:   "25:16",
          name:   "RPTR",
          desc:   "Current read pointer.",
          resval: "0x3d0"
        }
        { bits:   "9:0",
          name:   "WPTR",
          desc:   "Current write pointer.",
          resval: "0x3d0"
        }
      ]
    }
    // Target In-Band Interrupt Descriptor Queue.
    { name:     "TARG_IBIDESC_CONFIG",
      desc:     "Target In-Band Interrupt Descriptor Queue Configuration.",
      swaccess: "rw",
      hwaccess: "hro",
      fields: [
        { bits:   "25:16",
          name:   "MAX_ADDR",
          desc:   "Maximum address for Target IBI Descriptor Queue use (inclusive).",
          resval: "0x3ef"
        }
        { bits:   "9:0",
          name:   "MIN_ADDR",
          desc:   "Minimum address for Target IBI Descriptor Queue use.",
          resval: "0x3e0"
        }
      ]
    }
    { name:     "TARG_IBIDESC_STATE",
      desc:     "Target In-Band Interrupt Descriptor Queue State.",
      swaccess: "ro",
      hwaccess: "hwo",
      hwext:    "true",
      fields: [
        { bits:   "31",
          name:   "FULL",
          desc:   "Indicates if the queue is full.",
          resval: "0"
        }
        { bits:   "30",
          name:   "PRE",
          desc:   "Indicates if prefetched data is available.",
          resval: "0"
        }
        { bits:   "25:16",
          name:   "RPTR",
          desc:   "Current read pointer.",
          resval: "0x3e0"
        }
        { bits:   "9:0",
          name:   "WPTR",
          desc:   "Current write pointer.",
          resval: "0x3e0"
        }
      ]
    }
    // Target Asynchronous Event Queue.
    { name:     "TARG_ASYNC_CONFIG",
      desc:     "Target Asynchronous Event Queue Configuration.",
      swaccess: "rw",
      hwaccess: "hro",
      fields: [
        { bits:   "25:16",
          name:   "MAX_ADDR",
          desc:   "Maximum address for Target Asynchronous Event Queue use (inclusive).",
          resval: "0x3ff"
        }
        { bits:   "9:0",
          name:   "MIN_ADDR",
          desc:   "Minimum address for Target Asynchronous Event Queue use.",
          resval: "0x3f0"
        }
      ]
    }
    { name:     "TARG_ASYNC_STATE",
      desc:     "Target Asynchronous Event Queue State.",
      swaccess: "ro",
      hwaccess: "hwo",
      hwext:    "true",
      fields: [
        { bits:   "31",
          name:   "FULL",
          desc:   "Indicates if the queue is full.",
          resval: "0"
        }
        { bits:   "30",
          name:   "PRE",
          desc:   "Indicates if prefetched data is available.",
          resval: "0"
        }
        { bits:   "25:16",
          name:   "RPTR",
          desc:   "Current read pointer.",
          resval: "0x3f0"
        }
        { bits:   "9:0",
          name:   "WPTR",
          desc:   "Current write pointer.",
          resval: "0x3f0"
        }
      ]
    }
    // Leave some space for additional registers before the HCI registers start.
    { skipto:   "0x100" },
    { name:     "HCI_VERSION",
      desc:     "HCI Version."
      swaccess: "ro",
      hwaccess: "hwo",
      hwext:    "true",
      fields: [
        { bits:   "31:0",
          name:   "VERSION",
          desc:   "HCI Version."
          resval: "0x120"
        }
      ]
    },
    { name:     "HC_CONTROL",
      desc:     "Host Controller Control.",
      swaccess: "rw",
      hwaccess: "hrw",
      hwext:    "true",
      fields: [
        { bits:     "31",
          name:     "BUS_ENABLE",
          desc:     "Host Controller Bus Enable.",
          hwqe:     "true",
          resval:   "0"
        },
        { bits:     "30",
          name:     "RESUME",
          desc:     "Host Controller Resume.",
          hwqe:     "true",
          resval:   "0"
        },
        { bits:     "29",
          name:     "ABORT",
          desc:     "Host Controller Abort.",
          hwqe:     "true",
          resval:   "0"
        },
        { bits:     "12",
          name:     "HALT_ON_CMD_SEQ_TIMEOUT",
          desc:     "Halt on Command Sequence Timeout.",
          hwqe:     "true",
          resval:   "0"
        },
        { bits:     "8",
          name:     "HOT_JOIN_CTRL",
          desc:     "Hot-Join ACK/NACK Control.",
          hwqe:     "true",
          resval:   "0"
        },
        { bits:     "7",
          name:     "I2C_DEV_PRESENT",
          desc:     "I2C Device Present on Bus.",
          hwqe:     "true",
          resval:   "0"
        },
        { bits:     "6",
          name:     "MODE_SELECTOR",
          desc:     "DMA/PIO Mode Selector.",
          swaccess: "ro",
          hwaccess: "hwo",
          resval:   "1"
        },
        { bits:     "4",
          name:     "DATA_BYTE_ORDER_MODE",
          desc:     "Data Byte Ordering Mode.",
          swaccess: "ro",
          hwaccess: "hwo",
          resval:   "0"
        },
        { bits:     "3",
          name:     "AUTOCMD_DATA_RPT",
          desc:     "Auto-Command Data Report.",
          hwqe:     "true",
          resval:   "1"
        },
        { bits:     "0",
          name:     "IBA_INCLUDE",
          desc:     "Include I3C Broadcast Address.",
          hwqe:     "true",
          resval:   "0"
        }
      ]
    },
    { name:     "CONTROLLER_DEVICE_ADDR",
      desc:     "Controller Device Address.",
      swaccess: "rw",
      hwaccess: "hrw",
      hwext:    "true",
      hwqe:     "true",
      fields: [
        { bits:   "31",
          name:   "DYNAMIC_ADDR_VALID",
          desc:   "Dynamic Address is Valid.",
          resval: "0"
        }
        { bits:   "22:16",
          name:   "DYNAMIC_ADDR",
          desc:   "Device Dynamic Address.",
          resval: "0"
        }
      ]
    },
    { name:     "HC_CAPABILITIES",
      desc:     "Host Controller Capabilities.",
      swaccess: "ro",
      hwaccess: "hwo",
      hwext:    "true",
      fields: [
        { bits:   "30",
          name:   "SG_CAPABILITY_DC_EN",
          desc:   "Defines whether the Host Controller supports Scatter-Gather for DC.",
          resval: "0"
        }
        { bits:   "29",
          name:   "SG_CAPABILITY_IBI_EN",
          desc:   "Defines whether the Host Controller supports Scatter-Gather for IBI.",
          resval: "0"
        }
        { bits:   "28",
          name:   "SG_CAPABILITY_CR_EN",
          desc:   "Defines whether the Host Controller supports Scatter-Gather for CR.",
          resval: "0"
        }
        { bits:   "21:20",
          name:   "CMD_SIZE",
          desc:   "Defines the size and structure of the Command Descriptor supported by the Host Controller.",
          resval: "0"
        }
        { bits:   "13",
          name:   "SCHEDULE_COMMANDS_EN",
          desc:   "Defines whether the Host Controller supports Scheduled Commands capabilities.",
          resval: "1"
        }
        { bits:   "12",
          name:   "IBI_CREDIT_COUNT_EN",
          desc:   "Defines whether the Host Controller supports Target IBI Credit Counting.",
          resval: "1"
        }
        { bits:   "11",
          name:   "IBI_DATA_ABORT_EN",
          desc:   "Defines whether the Host Controller supports the IBI Data Abort operation.",
          resval: "1"
        }
        { bits:   "10",
          name:   "CMD_CCC_DEFBYTE",
          desc:   "Defines whether the Host Controller supports Transfer Commands that indicate CCCs when Defining Bytes.",
          resval: "1"
        }
        { bits:   "7",
          name:   "HDR_TS_EN",
          desc:   "Defines whether the Host Controller supports HDR-Ternary transfers.",
          resval: "0"
        }
        { bits:   "6",
          name:   "HDR_DDR_EN",
          desc:   "Defines whether the Host Controller supports HDR-DDR transfers.",
          resval: "1"
        }
        { bits:   "5",
          name:   "STANDBY_CR_CAP",
          desc:   "Defines whether the Host Controller supports handoff of the Active Controller role.",
          resval: "1"
        }
        { bits:   "3",
          name:   "AUTO_COMMAND",
          desc:   "Defines whether the Host Controller supports Auto-Command functionality.",
          resval: "1"
        }
        { bits:   "2",
          name:   "COMBO_COMMAND",
          desc:   "Defines whether the Host Controller supports Combo Transfer Command transfers.",
          resval: "1"
        }
      ]
    },
    { name:     "RESET_CONTROL",
      desc:     "Reset Control.",
      // Queue resets are instantaneous, so there's no need for hardware to change this register.
      swaccess: "wo",
      hwaccess: "hro",
      hwqe:     "true",
      hwext:    "true",
      fields: [
        { bits:   "5",
          name:   "IBI_QUEUE_RST",
          desc:   "IBI Queue Buffer Software Reset.",
          resval: "0"
        }
        { bits:   "4",
          name:   "RX_FIFO_RST",
          desc:   "Receive Queue Buffer Software Reset.",
          resval: "0"
        }
        { bits:   "3",
          name:   "TX_FIFO_RST",
          desc:   "Transmit Queue buffer Software Reset.",
          resval: "0"
        }
        { bits:   "2",
          name:   "RESP_QUEUE_RST",
          desc:   "Response Queue Software Reset.",
          resval: "0"
        }
        { bits:   "1",
          name:   "CMD_QUEUE_RST",
          desc:   "Command Queue Software Reset.",
          resval: "0"
        }
        { bits:   "0",
          name:   "SOFT_RST",
          desc:   "Core Software Reset.",
          resval: "0"
        }
      ]
    },
    { name:     "PRESENT_STATE",
      desc:     "Present State.",
      swaccess: "ro",
      hwaccess: "hwo",
      hwext:    "true",
      fields: [
        { bits:   "2",
          name:   "AC_CURRENT_OWN",
          desc:   "Active Controller.",
          resval: "0"
        }
      ]
    },
    { reserved: "2" },
    { name:     "INTR_STATUS",
      desc:     "Interrupt Status.",
      swaccess: "rw1c",
      hwaccess: "hrw",
      fields: [
        { bits:   "14",
          name:   "SCHED_CMD_MISSED_TICK_STAT",
          desc:   "Scheduled Command Missed Tick.",
          resval: "0"
        }
        { bits:   "13",
          name:   "HC_ERR_CMD_SEQ_TIMEOUT_STAT",
          desc:   "Host Controller Command Sequence Timeout.",
          resval: "0"
        }
        { bits:   "12",
          name:   "HC_WARN_CMD_SEQ_STALL_STAT",
          desc:   "Host Controller Command Sequence Stall.",
          resval: "0"
        }
        { bits:   "11",
          name:   "HC_SEQ_CANCEL_STAT",
          desc:   "Host Controller Cancelled Transaction Sequence.",
          resval: "0"
        }
        { bits:   "10",
          name:   "HC_INTERNAL_ERR_STAT",
          desc:   "Host Controller Internal Error.",
          resval: "0"
        }
      ]
    },
    { name:     "INTR_STATUS_ENABLE",
      desc:     "Interrupt Status Enable.",
      swaccess: "rw",
      hwaccess: "hro",
      fields: [
        { bits:   "14",
          name:   "SCHED_CMD_MISSED_TICK_STAT_EN",
          desc:   "Scheduled Command Missed Tick Status Enable.",
          resval: "0"
        }
        { bits:   "13",
          name:   "HC_ERR_CMD_SEQ_TIMEOUT_STAT_EN",
          desc:   "Host Controller Command Sequence Timeout Status Enable.",
          resval: "0"
        }
        { bits:   "12",
          name:   "HC_WARN_CMD_SEQ_STALL_STAT_EN",
          desc:   "Host Controller Command Sequence Stall Status Enable.",
          resval: "0"
        }
        { bits:   "11",
          name:   "HC_SEQ_CANCEL_STAT_EN",
          desc:   "Host Controller Cancelled Transaction Sequence Status Enable.",
          resval: "0"
        }
        { bits:   "10",
          name:   "HC_INTERNAL_ERR_STAT_EN",
          desc:   "Host Controller Internal Error Error Status Enable.",
          resval: "0"
        }
      ]
    },
    { name:     "INTR_SIGNAL_ENABLE",
      desc:     "Interrupt Signal Enable.",
      swaccess: "rw",
      hwaccess: "hro",
      fields: [
        { bits:   "14",
          name:   "SCHED_CMD_MISSED_TICK_SIGNAL_EN",
          desc:   "Scheduled Command Missed Tick Signal Enable.",
          resval: "0"
        }
        { bits:   "13",
          name:   "HC_ERR_CMD_SEQ_TIMEOUT_SIGNAL_EN",
          desc:   "Host Controller Command Sequence Timeout Signal Enable.",
          resval: "0"
        }
        { bits:   "12",
          name:   "HC_WARN_CMD_SEQ_STALL_SIGNAL_EN",
          desc:   "Host Controller Command Sequence Stall Signal Enable.",
          resval: "0"
        }
        { bits:   "11",
          name:   "HC_SEQ_CANCEL_SIGNAL_EN",
          desc:   "Host Controller Cancelled Transaction Sequence Signal Enable.",
          resval: "0"
        }
        { bits:   "10",
          name:   "HC_INTERNAL_ERR_SIGNAL_EN",
          desc:   "Host Controller Internal Error Signal Enable.",
          resval: "0"
        }
      ]
    },
    { name:     "INTR_FORCE",
      desc:     "Interrupt Force.",
      swaccess: "wo",
      hwaccess: "hro",
      hwext:    "true",
      hwqe:     "true",
      fields: [
        { bits:   "14",
          name:   "SCHED_CMD_MISSED_TICK_FORCE",
          desc:   "Force Scheduled Command Missed Tick.",
          resval: "0"
        }
        { bits:   "13",
          name:   "HC_ERR_CMD_SEQ_TIMEOUT_FORCE",
          desc:   "Force Host Controller Command Sequence Timeout.",
          resval: "0"
        }
        { bits:   "12",
          name:   "HC_WARN_CMD_SEQ_STALL_FORCE",
          desc:   "Force Host Controller Command Sequence Stall.",
          resval: "0"
        }
        { bits:   "11",
          name:   "HC_SEQ_CANCEL_FORCE",
          desc:   "Force Host Controller Cancelled Transaction Sequence.",
          resval: "0"
        }
        { bits:   "10",
          name:   "HC_INTERNAL_ERR_FORCE",
          desc:   "Force Host Controller Internal Error.",
          resval: "0"
        }
      ]
    },
    { name:     "DAT_SECTION_OFFSET",
      desc:     "Device Address Table Section Offset."
      swaccess: "ro",
      hwaccess: "hwo",
      hwext:    "true",
      fields: [
        { bits:   "31:28",
          name:   "ENTRY_SIZE",
          desc:   "DAT Entry size.",
          resval: "0"
        },
        { bits:   "18:12",
          name:   "TABLE_SIZE",
          desc:   "DAT Table Size.",
          resval: "32"
        }
        { bits:   "11:0",
          name:   "TABLE_OFFSET",
          desc:   "DAT Table Offset."
        }
      ]
    },
    { name:     "DCT_SECTION_OFFSET",
      desc:     "Device Characteristics Table Section Offset."
      swaccess: "ro",
      hwaccess: "hwo",
      hwext:    "true",
      fields: [
        { bits:     "31:28",
          name:     "ENTRY_SIZE",
          desc:     "DCT Entry size.",
          resval:   "0"
        },
        { bits:     "23:19",
          name:     "TABLE_INDEX",
          desc:     "DCT Table Index.",
          swaccess: "rw",
          hwaccess: "hrw",
          hwqe:     "true",
          resval:   "0"
        },
        { bits:     "18:12",
          name:     "TABLE_SIZE",
          desc:     "DCT Table Size.",
          resval:   "32"
        }
        { bits:     "11:0",
          name:     "TABLE_OFFSET",
          desc:     "DCT Table Offset."
        }
      ]
    },
    { name:     "RING_HEADERS_SECTION_OFFSET",
      desc:     "Ring Headers Section Offset.",
      swaccess: "ro",
      hwaccess: "hwo",
      hwext:    "true",
      fields: [
        { bits:   "15:0",
          name:   "SECTION_OFFSET",
          desc:   "Ring Headers Section Offset.",
          resval: "0"
        }
      ]
    }
    { name:     "PIO_SECTION_OFFSET",
      desc:     "PIO Section Offset.",
      swaccess: "ro",
      hwaccess: "hwo",
      hwext:    "true",
      fields: [
        { bits:   "15:0",
          name:   "SECTION_OFFSET",
          desc:   "PIO Section Offset.",
          resval: "0x100"
        }
      ]
    }
    { name:     "EXT_CAPS_SECTION_OFFSET",
      desc:     "Extended Capabilities Section Offset.",
      swaccess: "ro",
      hwaccess: "hwo",
      hwext:    "true",
      fields: [
        { bits:   "15:0",
          name:   "SECTION_OFFSET",
          desc:   "Extended Capabilities Section Offset.",
          resval: "0"
        }
      ]
    }
    { reserved: "2" },
    { name:     "INT_CTRL_CMDS_EN",
      desc:     "Internal Control Command Subtype Support.",
      swaccess: "ro",
      hwaccess: "hwo",
      hwext:    "true",
      fields: [
        { bits:     "15:1",
          name:     "MIPI_CMDS_SUPPORTED",
          desc:     "MIPI Alliance Commands Supported.",
          // TODO: Revisit.
          resval:   "0x18"
        }
        { bits:     "0",
          name:     "ICC_SUPPORT",
          desc:     "Internal Control Commands Supported.",
          resval:   "1"
        }
      ]
    }
    { reserved: "2" },
    { name:     "IBI_NOTIFY_CTRL",
      desc:     "IBI Notify Control.",
      swaccess: "rw",
      hwaccess: "hro",
      fields: [
        { bits:   "3",
          name:   "NOTIFY_IBI_REJECTED",
          desc:   "Notify Rejected In-Band Interrupt Request Control.",
          resval: "0"
        },
        { bits:   "1",
          name:   "NOTIFY_CRR_REJECTED",
          desc:   "Notify Rejected Controller Role Request Control.",
          resval: "0"
        },
        { bits:   "0",
          name:   "NOTIFY_HJ_REJECTED",
          desc:   "Notify Rejected Hot-Join Control.",
          resval: "0"
        }
      ]
    },
    { name:     "IBI_DATA_ABORT_CTRL",
      desc:     "IBI Data Abort Control.",
      hwaccess: "hro",
      fields: [
        { bits:     "31",
          name:     "IBI_DATA_ABORT_MON",
          desc:     "IBI Data Abort Monitor.",
          swaccess: "rw",
          resval:   "0"
        },
        { bits:     "20:18",
          name:     "MATCH_STATUS_TYPE",
          desc:     "Match IBI Status Type.",
          swaccess: "wo",
          resval:   "0"
        },
        { bits:     "17:16",
          name:     "AFTER_N_CHUNKS",
          desc:     "Abort After N Chunks.",
          swaccess: "wo",
          resval:   "0"
        },
        { bits:     "15:8",
          name:     "MATCH_IBI_ID",
          desc:     "Match IBI Target Address.",
          swaccess: "wo",
          resval:   "0"
        }
      ]
    },
    // The following three registers are described as read only in the HCI specification,
    // although they are also described as 'only present for Host Controllers that support direct
    // access to Host system memory.'
    { name:     "DEV_CTX_BASE_LO",
      desc:     "Device Context Base Address Low.",
      swaccess: "ro",
      hwaccess: "hwo",
      hwext:    "true",
      fields: [
        { bits:   "31:0",
          name:   "BASE_LO",
          desc:   "Device Context Base Low.",
          resval: "0"
        }
      ]
    },
    { name:     "DEV_CTX_BASE_HI",
      desc:     "Device Context Base Address High.",
      swaccess: "ro",
      hwaccess: "hwo",
      hwext:    "true",
      fields: [
        { bits:   "31:0",
          name:   "BASE_HI",
          desc:   "Device Context Base High.",
          resval: "0"
        }
      ]
    },
    { name:     "DEV_CTX_SG",
      desc:     "Device Contxt Scatter-Gather Support.",
      swaccess: "ro",
      hwaccess: "hwo",
      hwext:    "true",
      fields: [
        { bits:   "31",
          name:   "BLP",
          desc:   "Buffer Vs. List Pointer.",
          resval: "0"
        },
        { bits:   "15:0",
          name:   "LIST_SIZE",
          desc:   "List size.",
          resval: "0"
        }
      ]
    },
    { skipto:   "0x180" },
    // Must be aligned to a multiple of 0x10 to implement 4 ports; alignment is important because
    // decoding just extracts address bits.
    { window: {
        name:       "HCI_PORTS",
        desc:       '''HCI ports, occupying successive word addresses:

                    - COMMAND_QUEUE_PORT - Write-only Command Descriptor queue.
                    - RESPONSE_QUEUE_PORT - Read-only Response Descriptor queue.
                    - XFER_DATA_PORT - Read/write data buffer; Rx Data Buffer and Tx Data Buffer.
                    - IBI_PORT - Read-only In-Band Interrupt queue.
                    ''',
        items:      "4",
        validbits:  "32",
        byte-write: "false",
        unusual:    "false",
        swaccess:   "rw"
      }
    }
    { name:     "QUEUE_THLD_CTRL",
      desc:     "Queue Threshold Control.",
      swaccess: "rw",
      hwaccess: "hro",
      fields: [
        { bits:   "31:24",
          name:   "IBI_STATUS_THLD",
          desc:   "IBI Status Threshold.",
          resval: "1"
        }
        { bits:   "23:16",
          name:   "IBI_DATA_SEGMENT_SIZE",
          desc:   "IBI Data Segment Size.",
          resval: "1"
        }
        { bits:   "15:8",
          name:   "RESP_BUF_THLD",
          desc:   "Response Ready Buffer Threshold.",
          resval: "1"
        }
        { bits:   "7:0",
          name:   "CMD_EMPTY_BUF_THLD",
          desc:   "Command Ready Buffer Threshold.",
          resval: "1"
        }
      ]
    }
    { name:     "DATA_BUFFER_THLD_CTRL",
      desc:     "Transfer Data Buffer Threshold Control.",
      swaccess: "rw",
      hwaccess: "hro",
      fields: [
        { bits:   "26:24",
          name:   "RX_START_THLD",
          desc:   '''Receive Start Threshold in DWORDs.
                  Wait until there are at least 2^(N+1) DWORD entries available before starting a Read Transfer.
                  '''
          resval: "1"
        },
        { bits:   "18:16",
          name:   "TX_START_THLD",
          desc:   '''Transmit (Transfer) Start Threshold in DWORDs.
                  Wait until there are at least 2^(N+1) DWORDs of data available before starting a Write Transfer.
                  '''
          resval: "1"
        },
        { bits:   "10:8",
          name:   "RX_BUF_THLD",
          desc:   '''Receive Buffer Threshold.
                  Interrupt triggers when there are at least 2^(N+1) Rx Buffer DWORDs of data available.
                  ''',
          resval: "1"
        }
        { bits:   "2:0",
          name:   "TX_BUF_THLD",
          desc:   '''Transmit Buffer Threshold.
                  Interrupt triggers when there are at least 2^(N+1) Tx Buffer DWORD entries available.
                  ''',
          resval: "1"
        }
      ]
    }
    { name:     "QUEUE_SIZE",
      desc:     "Queue Size.",
      swaccess: "ro",
      hwaccess: "hwo",
      hwext:   "true",
      fields: [
        { bits:   "31:24",
          name:   "TX_DATA_BUFFER_SIZE",
          desc:   "Transmit Data Buffer Size.",
          resval: "6"
        }
        { bits:   "23:16",
          name:   "RX_DATA_BUFFER_SIZE",
          desc:   "Receive Data Buffer Size.",
          resval: "6"
        }
        { bits:   "15:8",
          name:   "IBI_STATUS_SIZE",
          desc:   "IBI Queue Size.",
          resval: "8"
        }
        { bits:   "7:0",
          name:   "CR_QUEUE_SIZE",
          desc:   "Command/Response Queue Size.",
          resval: "8"
        }
      ]
    }
    { name:     "ALT_QUEUE_SIZE",
      desc:     "Alternate Queue Size.",
      swaccess: "ro",
      hwaccess: "hwo",
      hwext:    "true",
      fields: [
        { bits:   "28",
          name:   "EXT_IBI_QUEUE_EN",
          desc:   "Extended IBI Queue Size."
          resval: "1"
        }
        { bits:   "24",
          name:   "ALT_RESP_QUEUE_EN",
          desc:   "Alternate Response Queue."
          resval: "0"
        }
        { bits:   "7:0",
          name:   "ALT_RESP_QUEUE_SIZE",
          desc:   "Alternate Response Queue Size."
          resval: "0"
        }
      ]
    }
    { name:     "PIO_INTR_STATUS",
      desc:     "PIO Interrupt Status.",
      swaccess: "rw1c",
      hwaccess: "hrw",
      fields: [
        { bits:     "9",
          name:     "TRANSFER_ERR_STAT",
          desc:     "Transfer Error Status.",
          swaccess: "rw1c",
          resval:   "0"
        }
        { bits:     "5",
          name:     "TRANSFER_ABORT_STAT",
          desc:     "Transfer Abort Status.",
          swaccess: "rw1c",
          resval:   "0"
        }
        { bits:     "4",
          name:     "RESP_READY_STAT",
          desc:     "Response Ready Status.",
          resval:   "0"
        }
        { bits:     "3",
          name:     "CMD_QUEUE_READY_STAT",
          desc:     "Command Queue Ready Status.",
          resval:   "0"
        }
        { bits:     "2",
          name:     "IBI_STATUS_THLD_STAT",
          desc:     "IBI Status Threshold Status.",
          resval:   "0"
        }
        { bits:     "1",
          name:     "RX_THLD_STAT",
          desc:     "Rx Data Buffer Threshold Status.",
          resval:   "0"
        }
        { bits:     "0",
          name:     "TX_THLD_STAT",
          desc:     "Tx Data Buffer Threshold Status.",
          resval:   "0"
        }
      ]
    }
    { name:     "PIO_INTR_STATUS_ENABLE",
      desc:     "PIO Interrupt Status Enable.",
      swaccess: "rw",
      hwaccess: "hro",
      fields: [
        { bits:   "9",
          name:   "TRANSFER_ERR_STAT_EN",
          desc:   "Transfer Error Status Enable.",
          resval: "0"
        }
        { bits:   "5",
          name:   "TRANSFER_ABORT_STAT_EN",
          desc:   "Transfer Abort Status Enable.",
          resval: "0"
        }
        { bits:   "4",
          name:   "RESP_READY_STAT_EN",
          desc:   "Response Ready Status Enable.",
          resval: "0"
        }
        { bits:   "3",
          name:   "CMD_QUEUE_READY_STAT_EN",
          desc:   "Command Queue Ready Status Enable.",
          resval: "0"
        }
        { bits:   "2",
          name:   "IBI_STATUS_THLD_STAT_EN",
          desc:   "IBI Status Threshold Status Enable.",
          resval: "0"
        }
        { bits:   "1",
          name:   "RX_THLD_STAT_EN",
          desc:   "Rx Data Buffer Threshold Status Enable.",
          resval: "0"
        }
        { bits:   "0",
          name:   "TX_THLD_STAT_EN",
          desc:   "Tx Data Buffer Threshold Status Enable.",
          resval: "0"
        }
      ]
    }
    { name:     "PIO_INTR_SIGNAL_ENABLE",
      desc:     "PIO Interrupt Signal Enable.",
      swaccess: "rw",
      hwaccess: "hro",
      fields: [
        { bits:   "9",
          name:   "TRANSFER_ERR_SIGNAL_EN",
          desc:   "Transfer Error Signal Enable.",
          resval: "0"
        }
        { bits:   "5",
          name:   "TRANSFER_ABORT_SIGNAL_EN",
          desc:   "Transfer Abort Signal Enable.",
          resval: "0"
        }
        { bits:   "4",
          name:   "RESP_READY_SIGNAL_EN",
          desc:   "Response Ready Signal Enable.",
          resval: "0"
        }
        { bits:   "3",
          name:   "CMD_QUEUE_READY_SIGNAL_EN",
          desc:   "Command Queue Ready Signal Enable.",
          resval: "0"
        }
        { bits:   "2",
          name:   "IBI_STATUS_THLD_SIGNAL_EN",
          desc:   "IBI Status Threshold Signal Enable.",
          resval: "0"
        }
        { bits:   "1",
          name:   "RX_THLD_SIGNAL_EN",
          desc:   "Rx Data Buffer Threshold Signal Enable.",
          resval: "0"
        }
        { bits:   "0",
          name:   "TX_THLD_SIGNAL_EN",
          desc:   "Tx Data Buffer Threshold Signal Enable.",
          resval: "0"
        }
      ]
    }
    { name:     "PIO_INTR_FORCE",
      desc:     "PIO Interrupt Force.",
      swaccess: "wo",
      hwaccess: "hro",
      hwext:    "true",
      hwqe:     "true",
      fields: [
        { bits:   "9",
          name:   "TRANSFER_ERR_FORCE",
          desc:   "Force Transfer Error.",
          resval: "0"
        }
        { bits:   "5",
          name:   "TRANSFER_ABORT_FORCE",
          desc:   "Force Transfer Abort.",
          resval: "0"
        }
        { bits:   "4",
          name:   "RESP_READY_FORCE",
          desc:   "Force Response Ready.",
          resval: "0"
        }
        { bits:   "3",
          name:   "CMD_QUEUE_READY_FORCE",
          desc:   "Force Command Queue Ready.",
          resval: "0"
        }
        { bits:   "2",
          name:   "IBI_THLD_FORCE",
          desc:   "Force IBI Status Threshold.",
          resval: "0"
        }
        { bits:   "1",
          name:   "RX_THLD_FORCE",
          desc:   "Force Rx Data Buffer Threshold.",
          resval: "0"
        }
        { bits:   "0",
          name:   "TX_THLD_FORCE",
          desc:   "Force Tx Data Buffer Threshold.",
          resval: "0"
        }
      ]
    }
    { name:     "PIO_CONTROL",
      desc:     "PIO Control.",
      swaccess: "rw",
      hwaccess: "hro",
      fields: [
        { bits:   "2",
          name:   "ABORT",
          desc:   "PIO Abort Request.",
          resval: "0"
        }
        { bits:   "1",
          name:   "RS",
          desc:   "PIO Run/Stop Request.",
          resval: "0"
        }
        { bits:   "0",
          name:   "ENABLE",
          desc:   "PIO Queues Enable Request.",
          resval: "1"
        }
      ]
    }
    // Leave some space for additional registers before the Extended Capabilities start.
    { skipto: "0x220" },
    // ----- Hardware Identification 0x01 (Extended Capability). -----
    { name:     "ID_EXTCAP_HEADER",
      desc:     "Hardware Identification Extended Capability Header",
      swaccess: "ro",
      hwaccess: "hwo",
      hwext:    "true",
      fields: [
        { bits:   "23:8",
          name:   "CAP_LENGTH",
          desc:   "Capability Structure Length in DWORDs.",
          resval: "4"
        }
        { bits:   "7:0",
          name:   "CAP_ID",
          desc:   "Extended Capability ID",
          resval: "0x01"
        }
      ]
    }
    // These fields are Read Only to software in the HCI and are supplied by the IP block
    // using top-level design parameters.
    { name:     "COMP_MANUFACTURER",
      desc:     "Component Manufacturer.",
      swaccess: "ro",
      hwaccess: "hwo",
      hwext:    "true",
      fields: [
        { bits:   "31:0",
          name:   "MIPI_VENDOR_ID",
          desc:   "MIPI-assigned Manufacturer ID for the Host Controller.",
          resval: "0"
        }
      ]
    }
    { name:     "COMP_VERSION",
      desc:     "Component Version.",
      swaccess: "ro",
      hwaccess: "hwo",
      hwext:    "true",
      fields: [
        { bits:   "31:0",
          name:   "I3C_VER_ID",
          desc:   "Vendor-assigned component version for the Host Controller.",
          resval: "0"
        }
      ]
    }
    { name:     "COMP_TYPE",
      desc:     "Component Type.",
      swaccess: "ro",
      hwaccess: "hwo",
      hwext:    "true",
      fields: [
        { bits:   "31:0",
          name:   "I3C_PRODUCT_ID",
          desc:   "Vendor-assigned component type for the Host Controller.",
          resval: "0"
        }
      ]
    }
    // ----- Controller Configuration 0x02 (Extended Capability). -----
    { name:     "CTRL_CFG_EXTCAP_HEADER",
      desc:     "Hardware Identification Extended Capability Header",
      swaccess: "ro",
      hwaccess: "hwo",
      hwext:    "true",
      fields: [
        { bits:   "23:8",
          name:   "CAP_LENGTH",
          desc:   "Capability Structure Length in DWORDs.",
          resval: "2"
        }
        { bits:   "7:0",
          name:   "CAP_ID",
          desc:   "Extended Capability ID",
          resval: "0x02"
        }
      ]
    }
    { name:     "CONTROLLER_CONFIG",
      desc:     "Controller Config.",
      swaccess: "ro",
      hwaccess: "hwo",
      hwext:    "true",
      fields: [
        { bits:   "5:4",
          name:   "OPERATION_MODE",
          desc:   '''Controller Operation Mode.
                  0x1 : Controller Role functionality only.
                  0x2 : Target Role functionality only.
                  0x3 : Both Controller Role and Target Role functionality.
                  '''
          resval: "3"
        }
      ]
    }
    // ----- Dead Bus Recovery 0x0b (Extended Capability). -----
    { name:     "DBR_EXTCAP_HEADER",
      desc:     "Dead Bus Recovery Extended Capability Header",
      swaccess: "ro",
      hwaccess: "hwo",
      hwext:    "true",
      fields: [
        { bits:   "23:8",
          name:   "CAP_LENGTH",
          desc:   "Capability Structure Length in DWORDs.",
          resval: "2"
        }
        { bits:   "7:0",
          name:   "CAP_ID",
          desc:   "Extended Capability ID",
          resval: "0x0b"
        }
      ]
    }
    { name:     "DBR_ENGAGE",
      desc:     "Dead Bus Recovery Engage.",
      swaccess: "wo",
      hwaccess: "hro",
      hwext:    "true",
      hwqe:     "true",
      fields: [
        { bits:   "22:16",
          name:   "DBR_IBI_ADDRESS",
          desc:   "IBI Address.",
          resval: "0x0"
        }
        { bits:   "9:8",
          name:   "DBR_ASX_TIMING",
          desc:   "Activity State Timing.",
          resval: "0x0"
        }
        { bits:   "6:4",
          name:   "DBR_MODE",
          desc:   "Engagement Mode.",
          resval: "0x0"
        }
        { bits:   "3:0",
          name:   "DBG_VERIF_KEY",
          desc:   "Verification Key.",
          resval: "0x0"
        }
      ]
    }
    // ----- Debug Specific 0x0c (Extended Capability). -----
    { name:     "DEBUG_EXTCAP_HEADER",
      desc:     "Debug Specific Extended Capability Header",
      swaccess: "ro",
      hwaccess: "hwo",
      hwext:    "true",
      fields: [
        { bits:   "23:8",
          name:   "CAP_LENGTH",
          desc:   "Capability Structure Length in DWORDs.",
          resval: "6"
        }
        { bits:   "7:0",
          name:   "CAP_ID",
          desc:   "Extended Capability ID",
          resval: "0x0c"
        }
      ]
    }
    { name:     "QUEUE_STATUS_LEVEL",
      desc:     "Queue Status Level",
      swaccess: "ro",
      hwaccess: "hwo",
      hwext:    "true",
      fields: [
        { bits:   "28:24",
          name:   "IBI_STATUS_CNT",
          desc:   "IBI Buffer Status Count.",
          resval: "0"
        }
        { bits:   "23:16",
          name:   "IBI_BUFFER_LVL",
          desc:   "IBI Buffer Level.",
          resval: "0"
        }
        { bits:   "15:8",
          name:   "RESPONSE_BUFFER_LVL",
          desc:   "Response Buffer Level.",
          resval: "0"
        }
        { bits:   "7:0",
          name:   "CMD_QUEUE_FREE_LVL",
          desc:   "Command Queue Free Buffer Level.",
          // TODO: This is the Command Queue size.
          resval: "0x10"
        }
      ]
    }
    { name:     "DATA_BUFFER_STATUS_LEVEL",
      desc:     "Data Buffer Status Level",
      swaccess: "ro",
      hwaccess: "hwo",
      hwext:    "true",
      fields: [
        { bits:   "15:8",
          name:   "RX_BUF_LVL",
          desc:   "Rx Data Buffer Status Count.",
          resval: "0"
        }
        { bits:   "7:0",
          name:   "TX_BUF_FREE_LVL",
          desc:   "Tx Data Buffer Status Count.",
          // TODO: This is the Tx Data Queue size.
          resval: "0x80"
        }
      ]
    }
    { name:     "PRESENT_STATE_DEBUG",
      desc:     "Present State Debug",
      swaccess: "ro",
      hwaccess: "hwo",
      hwext:    "true",
      fields: [
        { bits:   "27:24",
          name:   "CMD_TID",
          desc:   "Command Transaction ID.",
          resval: "0"
        }
        { bits:   "21:16",
          name:   "BCL_TFR_ST_STATUS",
          desc:   "Bus Controller Logic State.",
          resval: "0"
        }
        { bits:   "13:8",
          name:   "BCL_TFR_STATUS",
          desc:   "Bus Controller Logic Transfer Type Status.",
          resval: "0"
        }
        { bits:   "1",
          name:   "SDA_LINE_SIGNAL_LEVEL",
          desc:   "SDA Line Signal Level.",
          resval: "1"
        }
        { bits:   "0",
          name:   "SCL_LINE_SIGNAL_LEVEL",
          desc:   "SCL Line Signal Level.",
          resval: "1"
        }
      ]
    }
    { name:     "MX_ERROR_COUNTERS",
      desc:     "Controller Error Counters.",
      swaccess: "ro",
      hwaccess: "hwo",
      hwext:    "true",
      fields: [
        { bits:   "7:0",
          name:   "CE2_ERROR_COUNT",
          desc:   "CE2 Error Counter.",
          resval: "0"
        }
      ]
    }
    { name:     "SCHED_CMDS_DEBUG",
      desc:     "Scheduled Commands Debug",
      swaccess: "ro",
      hwaccess: "hwo",
      hwext:    "true",
      fields: [
        { bits:   "21",
          name:   "ERR_OCCURRED",
          desc:   "Error Occurred.",
          resval: "0",
        }
        { bits:   "20:16",
          name:   "TICK_INTERVAL",
          desc:   "Tick Interval Number.",
          resval: "0",
        }
        { bits:   "15:8",
          name:   "ENTITY_ID",
          desc:   "Entity ID.",
          resval: "0",
        }
        { bits:   "7",
          name:   "ERR_TYPE",
          desc:   "Error Type.",
          resval: "0",
        }
        { bits:   "6:4",
          name:   "INST_ID",
          desc:   "Instance ID.",
          resval: "0",
        }
        { bits:   "3:0",
          name:   "SCHED_HANDLER",
          desc:   "Scheduled Command Handler Type.",
          resval: "0",
        }
      ]
    }
    // ----- Standby Controller 0x12 (Extended Capability). -----
    { name:     "STBY_CR_EXTCAP_HEADER",
      desc:     "Standby Controller Extended Capability Header",
      swaccess: "ro",
      hwaccess: "hwo",
      hwext:    "true",
      fields: [
        { bits:   "23:8",
          name:   "CAP_LENGTH",
          desc:   "Capability Structure Length in DWORDs.",
          resval: "0xe"
        }
        { bits:   "7:0",
          name:   "CAP_ID",
          desc:   "Extended Capability ID",
          resval: "0x12"
        }
      ]
    }
    { name:     "STBY_CR_CONTROL",
      desc:     "Standby Controller Control",
      swaccess: "rw",
      hwaccess: "hrw",
      hwext:    "true",
      hwqe:     "true",
      fields: [
        { bits:   "31:30",
          name:   "STBY_CR_ENABLE_INIT",
          desc:   "Host Controller Secondary Controller Enable.",
          resval: "0"
        }
        { bits:   "20",
          name:   "RSTACT_DEFBYTE_02",
          desc:   "RSTACT Support DefByte 0x02",
          resval: "0"
        }
        // TODO: The following 4 fields are billed as R/cW.
        { bits:   "15",
          name:   "DAA_ENTDAA_ENABLE",
          desc:   "Dynamic Address Method Enable.",
          resval: "0"
        }
        { bits:   "14",
          name:   "DAA_SETDASA_ENABLE",
          desc:   "Dynamic Address Method Enable.",
          resval: "0"
        }
        { bits:   "13",
          name:   "DAA_SETAASA_ENABLE",
          desc:   "Dynamic Address Method Enable.",
          resval: "0"
        }
        { bits:   "12",
          name:   "TARGET_XACT_ENABLE",
          desc:   "Target Transaction Interface Servicing Enable.",
          resval: "1"
        }
        { bits:   "10:8",
          name:   "BCAST_CCC_IBI_RING",
          desc:   "Ring Bundle IBI Selector for Broadcast CCC Capture.",
          resval: "0"
        }
        { bits:   "5",
          name:   "CR_REQUEST_SEND",
          desc:   "Send Controller Role Request.",
          resval: "0"
        }
        { bits:   "4",
          name:   "HANDOFF_DEEP_SLEEP",
          desc:   "Handoff Deep Sleep.",
          resval: "0"
        }
        { bits:   "3",
          name:   "PRIME_ACCEPT_GETACCR",
          desc:   "Prime to Accept Controller Role.",
          resval: "1"
        }
        { bits:   "2",
          name:   "ACR_FSM_OP_SELECT",
          desc:   "Active Controller Select.",
          resval: "1"
        }
        { bits:   "1",
          name:   "HANDOFF_DELAY_NACK",
          desc:   "Handoff Delay NACK.",
          resval: "0"
        }
        { bits:   "0",
          name:   "PENDING_RX_NACK",
          desc:   "Pending RX NACK.",
          resval: "0"
        }
      ]
    }
    { name:     "STBY_CR_DEVICE_ADDR",
      desc:     "Standby Controller Device Address",
      hwext:    "true",
      hwqe:     "true",
      fields: [
        { bits:     "31",
          name:     "DYNAMIC_ADDR_VALID",
          desc:     "Dynamic Address is Valid.",
          swaccess: "ro",
          hwaccess: "hwo",
          resval:   "0"
        }
        { bits:     "22:16",
          name:     "DYNAMIC_ADDR",
          desc:     "Device Dynamic Address.",
          swaccess: "ro",
          hwaccess: "hwo",
          resval:   "0"
        }
        { bits:     "15",
          name:     "STATIC_ADDR_VALID",
          desc:     "Static Address is Valid.",
          swaccess: "rw",
          hwaccess: "hrw",
          resval:   "0"
        }
        { bits:     "6:0",
          name:     "STATIC_ADDR",
          desc:     "Device Static Address.",
          swaccess: "rw",
          hwaccess: "hrw",
          resval:   "0"
        }
      ]
    }
    { name:     "STBY_CR_CAPABILITIES",
      desc:     "Standby Controller Capabilities",
      swaccess: "ro",
      hwaccess: "hwo",
      hwext:    "true",
      fields: [
        { bits:   "15",
          name:   "DAA_ENTDAA_SUPPORT",
          desc:   "Dynamic Address Assignment with ENTDAA is supported.",
          resval: "1"
        }
        { bits:   "14",
          name:   "DAA_SETDASA_SUPPORT",
          desc:   "Dynamic Address Assignment with SETDASA is supported.",
          resval: "1"
        }
        { bits:   "13",
          name:   "DAA_SETAASA_SUPPORT",
          desc:   "Dynamic Address Assignment with SETAASA is supported.",
          resval: "1"
        }
        { bits:   "12",
          name:   "TARGET_XACT_SUPPORT",
          desc:   "I3C Target Transaction Interface is supported.",
          resval: "1"
        }
        { bits:   "5",
          name:   "SIMPLE_CRR_SUPPORT",
          desc:   "Simple Controller Role Request is supported.",
          resval: "1"
        }
      ]
    }
    { reserved: "1" },
    { name:     "STBY_CR_STATUS",
      desc:     "Standby Controller Status",
      swaccess: "rw",
      hwaccess: "hro",
      fields: [
        { bits:   "8",
          name:   "HJ_REQ_STATUS",
          desc:   "Hot-Join Request Status.",
          resval: "0"
        }
        { bits:   "7:5",
          name:   "SIMPLE_CRR_STATUS",
          desc:   "Simple Controller Role Request Status.",
          resval: "0"
        }
        { bits:   "1",
          name:   "AC_CURRENT_OWN",
          desc:   "Active Controller.",
          resval: "0"
        }
      ]
    }
    { name:     "STBY_CR_DEVICE_CHAR",
      desc:     "Standby Controller Device Characteristics",
      swaccess: "rw",
      hwaccess: "hrw",
      hwext:    "true",
      hwqe:     "true",
      fields: [
        { bits:     "31:29",
          name:     "BCR_FIXED",
          desc:     "Bus Characteristics Register Fixed.",
          swaccess: "ro",
          resval:   "3"
        }
        { bits:   "28:24",
          name:   "BCR_VAR",
          desc:   "Bus Characteristics Register Variable.",
          resval: "0"
        }
        { bits:   "23:16",
          name:   "DCR",
          desc:   "Device Characteristics Register.",
          resval: "0"
        }
        { bits:   "15:1",
          name:   "PID_HI",
          desc:   "Device Provisional ID High.",
          resval: "0"
        }
      ]
    }
    { name:     "STBY_CR_DEVICE_PID_LO",
      desc:     "Standby Controller PID Low",
      swaccess: "rw",
      hwaccess: "hrw",
      hwext:    "true",
      hwqe:     "true",
      fields: [
        { bits:   "31:0",
          name:   "PID_LO",
          desc:   "Device Provisional ID Low.",
          resval: "0"
        }
      ]
    }
    { name:     "STBY_CR_INTR_STATUS",
      desc:     "Standby Controller Interrupt Status",
      swaccess: "rw1c",
      hwaccess: "hrw",
      fields: [
        { bits:   "19",
          name:   "CCC_FATAL_RSTDAA_ERR_STAT",
          desc:   "CCC Fatal RSTDAA Error Status.",
          resval: "0"
        }
        { bits:   "18",
          name:   "CCC_UNHANDLED_NACK_STAT",
          desc:   "CCC Unhandled NACK Status.",
          resval: "0"
        }
        { bits:   "17",
          name:   "CCC_PARAM_MODIFIED_STAT",
          desc:   "CCC Parameter Modified Status.",
          resval: "0"
        }
        { bits:   "16",
          name:   "STBY_CR_OP_RSTACT_STAT",
          desc:   "Secondary Controller Operation Reset Action.",
          resval: "0"
        }
        { bits:   "14",
          name:   "STBY_CR_ACCEPT_ERR_STAT",
          desc:   "Secondary Controller Transition Error Status.",
          resval: "0"
        }
        { bits:   "13",
          name:   "STBY_CR_ACCEPT_OK_STAT",
          desc:   "Secondary Controller Transition OK Status.",
          resval: "0"
        }
        { bits:   "12",
          name:   "STBY_CR_ACCEPT_NACKED_STAT",
          desc:   "Secondary Controller Transition NACKed.",
          resval: "0"
        }
        { bits:   "11",
          name:   "STBY_CR_DYN_ADDR_STAT",
          desc:   "Secondary Controller Dynamic Address Status.",
          resval: "0"
        }
        { bits:   "10",
          name:   "CRR_RESPONSE_STAT",
          desc:   "Controller Role Request Response Status.",
          resval: "0"
        }
        { bits:   "3",
          name:   "ACR_HANDOFF_ERR_M3_STAT",
          desc:   "Controller Role Handoff Error Type CE3 Recovery.",
          resval: "0"
        }
        { bits:   "2",
          name:   "ACR_HANDOFF_ERR_FAIL_STAT",
          desc:   "Controller Role Handoff Error Due To Failure.",
          resval: "0"
        }
        { bits:   "1",
          name:   "ACR_HANDOFF_OK_PRIMED_STAT",
          desc:   "Controller Role Handoff OK and Primed to Accept.",
          resval: "0"
        }
        { bits:   "0",
          name:   "ACR_HANDOFF_OK_REMAIN_STAT",
          desc:   "Controller Role Handoff OK and Will Remain Secondary Controller.",
          resval: "0"
        }
      ]
    }
    { reserved: "1" },
    { name:     "STBY_CR_INTR_SIGNAL_ENABLE",
      desc:     "Standby Controller Interrupt Signal Enable",
      swaccess: "rw",
      hwaccess: "hro",
      fields: [
        { bits:   "19",
          name:   "CCC_FATAL_RSTDAA_ERR_SIGNAL_EN",
          desc:   "Standby Controller Interrupt Signal Enable.",
          resval: "1"
        }
        { bits:   "18",
          name:   "CCC_UNHANDLED_NACK_SIGNAL_EN",
          desc:   "Standby Controller Interrupt Signal Enable.",
          resval: "1"
        }
        { bits:   "17",
          name:   "CCC_PARAM_MODIFIED_SIGNAL_EN",
          desc:   "Standby Controller Interrupt Signal Enable.",
          resval: "0",
        }
        { bits:   "16",
          name:   "STBY_CR_OP_RSTACT_SIGNAL_EN",
          desc:   "Standby Controller Interrupt Signal Enable.",
          resval: "0"
        }
        { bits:   "14",
          name:   "STBY_CR_ACCEPT_ERR_SIGNAL_EN",
          desc:   "Standby Controller Interrupt Signal Enable.",
          resval: "0"
        }
        { bits:   "13",
          name:   "STBY_CR_ACCEPT_OK_SIGNAL_EN",
          desc:   "Standby Controller Interrupt Signal Enable.",
          resval: "0"
        }
        { bits:   "12",
          name:   "STBY_CR_ACCEPT_NACKED_SIGNAL_EN",
          desc:   "Standby Controller Interrupt Signal Enable.",
          resval: "0"
        }
        { bits:   "11",
          name:   "STBY_CR_DYN_ADDR_SIGNAL_EN",
          desc:   "Standby Controller Interrupt Signal Enable.",
          resval: "0"
        }
        { bits:   "10",
          name:   "CRR_RESPONSE_SIGNAL_EN",
          desc:   "Standby Controller Interrupt Signal Enable.",
          resval: "0"
        }
        { bits:   "3",
          name:   "ACR_HANDOFF_ERR_M3_SIGNAL_EN",
          desc:   "Standby Controller Interrupt Signal Enable.",
          resval: "0"
        }
        { bits:   "2",
          name:   "ACR_HANDOFF_ERR_FAIL_SIGNAL_EN",
          desc:   "Standby Controller Interrupt Signal Enable.",
          resval: "0"
        }
        { bits:   "1",
          name:   "ACR_HANDOFF_OK_PRIMED_SIGNAL_EN",
          desc:   "Standby Controller Interrupt Signal Enable.",
          resval: "0"
        }
        { bits:   "0",
          name:   "ACR_HANDOFF_OK_REMAIN_SIGNAL_EN",
          desc:   "Standby Controller Interrupt Signal Enable.",
          resval: "0"
        }
      ]
    }
    { name:     "STBY_CR_INTR_FORCE",
      desc:     "Standby Controller Interrupt Force",
      swaccess: "wo",
      hwaccess: "hro",
      hwext:    "true",
      hwqe:     "true",
      fields: [
        { bits:   "19",
          name:   "CCC_FATAL_RSTDAA_ERR_FORCE",
          desc:   "Standby Controller Interrupt Force.",
          resval: "0"
        }
        { bits:   "18",
          name:   "CCC_UNHANDLED_NACK_FORCE",
          desc:   "Standby Controller Interrupt Force.",
          resval: "0"
        }
        { bits:   "17",
          name:   "CCC_PARAM_MODIFIED_FORCE",
          desc:   "Standby Controller Interrupt Force.",
          resval: "0"
        }
        { bits:   "16",
          name:   "STBY_CR_OP_RSTACT_FORCE",
          desc:   "Standby Controller Interrupt Force.",
          resval: "0"
        }
        { bits:   "14",
          name:   "STBY_CR_ACCEPT_ERR_FORCE",
          desc:   "Standby Controller Interrupt Force.",
          resval: "0"
        }
        { bits:   "13",
          name:   "STBY_CR_ACCEPT_OK_FORCE",
          desc:   "Standby Controller Interrupt Force.",
          resval: "0"
        }
        { bits:   "12",
          name:   "STBY_CR_ACCEPT_NACKED_FORCE",
          desc:   "Standby Controller Interrupt Force.",
          resval: "0"
        }
        { bits:   "11",
          name:   "STBY_CR_DYN_ADDR_FORCE",
          desc:   "Standby Controller Interrupt Force.",
          resval: "0"
        }
        { bits:   "10",
          name:   "CRR_RESPONSE_FORCE",
          desc:   "Standby Controller Interrupt Force.",
          resval: "0"
        }
      ]
    }
    { name:     "STBY_CR_CCC_CONFIG_GETCAPS",
      desc:     "Standby Controller CCC Auto-Response Config Get Capabilities",
      swaccess: "rw",
      hwaccess: "hrw",
      hwext:    "true",
      hwqe:     "true",
      fields: [
        { bits:   "4",
          name:   "F2_CRCAP2_DEV_INTERACT",
          desc:   "GETCAPS CCC CRCAPS Byte 2.",
          resval: "0"
        }
        { bits:   "2:0",
          name:   "F2_CRCAP1_BUS_CONFIG",
          desc:   "GETCAPS CCC CRCAPS Byte 1.",
          resval: "0"
        }
      ]
    }
    { name:     "STBY_CR_CCC_CONFIG_RSTACT_PARAMS",
      desc:     "Standby Controller CCC Auto-Response Config Get Capabilities",
      swaccess: "rw",
      hwext:    "true",
      hwqe:     "true",
      fields: [
        { bits:     "31",
          name:     "RESET_DYNAMIC_ADDR",
          desc:     "Reset Dynamic Address After Target Reset.",
          hwaccess: "hrw",
          // TODO: nail down behaviour.
          resval:   "1"
        }
        { bits:     "23:16",
          name:     "RESET_TIME_TARGET",
          desc:     "Time to Reset Target.",
          hwaccess: "hrw",
          resval:   "0"
        }
        { bits:     "15:8",
          name:     "RESET_TIME_PERIPHERAL",
          desc:     "Time to Reset Peripheral.",
          hwaccess: "hrw",
          resval:   "0"
        }
        { bits:     "7:0",
          name:     "RST_ACTION",
          desc:     "Defining Byte of the RSTACT CCC.",
          swaccess: "ro",
          hwaccess: "hrw",
          resval:   "0"
        }
      ]
    }
    // ----- Target Transaction Interface 0xC8 (Extended Capability). -----
    { name:     "TTI_EXTCAP_HEADER",
      desc:     "Target Transaction Interface Extended Capability Header",
      swaccess: "ro",
      hwaccess: "hwo",
      hwext:    "true",
      fields: [
        { bits:   "23:8",
          name:   "CAP_LENGTH",
          desc:   "Capability Structure Length in DWORDs.",
          resval: "0x59"
        }
        { bits:   "7:0",
          name:   "CAP_ID",
          desc:   "Extended Capability ID",
          resval: "0xC8"
        }
      ]
    }
    { name:     "TARG_INTR_STATUS",
      desc:     "Target Interrupt Status.",
      swaccess: "rw1c",
      hwaccess: "hrw",
      fields: [
        { bits:     "31",
          name:     "TE_STAT",
          desc:     "Target Error Status.",
          resval:   "0"
        }
        { bits:     "19",
          name:     "TX3_DESC_READY_STAT",
          desc:     "Target 3 Tx Descriptor Queue Ready Status.",
          resval:   "0"
        }
        { bits:     "18",
          name:     "TX2_DESC_READY_STAT",
          desc:     "Target 2 Tx Descriptor Queue Ready Status.",
          resval:   "0"
        }
        { bits:     "17",
          name:     "TX1_DESC_READY_STAT",
          desc:     "Target 1 Tx Descriptor Queue Ready Status.",
          resval:   "0"
        }
        { bits:     "16",
          name:     "TX0_DESC_READY_STAT",
          desc:     "Target 0 Tx Descriptor Queue Ready Status.",
          resval:   "0"
        }
        { bits:     "11",
          name:     "TX3_THLD_STAT",
          desc:     "Target 3 Tx Data Buffer Threshold Status.",
          resval:   "0"
        }
        { bits:     "10",
          name:     "TX2_THLD_STAT",
          desc:     "Target 2 Tx Data Buffer Threshold Status.",
          resval:   "0"
        }
        { bits:     "9",
          name:     "TX1_THLD_STAT",
          desc:     "Target 1 Tx Data Buffer Threshold Status.",
          resval:   "0"
        }
        { bits:     "8",
          name:     "TX0_THLD_STAT",
          desc:     "Target 0 Tx Data Buffer Threshold Status.",
          resval:   "0"
        }
        { bits:     "7",
          name:     "ASYNC_EVT_OVL_STAT",
          desc:     "Asynchronous Event Queue Overflow Status.",
          swaccess: "rw1c",
          resval:   "0"
        }
        { bits:     "6",
          name:     "RX_BUFFER_OVL_STAT",
          desc:     "Rx Data Buffer Overflow Status.",
          swaccess: "rw1c",
          resval:   "0"
        }
        { bits:     "5",
          name:     "TRANSFER_ERR_STAT",
          desc:     "Transfer Error Status.",
          swaccess: "rw1c",
          resval:   "0"
        }
        { bits:     "4",
          name:     "TRANSFER_ABORT_STAT",
          desc:     "Transfer Abort Status.",
          swaccess: "rw1c",
          resval:   "0"
        }
        { bits:     "3",
          name:     "ASYNC_EVT_READY_STAT",
          desc:     "Asynchronous Event Queue Ready Status.",
          resval:   "0"
        }
        { bits:     "2",
          name:     "RX_DESC_READY_STAT",
          desc:     "Rx Descriptor Queue Ready Status.",
          resval:   "0"
        }
        { bits:     "1",
          name:     "IBI_STATUS_THLD_STAT",
          desc:     "IBI Status Threshold Status.",
          resval:   "0"
        }
        { bits:     "0",
          name:     "RX_THLD_STAT",
          desc:     "Rx Data Buffer Threshold Status.",
          resval:   "0"
        }
      ]
    }
    { name:     "TARG_INTR_STATUS_ENABLE",
      desc:     "Target Interrupt Status Enable.",
      swaccess: "rw",
      hwaccess: "hro",
      fields: [
        { bits:   "31",
          name:   "TE_STAT_EN",
          desc:   "Target Error Status Enable.",
          resval: "0"
        }
        { bits:   "19",
          name:   "TX3_DESC_READY_STAT_EN",
          desc:   "Target 3 Tx Descriptor Queue Ready Status Enable.",
          resval: "0"
        }
        { bits:   "18",
          name:   "TX2_DESC_READY_STAT_EN",
          desc:   "Target 2 Tx Descriptor Queue Ready Status Enable.",
          resval: "0"
        }
        { bits:   "17",
          name:   "TX1_DESC_READY_STAT_EN",
          desc:   "Target 1 Tx Descriptor Queue Ready Status Enable.",
          resval: "0"
        }
        { bits:   "16",
          name:   "TX0_DESC_READY_STAT_EN",
          desc:   "Target 0 Tx Descriptor Queue Ready Status Enable.",
          resval: "0"
        }
        { bits:   "11",
          name:   "TX3_THLD_STAT_EN",
          desc:   "Target 3 Tx Data Buffer Threshold Status Enable.",
          resval: "0"
        }
        { bits:   "10",
          name:   "TX2_THLD_STAT_EN",
          desc:   "Target 2 Tx Data Buffer Threshold Status Enable.",
          resval: "0"
        }
        { bits:   "9",
          name:   "TX1_THLD_STAT_EN",
          desc:   "Target 1 Tx Data Buffer Threshold Status Enable.",
          resval: "0"
        }
        { bits:   "8",
          name:   "TX0_THLD_STAT_EN",
          desc:   "Target 0 Tx Data Buffer Threshold Status Enable.",
          resval: "0"
        }
        { bits:   "7",
          name:   "ASYNC_EVT_OVL_STAT_EN",
          desc:   "Asynchronous Event Queue Overflow Status Enable.",
          resval: "0"
        }
        { bits:   "6",
          name:   "RX_BUFFER_OVL_STAT_EN",
          desc:   "Rx Data Buffer Overflow Status Enable.",
          resval: "0"
        }
        { bits:   "5",
          name:   "TRANSFER_ERR_STAT_EN",
          desc:   "Transfer Error Status Enable.",
          resval: "0"
        }
        { bits:   "4",
          name:   "TRANSFER_ABORT_STAT_EN",
          desc:   "Transfer Abort Status Enable.",
          resval: "0"
        }
        { bits:   "3",
          name:   "ASYNC_EVT_READY_STAT_EN",
          desc:   "Asynchronous Event Queue Ready Status Enable.",
          resval: "0"
        }
        { bits:   "2",
          name:   "RX_DESC_READY_STAT_EN",
          desc:   "Rx Descriptor Queue Ready Status Enable.",
          resval: "0"
        }
        { bits:   "1",
          name:   "IBI_STATUS_THLD_STAT_EN",
          desc:   "IBI Status Threshold Status Enable.",
          resval: "0"
        }
        { bits:   "0",
          name:   "RX_THLD_STAT_EN",
          desc:   "Rx Data Buffer Threshold Status Enable.",
          resval: "0"
        }
      ]
    }
    { name:     "TARG_INTR_SIGNAL_ENABLE",
      desc:     "Target Interrupt Signal Enable.",
      swaccess: "rw",
      hwaccess: "hro",
      fields: [
        { bits:   "31",
          name:   "TE_SIGNAL_EN",
          desc:   "Target Error Signal Enable.",
          resval: "0"
        }
        { bits:   "19",
          name:   "TX3_DESC_READY_SIGNAL_EN",
          desc:   "Target 3 Tx Descriptor Queue Ready Signal Enable.",
          resval: "0"
        }
        { bits:   "18",
          name:   "TX2_DESC_READY_SIGNAL_EN",
          desc:   "Target 2 Tx Descriptor Queue Ready Signal Enable.",
          resval: "0"
        }
        { bits:   "17",
          name:   "TX1_DESC_READY_SIGNAL_EN",
          desc:   "Target 1 Tx Descriptor Queue Ready Signal Enable.",
          resval: "0"
        }
        { bits:   "16",
          name:   "TX0_DESC_READY_SIGNAL_EN",
          desc:   "Target 0 Tx Descriptor Queue Ready Signal Enable.",
          resval: "0"
        }
        { bits:   "11",
          name:   "TX3_THLD_SIGNAL_EN",
          desc:   "Target 3 Tx Data Buffer Threshold Signal Enable.",
          resval: "0"
        }
        { bits:   "10",
          name:   "TX2_THLD_SIGNAL_EN",
          desc:   "Target 2 Tx Data Buffer Threshold Signal Enable.",
          resval: "0"
        }
        { bits:   "9",
          name:   "TX1_THLD_SIGNAL_EN",
          desc:   "Target 1 Tx Data Buffer Threshold Signal Enable.",
          resval: "0"
        }
        { bits:   "8",
          name:   "TX0_THLD_SIGNAL_EN",
          desc:   "Target 0 Tx Data Buffer Threshold Signal Enable.",
          resval: "0"
        }
        { bits:   "7",
          name:   "ASYNC_EVT_OVL_SIGNAL_EN",
          desc:   "Asynchronous Event Queue Overflow Signal Enable.",
          resval: "0"
        }
        { bits:   "6",
          name:   "RX_BUFFER_OVL_SIGNAL_EN",
          desc:   "Rx Data Buffer Overflow Signal Enable.",
          resval: "0"
        }
        { bits:   "5",
          name:   "TRANSFER_ERR_SIGNAL_EN",
          desc:   "Transfer Error Signal Enable.",
          resval: "0"
        }
        { bits:   "4",
          name:   "TRANSFER_ABORT_SIGNAL_EN",
          desc:   "Transfer Abort Signal Enable.",
          resval: "0"
        }
        { bits:   "3",
          name:   "ASYNC_EVT_READY_SIGNAL_EN",
          desc:   "Asynchronous Event Queue Ready Signal Enable.",
          resval: "0"
        }
        { bits:   "2",
          name:   "RX_DESC_READY_SIGNAL_EN",
          desc:   "Rx Descriptor Queue Ready Signal Enable.",
          resval: "0"
        }
        { bits:   "1",
          name:   "IBI_STATUS_THLD_SIGNAL_EN",
          desc:   "IBI Status Threshold Signal Enable.",
          resval: "0"
        }
        { bits:   "0",
          name:   "RX_THLD_SIGNAL_EN",
          desc:   "Rx Data Buffer Threshold Signal Enable.",
          resval: "0"
        }
      ]
    }
    { name:     "TARG_INTR_FORCE",
      desc:     "Target Interrupt Force.",
      swaccess: "wo",
      hwaccess: "hro",
      hwext:    "true",
      hwqe:     "true",
      fields: [
        { bits:   "31",
          name:   "TE_FORCE",
          desc:   "Force Target Error.",
          resval: "0"
        }
        { bits:   "19",
          name:   "TX3_DESC_READY_FORCE",
          desc:   "Target 3 Force Tx Descriptor Queue Ready.",
          resval: "0"
        }
        { bits:   "18",
          name:   "TX2_DESC_READY_FORCE",
          desc:   "Target 2 Force Tx Descriptor Queue Ready.",
          resval: "0"
        }
        { bits:   "17",
          name:   "TX1_DESC_READY_FORCE",
          desc:   "Target 1 Force Tx Descriptor Queue Ready.",
          resval: "0"
        }
        { bits:   "16",
          name:   "TX0_DESC_READY_FORCE",
          desc:   "Target 0 Force Tx Descriptor Queue Ready.",
          resval: "0"
        }
        { bits:   "11",
          name:   "TX3_THLD_FORCE",
          desc:   "Target 3 Force Tx Data Buffer Threshold.",
          resval: "0"
        }
        { bits:   "10",
          name:   "TX2_THLD_FORCE",
          desc:   "Target 2 Force Tx Data Buffer Threshold.",
          resval: "0"
        }
        { bits:   "9",
          name:   "TX1_THLD_FORCE",
          desc:   "Target 1 Force Tx Data Buffer Threshold.",
          resval: "0"
        }
        { bits:   "8",
          name:   "TX0_THLD_FORCE",
          desc:   "Target 0 Force Tx Data Buffer Threshold.",
          resval: "0"
        }
        { bits:   "7",
          name:   "ASYNC_EVT_OVL_FORCE",
          desc:   "Force Asynchronous Event Queue Overflow.",
          resval: "0"
        }
        { bits:   "6",
          name:   "RX_BUFFER_OVL_FORCE",
          desc:   "Force Rx Data Buffer Overflow.",
          resval: "0"
        }
        { bits:   "5",
          name:   "TRANSFER_ERR_FORCE",
          desc:   "Force Transfer Error.",
          resval: "0"
        }
        { bits:   "4",
          name:   "TRANSFER_ABORT_FORCE",
          desc:   "Force Transfer Abort.",
          resval: "0"
        }
        { bits:   "3",
          name:   "ASYNC_EVT_READY_FORCE",
          desc:   "Force Asynchronous Event Queue Ready.",
          resval: "0"
        }
        { bits:   "2",
          name:   "RX_DESC_READY_FORCE",
          desc:   "Force Rx Descriptor Queue Ready.",
          resval: "0"
        }
        { bits:   "1",
          name:   "IBI_THLD_FORCE",
          desc:   "Force IBI Status Threshold.",
          resval: "0"
        }
        { bits:   "0",
          name:   "RX_THLD_FORCE",
          desc:   "Force Rx Data Buffer Threshold.",
          resval: "0"
        }
      ]
    }
    { name:     "TARG_PIO_CONTROL",
      desc:     "Target PIO mode Control register.",
      hwaccess: "hrw",
      hwqe:     "true",
      fields: [
        { bits:     "31:28",
          name:     "ABORT",
          desc:     '''Allows software to abort transmission for each Virtual Target in turn.
                    Writing 1 to the corresponding bit will abort any in-progress transmission from that Virtual Target.
                    Transmission will enter the Suspended state, and no further transmission shall occur until the Suspended state is cleared.
                    ''',
          swaccess: "rw",
          resval:   "0"
        }
        { bits:     "27:24",
          name:     "SUSPENDED",
          desc:     '''Indicates, for each Virtual Target in turn, whether transmission has been suspended.
                    If an error occurs during transmission the Suspended bit will be set automatically by hardware.
                    Software use of the Abort mechanism described above also causes this bit to become set.
                    It remains asserted until the software writes a 1 to clear this bit.
                    ''',
          swaccess: "rw1c",
          resval:   "0"
        }
        { bits:     "15",
          name:     "IBI_ABORT",
          desc:     '''Allows software to abort transmission of In-Band Interrupts.
                    Writing 1 to the corresponding bit will abort any in-progress IBI transmission.
                    Transmission will enter the Suspended state, and no further transmission shall occur until the Suspended state is cleared.
                    ''',
          swaccess: "rw",
          resval:   "0"
        }
        { bits:     "14",
          name:     "IBI_SUSPENDED",
          desc:     '''Indicates whether transmission of In-Band Interrupts has been suspended.
                    If an error occurs during transmission the Suspended bit will be set automatically by hardware.
                    Software use of the IBI Abort mechanism described above also causes this bit to become set.
                    It remains asserted until the software writes a 1 to clear this bit.
                    ''',
          swaccess: "rw1c",
          resval:   "0"
        }
      ]
    }
    { name:     "TARG_ASYNC_EVT_CONTROL",
      desc:     "Target Asynchronous Event Queue Control.",
      hwaccess: "hro",
      hwqe:     "true",
      fields: [
        { bits:     "31",
          name:     "RESET",
          desc:     "Write 1 to reset the Asynchronous Event Queue.",
          swaccess: "rw1c",
          resval:   "0",
        }
        { bits:     "5",
          name:     "BUS_EVENTS",
          desc:     "Report I3C Bus Events.",
          swaccess: "rw",
          resval:   "0",
        }
        { bits:     "4",
          name:     "IBI_SUSPEND",
          desc:     "Report Suspension of In-Band Interrupts.",
          swaccess: "rw",
          resval:   "0",
        }
        { bits:     "3",
          name:     "TX_SUSPEND",
          desc:     "Report Suspension of Target transmissions.",
          swaccess: "rw",
          resval:   "0"
        }
        { bits:     "2",
          name:     "DIR_GET_CCC",
          desc:     "Capture Direct GET CCC traffic.",
          swaccess: "rw",
          resval:   "0"
        }
        { bits:     "1",
          name:     "DIR_SET_CCC",
          desc:     "Capture Direct SET CCC traffic.",
          swaccess: "rw",
          resval:   "0"
        }
        { bits:     "0",
          name:     "BCST_CCC",
          desc:     "Capture Broadcast CCC traffic.",
          swaccess: "rw",
          resval:   "0"
        }
      ]
    }
    { name:     "TARG_ERROR",
      desc:     "Target Error counts.",
      swaccess: "rw1c",
      hwaccess: "hrw",
      fields: [
        { bits:   "31:28",
          name:   "DBR",
          desc:   "Count of Dead Bus Recovery attempts.",
          resval: "0"
        }
        { bits:   "27:24",
          name:   "TE6",
          desc:   "Count of type 6 Target Errors.",
          resval: "0"
        }
        { bits:   "23:20",
          name:   "TE5",
          desc:   "Count of type 5 Target Errors.",
          resval: "0"
        }
        { bits:   "19:16",
          name:   "TE4",
          desc:   "Count of type 4 Target Errors.",
          resval: "0"
        }
        { bits:   "15:12",
          name:   "TE3",
          desc:   "Count of type 3 Target Errors.",
          resval: "0"
        }
        { bits:   "11:8",
          name:   "TE2",
          desc:   "Count of type 2 Target Errors.",
          resval: "0"
        }
        { bits:   "7:4",
          name:   "TE1",
          desc:   "Count of type 1 Target Errors.",
          resval: "0"
        }
        { bits:   "3:0",
          name:   "TE0",
          desc:   "Count of type 0 Target Errors.",
          resval: "0"
        }
      ]
    }
    { name:     "TARG_QUEUE_THLD_CTRL",
      desc:     "Target-side control register for setting queue interrupt thresholds.",
      swaccess: "rw",
      hwaccess: "hro",
      fields: [
        { bits:   "31:24",
          name:   "IBI_STATUS_THLD",
          desc:   "IBI Status Threshold.",
          resval: "1"
        }
        { bits:   "15:8",
          name:   "RX_DESC_THLD",
          desc:   '''Rx Descriptor Queue Threshold.
                  Interrupt is issued when the Rx Descriptor Queue contains at least N entries.
                  0: Do not raise an interrupt.
                  ''',
          resval: "1"
        }
      ]
    }
    { name:     "TARG_QUEUE_STATUS_LEVEL",
      desc:     "Target-side queue levels.",
      swaccess: "ro",
      hwaccess: "hwo",
      hwext:    "true",
      fields: [
        { bits:   "31:24",
          name:   "IBI_FREE_LVL",
          desc:   "The available space (in DWORDs) in the Target IBI queue."
        }
        { bits:   "23:16",
          name:   "ASYNC_EVT_LVL",
          desc:   "The number of Asynchronous Event descriptors in the queue."
        }
        { bits:   "15:8",
          name:   "RX_DESC_LVL",
          desc:   "The number of descriptors present in the Rx Descriptor queue."
        }
        { bits:   "7:0",
          name:   "RX_BUF_LVL",
          desc:   "The number of DWORDs of data present in the Rx Buffer."
        }
      ]
    }
    { name:     "TARG_BUF_THLD_CTRL",
      desc:     "Target-side control register for setting buffer interrupt thresholds.",
      swaccess: "rw",
      hwaccess: "hro",
      fields: [
        { bits:   "30:28",
          name:   "RX_START_THLD",
          desc:   '''Receive Start Threshold in DWORDs.
                  Wait until there are at least 2^(N+1) DWORD entries available before starting a Read Transfer.
                  '''
          resval: "1"
        }
        { bits:   "27:24",
          name:   "RX_BUF_THLD",
          desc:   '''Receive Buffer Threshold.
                  Interrupt triggers when there are at least N+1 Rx Buffer DWORDs of data available.
                  ''',
          resval: "1"
        }
        { bits:   "11:0",
          name:   "RX_SEGMENT_SIZE",
          desc:   '''Maximum length of received data segment, minus 1.
                  Received data is divided into DWORDs of no more than this length.
                  '''
          resval: "1"
        }
      ]
    }
    { multireg: {
        name:     "TARG_RW_LEN",
        desc:     "Target Read/Write Length.",
        count:    "MaxTargets",
        cname:    "TARGET",
        swaccess: "rw",
        hwaccess: "hrw",
        fields: [
          { bits:   "31:16",
            name:   "MWL",
            desc:   "Maximum Write transfer Length, in bytes.",
            resval: "0xffff"
          }
          { bits:   "15:0",
            name:   "MRL",
            desc:   "Maximum Read transfer Length, in bytes.",
            resval: "0xffff"
          }
        ]
      }
    }
    { multireg: {
        name:     "TARG_IBI_LEN",
        desc:     "Target IBI payload Length.",
        count:    "MaxTargets",
        cname:    "TARGET",
        hwaccess: "hrw",
        fields: [
          { bits:     "7:0",
            name:     "IBI_LEN",
            desc:     "Maximum length of IBI data payload, in bytes.",
            swaccess: "rw",
            resval:   "0xff"
          }
        ]
      }
    }
    { multireg: {
        name:     "TARG_EVENT_ENABLE",
        desc:     "Target Event enables.",
        count:    "MaxTargets",
        cname:    "TARGET",
        swaccess: "ro",
        hwaccess: "hrw",
        fields: [
          { bits:     "2",
            name:     "ENHJ",
            desc:     "If 1 then Hot-Join requests are enabled for this Target.",
            resval:   "1",
          }
          { bits:     "1",
            name:     "ENCR",
            desc:     "If 1 then Controller Role Requests are enabled for this Target.",
            resval:   "1",
          }
          { bits:     "0",
            name:     "ENINT",
            desc:     "If 1 then In-Band Interrupts are enabled for this Target.",
            resval:   "1",
          }
        ]
      }
    }
    { name:     "TARG_STATE_DEBUG",
      swaccess: "ro",
      hwaccess: "hwo",
      hwext:    "true",
      desc:     "Target State Debug",
      fields: [
        { bits:   "31:24",
          name:   "TRX_STATE",
          desc:   "Transceiver state.",
          resval: "0",
        }
        { bits:   "23:16",
          name:   "FSM_STATE",
          desc:   "Core FSM state.",
          resval: "0",
        }
        { bits:   "15:12",
          name:   "BUS_MODE",
          desc:   "Current bus mode.",
          resval: "0",
        }
        { bits:   "9",
          name:   "BUS_IDLE",
          desc:   "Reports whether the Bus Idle condition is met at this instant.",
          resval: "0"
        }
        { bits:   "8",
          name:   "BUS_AVAIL",
          desc:   "Reports whether the Bus Available condition is met at this instant.",
          resval: "0"
        }
        { bits:   "1",
          name:   "SDA_LINE_SIGNAL_LEVEL",
          desc:   "SDA Line Signal Level.",
          resval: "1"
        }
        { bits:   "0",
          name:   "SCL_LINE_SIGNAL_LEVEL",
          desc:   "SCL Line Signal Level.",
          resval: "1"
        }
      ]
    }
    { multireg: {
        name:     "TARG_ENABLE",
        count:    "MaxTargets",
        cname:    "TARGET",
        compact:  "true",
        desc:     "Enable signals for individual virtual targets.",
        swaccess: "rw",
        hwaccess: "hro",
        fields: [
          { bits:   "0",
            name:   "ENABLE",
            desc:   '''Enable virtual target.
                    A disabled target will not participate in address assignment or respond to bus traffic.
                    '''
            resval: "0"
          }
        ]
      }
    }
    { multireg: {
        name:     "TARG_GROUP",
        count:    "MaxGroups"
        cname:    "GROUP"
        desc:     "Group addressing configuration.",
        swaccess: "ro",
        hwaccess: "hrw",
        fields: [
          { bits:   "15:8",
            name:   "TARGETS",
            desc:   '''The set of virtual targets subscribed to this group address.
                    If zero, this entry in the list of group addresses is unused.
                    ''',
            resval: "0"
          }
          { bits:   "6:0",
            name:   "GROUP_ADDR",
            desc:   '''Group addresss, iff the entry is used.
                    If zero, and TARGETS is non-zero, all I3C traffic will be captured as if addressed to the selected Target(s).
                    '''
            resval: "0"
          }
        ]
      }
    }
    { multireg: {
        name:     "TARG_TX_THLD_CTRL",
        desc:     "Target control register for setting Tx thresholds.",
        count:    "MaxTargets",
        cname:    "TARGET",
        swaccess: "rw",
        hwaccess: "hro",
        fields: [
          { bits:   "18:16",
            name:   "TX_START_THLD",
            desc:   '''Transmit (Transfer) Start Threshold in DWORDs.
                    Wait until there are at least 2^(N+1) DWORDs of data available before starting a Write Transfer.
                    '''
            resval: "1"
          }
          { bits:   "15:8",
            name:   "TX_DESC_EMPTY_THLD",
            desc:   '''Tx Descriptor Queue Threshold.
                    Interrupt is issued when the Tx Descriptor Queue contains at least N empty entries.
                    0: Do not raise an interrupt.
                    ''',
            resval: "1"
          }
          { bits:   "7:0",
            name:   "TX_BUF_THLD",
            desc:   '''Transmit Buffer Threshold.
                    Interrupt triggers when there are at least N+1 Tx Buffer DWORD entries available.
                    ''',
            resval: "1"
          }
        ]
      }
    }
    { multireg: {
        name:     "TARG_TX_QUEUE_STATUS_LEVEL",
        desc:     "Target status register reporting transmit queue levels.",
        count:    "MaxTargets",
        cname:    "TARGET",
        swaccess: "ro",
        hwaccess: "hwo",
        hwext:    "true",
        fields: [
          { bits:   "15:8",
            name:   "TX_DESC_FREE_LVL",
            desc:   "The number of free Tx Descriptor Queue entries."
          }
          { bits:   "7:0",
            name:   "TX_BUF_FREE_LVL",
            desc:   "The number of free DWORDs in the Tx Buffer."
          }
        ]
      }
    }
    { multireg: {
        name:     "TARG_ADDR",
        desc:     "Target I3C addresses.",
        count:    "MaxTargets",
        cname:    "TARGET",
        swaccess: "rw",
        fields: [
          { bits:     "31",
            name:     "DYNAMIC_ADDR_VALID",
            desc:     "Dynamic Address is Valid.",
            hwaccess: "hrw",
            resval:   "0"
          }
          { bits:     "22:16",
            name:     "DYNAMIC_ADDR",
            desc:     "Device Dynamic Address.",
            hwaccess: "hrw",
            resval:   "0"
          }
          { bits:     "15",
            name:     "STATIC_ADDR_VALID",
            desc:     "Static Addres is Valid.",
            hwaccess: "hro",
            resval:   "0"
          }
          { bits:     "6:0",
            name:     "STATIC_ADDR",
            desc:     "Device Static Address.",
            hwaccess: "hro",
            resval:   "0"
          }
        ]
      }
    }
    { multireg: {
        name:     "TARG_CHAR",
        desc:     "Target Characteristics.",
        count:    "MaxTargets",
        cname:    "TARGET",
        swaccess: "rw",
        hwaccess: "hro",
        fields: [
          { bits:   "31:24",
            name:   "BCR",
            desc:   "Bus Characteristics Register.",
            resval: "0x3e"
          }
          { bits:   "23:16",
            name:   "DCR",
            desc:   "Device Characteristics Register.",
            resval: "0"
          }
          { bits:   "15:0",
            name:   "PID_HI",
            desc:   "High part of Provisioned ID.",
            resval: "0"
          }
        ]
      }
    }
    { multireg: {
        name:     "TARG_PID_LO",
        desc:     "Low parts of Target Provisioned IDs.",
        count:    "MaxTargets",
        cname:    "TARGET",
        swaccess: "rw",
        hwaccess: "hro",
        fields: [
          { bits:   "31:0",
            name:   "PID_LO",
            desc:   "Low part of Provisioned ID.",
            resval: "0"
          }
        ]
      }
    }
    { multireg: {
        name:     "TARG_CAPS",
        desc:     "Target Capabilities.",
        count:    "MaxTargets",
        cname:    "TARGET",
        swaccess: "rw",
        hwaccess: "hro",
        fields: [
          { bits:     "13",
            name:     "VTCAP1_SHARED_DET",
            desc:     "Shared Peripheral Detect.",
            resval:   "0"
          }
          { bits:     "12",
            name:     "VTCAP1_SIDE_FX",
            desc:     "Side Effects.",
            resval:   "0",
          }
          { bits:     "10:8",
            name:     "VTCAP1_TYPE",
            desc:     "Virtual Target Type.",
            resval:   "0"
          }
          { bits:     "4:0",
            name:     "VTCAP2",
            desc:     "The defined bits of the VTCAP2 byte.",
            resval:   "0"
          }
        ]
      }
    }
    { multireg: {
        name:     "TARG_INFO",
        desc:     "Target information.",
        count:    "MaxTargets",
        cname:    "TARGET",
        swaccess: "ro",
        fields: [
          { bits:     "11",
            name:     "ENDXFER_CAND_CRC_EARLY",
            desc:     "Candidate setting for 'CRC Word Indicator.'",
            hwaccess: "hrw",
            resval:   "1"
          }
          { bits:     "10",
            name:     "ENDXFER_CAND_WR_EARLY_TERM",
            desc:     "Candidate setting for 'Enable WRITE Early Termination Request.'",
            hwaccess: "hrw",
            resval:   "0"
          }
          { bits:     "8",
            name:     "ENDXFER_CAND_WR_NACK",
            desc:     "Candidate setting for 'Enable ACK/NACK Capability for WRITE Comamnd.'",
            hwaccess: "hrw",
            resval:   "0"
          }
          { bits:     "5",
            name:     "ENDXFER_CRC_EARLY",
            desc:     "CRC Word Indicator.",
            hwaccess: "hrw",
            resval:   "1"
          }
          { bits:     "4",
            name:     "ENDXFER_WR_EARLY_TERM",
            desc:     "Enable WRITE Early Termination Request.",
            hwaccess: "hrw",
            resval:   "0"
          }
          { bits:     "3",
            name:     "ENDXFER_WR_NACK",
            desc:     "Enable ACK/NACK Capability for WRITE Command.",
            hwaccess: "hrw",
            resval:   "0"
          }
          { bits:     "1:0",
            name:     "AS",
            desc:     "Activity State (ENTASn).",
            hwaccess: "hwo",
            resval:   "0"
          }
        ]
      }
    }
    { multireg: {
        name:     "TARG_MAX_RDWR",
        desc:     "Target Maximum Read/Write Rate and Turnaround.",
        count:    "MaxTargets",
        cname:    "MAX_RDWR",
        swaccess: "rw",
        hwaccess: "hro",
        fields: [
          { bits:   "31:28",
            name:   "RDTURN_SCALE",
            desc:   '''Maximum Read Turnaround Time Scale.

                    This value scales the Turnaround Time Value, giving the Maximum Read Turnaround Time in microseconds.
                    max time = RDTURN_VAL << (RDTURN_SCALE + 1)
                    ''',
            resval: "0"
          }
          { bits:   "27:16",
            name:   "RDTURN_VAL",
            desc:   "Maximum Read Turnaround Time Value.",
            resval: "1"
          }
          { bits:   "15:8",
            name:   "MAXWR",
            desc:   "Maximum Write Settings.",
            resval: "0"
          }
          { bits:   "6:0",
            name:   "MAXRD",
            desc:   "Maximum Read Settings",
            resval: "0"
          }
        ]
      }
    }
    // Leave some space for additional registers before the TTI ports window starts.
    { skipto: "0x3a0" },
    // Must be aligned to a multiple of 0x40 to implement 16 ports; alignment is important because
    // decoding just extracts address bits.
    { window: {
        name:       "TTI_PORTS",
        desc:       '''TTI ports, occupying successive word addresses:

                    - Rx Descriptor Queue.
                    - Rx Data Buffer.
                    - IBI Status Descriptor.
                    - IBI Data Buffer.
                    - Asynchronous Event Queue.
                    - Target 0-3 Tx Descriptor Queue.
                    - Target 0-3 Tx Data Buffer.
                    ''',
        items:      "13",
        validbits:  "32",
        byte-write: "false",
        unusual:    "true",  // Not 2^N words.
        swaccess:   "rw"
      }
    }
    // Terminator for the linked list of Extended Capabilities.
    { name:     "TERM_EXTCAP_HEADER",
      desc:     "Terminating Extended Capability Header",
      swaccess: "ro",
      hwaccess: "hwo",
      hwext:    "true",
      fields: [
        { bits:   "23:8",
          name:   "CAP_LENGTH",
          desc:   "Capability Structure Length in DWORDs.",
          resval: "0x01"
        }
        { bits:   "7:0",
          name:   "CAP_ID",
          desc:   "Extended Capability ID",
          resval: "0x00"
        }
      ]
    }
    { skipto: "0x500" },
    { window: {
        name:       "DAT",
        desc:       "Device Address Table.",
        items:      "NumDATWords",
        validbits:  "32",
        unusual:    "false",
        byte-write: "false",
        swaccess:   "rw"
      }
    }
    { window: {
        name:       "DCT",
        desc:       "Device Characteristics Table.",
        items:      "NumDCTWords",
        validbits:  "32",
        byte-write: "false",
        unusual:    "false",
        swaccess:   "rw"
      }
    }
    // This window onto the entire message buffer is optionally included based on 'SWDirectMsgBuf'.
    // - Up to 512 words of the message buffer may be accessed at a time, with any additional upper
    //   address bits being specified by the `BUFFER_CTRL.SW_ADDR_HI` register field.
    { window: {
        name:       "BUFFER",
        items:      "512",
        validbits:  "32",
        byte-write: "false",
        unusual:    "false"
        swaccess:   "rw",
        desc:       "Software-managed 2KiB message buffer used for transmitting and receiving messages."
      }
    }
  ]
}
