// Copyright lowRISC contributors.
// Licensed under the Apache License, Version 2.0, see LICENSE for details.
// SPDX-License-Identifier: Apache-2.0
{ name: "entropy_src",
  clock_primary: "clk_i",
  reset_primary: "rst_ni",
  other_clock_list: ["clk_es_50mhz_i"]      
  other_reset_list: ["rst_es_50mhz_ni"]      
  bus_device: "tlul",
  bus_host: "none",
  param_list: [
    { name: "QuarFifoDepth",
      desc: "Depth of the quarantine FIFOs",
      type: "int",
      default: "32",
      local: "true"
    },
  ],
  interrupt_list: [
    { name: "es_entropy_valid"
      desc: "Asserted when entropy source bits are available."}
    { name: "es_ana_src_ok"
      desc: "Asserted when the analog source is available."}
    { name: "es_ana_bits_err"
      desc: "Asserted when the analog source data bits have a polarity error."}
    { name: "es_ana_fifo_err"
      desc: "Asserted when the analog source fifo has a FIFO error."}
    { name: "es_fifo_err"
      desc: "Asserted when a FIFO error occurs."}
  ],

  inter_signal_list: [
    { struct:  "csrng_entropy", 
      type:    "req_rsp",
      name:    "csrng_entropy", 
      act:     "responder",
      package: "csrng_pkg",     
    }
  ],

  regwidth: "32",
  registers: [
    { name: "ES_REGEN",
      desc: "Register write enable for all control registers",
      swaccess: "rw1c",
      hwaccess: "hro",
      fields: [
        {
            bits:   "0",
            desc: ''' When true, the ES_CONF and ES_SEED registers can be modified.
            When false, they become read-only. Defaults true, write one to clear. Note that this needs to be
            cleared after initial configuration at boot in order to lock in the listed register settings.
            '''
            resval: 1 
        },
      ]
    },
    { name: "ES_REV",
      desc: "ENTROPY_SRC revision register",
      swaccess: "ro",
      hwaccess: "none",
      fields: [
        { bits: "23:16",
          name: "CHIP_TYPE",
          desc: "Read of this register shows the type of chip using this block.",
          resval: "0x1"
        }
        { bits: "15:8",
          name: "HW_REVISION",
          desc: "Read of this register shows the revision of this block.",
          resval: "0x1"
       }
        { bits: "7:0",
          name: "ABI_REVISION",
          desc: "Read of this register shows the ABI of this block.",
          resval: "0x1"
        }
      ]
    },
    { name: "ES_CONF",
      desc: "ENTROPY_SRC configuration register",
      swaccess: "rw",
      hwaccess: "hro",
      regwen:   "ES_REGEN",
      fields: [
        { bits: "1:0",
          name: "ENABLE",
          desc: '''Master enable for the ENTROPY_SRC entropy generation function.
                  This two bit field is the status of the application seed input FIFO.
                  0b00: Disabled
                  0b01: LFSR mode enabled
                  0b10: Analog mode enabled
                  0b11: Reserved
                '''                
        }
        { bits: "4",
          name: "ANA_SRC_EN",
          desc: '''Setting this bit enables the analog entropy source. This should be set first,
                wait for the status bit to set, then set the mode enable bits.
                '''
        }
        { bits: "5",
          name: "RCT_EN",
          desc: "Setting this bit enables the health test called Repeative Count Test."
        }
        { bits: "6",
          name: "APT_EN",
          desc: "Setting this bit enables the health test called Adaptive Proportion Test."
        }
      ]
    },
    { name: "ES_RCT_HEALTH",
      desc: "ENTROPY_SRC RCT health test register",
      swaccess: "rw",
      hwaccess: "hro",
      fields: [
        { bits: "15:0",
          name: "RCT_MAX",
          desc: "This is the cutoff value for failures of the RCT health test."
          resval: "0x06"
        }
      ]
    },
    { name: "ES_APT_HEALTH",
      desc: "ENTROPY_SRC APT health test register",
      swaccess: "rw",
      hwaccess: "hro",
      fields: [
        { bits: "15:0",
          name: "APT_MAX",
          desc: "This is the cutoff value for failures of the APT health test."
          resval: "0x06"
        }
        { bits: "31:16",
          name: "APT_WIN",
          desc: "This is the window value for testing of the APT health test."
          resval: "0x40"
        }
      ]
    },
    { name: "ES_ENTROPY",
      desc: "ENTROPY_SRC entropy source",
      swaccess: "ro",
      hwaccess: "hrw",
      hwext: "true",
      hwre: "true",
      fields: [
        { bits: "31:0",
          desc: "A read of this register provides entropy needed for an entropy source."
        }
      ]
    },
    { name:     "ES_STATUS",
      desc:     "ENTROPY_SRC status register",
      swaccess: "ro",
      hwaccess: "hwo",
      hwext: "true",
      fields: [
        { bits: "2:0",
          name: "FIFO0_DEPTH",
          desc: "This is the depth of the lfsr entropy source FIFO."
        }
        { bits: "6:4",
          name: "FIFO1_DEPTH",
          desc: "This is the depth of the analog entropy source FIFO."
        }
        { bits: "10:8",
          name: "FIFO2_DEPTH",
          desc: "This is the depth of the software entropy delivery FIFO."
        }
        { bits: "14:12",
          name: "FIFO3_DEPTH",
          desc: "This is the depth of the hardware entropy delivery FIFO."
        }
        { bits: "31",
          name: "DIAG",
          desc: "This bit is for internal debug only."
        }
      ]
    },
    { name:     "ES_FDEPTHST",
      desc:     "ENTROPY_SRC FIFO depth status register",
      swaccess: "ro",
      hwaccess: "hwo",
      hwext: "true",
      fields: [
        { bits: "2:0",
          name: "ENTROPY_FIFO_DEPTH",
          desc: "This register will reflect the current depth of the entropy FIFO."
        }
      ]
    },
    { name: "ES_THRESH",
      desc: "ENTROPY_SRC threshold register",
      swaccess: "rw",
      fields: [
        { bits: "2:0",
          name: "FIFO_THRESHOLD",
          desc: "The entropy FIFO depth will be compared against this register value when setting the es_entropy_valid interrupt signal."
       }
      ]
    }
    { name: "ES_RATE",
      desc: "ENTROPY_SRC entropy rate register",
      swaccess: "rw",
      fields: [
        { bits: "15:0",
          name: "ENTROPY_RATE",
          desc: '''This register determines the rate that entropy bits will be supplied. Its purpose to is simulate slow entropy sources.
                A value of 1 will deliver full rate entropy. A value of 2 will cut a full entropy source in half. A value of 8 will cut
                the rate by 1/8th. The precise equation for entropy delivery is one clock cycle of entropy is generated
                every 1/(ENTROPY_RATE) equal to one. A value of 0 disables all entropy generation.
                '''
          resval: "0x00000004"
      }
      ]
    }
    { name: "ES_SEED",
      desc: "ENTROPY_SRC seed register",
      swaccess: "rw",
      regwen:   "ES_REGEN",
      fields: [
        { bits: "7:0",
          name: "LFSR_SEED",
          desc: "Seed used to load into the LFSR for the initial state. This field will not update if the ES_REGEN bit 0 is cleared.",
          resval: "0xab"
       }
      ]
    }
  ]
}

