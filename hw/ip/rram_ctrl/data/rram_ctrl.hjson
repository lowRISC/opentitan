// Copyright lowRISC contributors (OpenTitan project).
// Licensed under the Apache License, Version 2.0, see LICENSE for details.
// SPDX-License-Identifier: Apache-2.0
{
  name:               "rram_ctrl",
  human_name:         "RRAM Controller",
  one_line_desc:      "Interfaces and manages integrated non-volatile RRAM memory; supports scrambling, integrity, secure wipe and emulated OTP access.",
  one_paragraph_desc: '''
                      RRAM Controller interfaces the integrated, non-volatile RRAM memory with software and other hardware components in the system, such as Life Cycle Controller, Key Manager, and OTP Controller.
                      It consists of the open-source RRAM controller that interfaces with a third party RRAM macro.
                      The RRAM controller handles direct memory mapped read requests, software controlled read and write requests, as well as life cycle RMA entry.
                      The controller supports a differentiation between info and data partitions, RRAM memory protection at page boundaries, and the handling of key manager secrets inaccessible to software.
                      The data partition of the RRAM is further divided into a data region and an OTP region.
                      The controller handles OTP read and write requests that are emulated with a read-set-write algorithm on the OTP region.
                      The RRAM phy is highly parameterized (number of pages, number of words and word size for each page, and number of read buffers) and supports XEX scrambling configurable by software, as well as ECC support configurable on a page boundary.
                      '''
  // Unique comportable IP identifier defined under KNOWN_CIP_IDS in the regtool.
  cip_id:             "45",
  design_spec:        "../doc",
  dv_doc:             "../doc/dv"
  hw_checklist:       "../doc/checklist",
  sw_checklist:       "/sw/device/lib/dif/dif_rram_ctrl",
  revisions: [
      {
          version:            "1.0.0",
          life_stage:         "L1",
          design_stage:       "D1",
          verification_stage: "V0",
      },
  ]
  clocking: [
    {clock: "clk_i", reset: "rst_ni", primary: true},
    {clock: "clk_otp_i", reset: "rst_otp_ni"}
  ]
  bus_interfaces: [
    { protocol: "tlul", direction: "device", name: "core" }
    { protocol: "tlul", direction: "device", name: "host" }
  ],
  interrupt_list: [
    // The first two status interrupts assert by default, since the FIFO is empty.
    // This is captured in the Hjson via the `default` key so that automatically generated tests can incorporate this information.
    { name: "wr_empty",   type: "status", desc: "Write FIFO empty",              default: "1"},
    { name: "wr_lvl",     type: "status", desc: "Write FIFO drained to level",   default: "1"},
    { name: "rd_full",    type: "status", desc: "Read FIFO full",                            },
    { name: "rd_lvl",     type: "status", desc: "Read FIFO filled to level",                 },
    { name: "op_done",    type: "event",  desc: "Operation complete",                        },
    { name: "corr1_err",  type: "event",  desc: "Correctable single-bit error encountered",  },
    { name: "corr2_err",  type: "event",  desc: "Correctable double-bit error encountered",  },
  ],

  alert_list: [
    { name: "recov_err",
      desc: '''
            RRAM recoverable errors.
            Fired whenever a software initiated controller operation completes with any bit set in !!ERR_CODE.
            ''',
    },
    { name: "fatal_std_err",
      desc: '''
            RRAM standard fatal errors.
            Fired whenever any bit in !!STD_FAULT_STATUS is set.
            '''
    },
    { name: "fatal_err",
      desc: '''
            RRAM fatal errors.
            Fired whenever any bit in !!FAULT_STATUS is set, including uncorrectable ECC errors.

            Note that this alert is not always fatal.
            The underlying error bits in the !!FAULT_STATUS register remain set until reset, meaning the alert keeps firing.
            This doesn't hold for !!FAULT_STATUS.PHY_RELBL_ERR.
            To allow firmware to deal with multi-bit ECC errors during firmware selection and verification, these error bits can be cleared.
            After passing this stage, it is recommended that firmware classifies the corresponding alert as fatal on the receiver end, i.e, inside the alert handler.
            '''
    },
    { name: "fatal_macro_err",
      desc: "Fatal errors triggered inside the RRAM macro, including fatal TL-UL bus integrity faults of the test interface."
    },
    { name: "recov_macro_err",
      desc: "Recoverable errors triggered inside the RRAM macro."
    }
  ],

  inter_signal_list: [
    { struct:  "rram_macro",
      type:    "req_rsp",
      name:    "rram_macro",
      act:     "req",
      package: "rram_ctrl_pkg"
    },
    { struct:  "nvm_otp_key",
      type:    "req_rsp",
      name:    "otp_key",
      act:     "req",
      package: "otp_ctrl_pkg"
    },
    { struct:  "otp_ctrl_macro"
      type:    "req_rsp"
      name:    "otp_macro"
      act:     "rsp"
      default: "'0"
      package: "otp_ctrl_macro_pkg"
      desc:    "Data interface for the OTP macro."
    }
    { struct:  "lc_tx"
      type:    "uni"
      name:    "lc_creator_seed_sw_rw_en"
      act:     "rcv"
      package: "lc_ctrl_pkg"
    },
    { struct:  "lc_tx"
      type:    "uni"
      name:    "lc_owner_seed_sw_rw_en"
      act:     "rcv"
      package: "lc_ctrl_pkg"
    },
    { struct:  "lc_tx"
      type:    "uni"
      name:    "lc_iso_part_sw_rd_en"
      act:     "rcv"
      package: "lc_ctrl_pkg"
    },
    { struct:  "lc_tx"
      type:    "uni"
      name:    "lc_iso_part_sw_wr_en"
      act:     "rcv"
      package: "lc_ctrl_pkg"
    },
    { struct:  "lc_tx"
      type:    "uni"
      name:    "lc_seed_hw_rd_en"
      act:     "rcv"
      package: "lc_ctrl_pkg"
    },
    { struct:  "lc_tx"
      type:    "uni"
      name:    "lc_escalate_en"
      act:     "rcv"
      package: "lc_ctrl_pkg"
    },
    { struct:  "lc_tx"
      type:    "uni"
      name:    "rma_req"
      act:     "rcv"
      package: "lc_ctrl_pkg"
    },
    { struct:  "lc_tx"
      type:    "uni"
      name:    "rma_ack"
      act:     "req"
      package: "lc_ctrl_pkg"
    },
    { struct:  "lc_nvm_rma_seed"
      type:    "uni"
      name:    "rma_seed"
      act:     "rcv"
      package: "lc_ctrl_pkg"
    },
    { struct:  "pwr_nvm",
      type:    "uni",
      name:    "pwrmgr",
      act:     "req",
      package: "pwrmgr_pkg"
    },
    { struct:  "keymgr_dpe_creator_seed",
      type:    "uni",
      name:    "keymgr_creator_seed",
      act:     "req",
      default: "'0",
      package: "keymgr_dpe_pkg",
      desc:    "Creator seed output to the key manager"
    },
    { struct:  "keymgr_dpe_owner_seed",
      type:    "uni",
      name:    "keymgr_owner_seed",
      act:     "req",
      default: "'0",
      package: "keymgr_dpe_pkg",
      desc:    "Owner seed output to the key manager"
    }
  ],

  countermeasures: [
    { name: "REG.BUS.INTEGRITY",
      desc: '''
            End-to-end bus integrity scheme.
            Standard integrity protection to the register file
            '''
    }
    { name: "HOST.BUS.INTEGRITY",
      desc: '''
            End-to-end bus integrity scheme.
            The integrity is added in rram_phy_rd and stored alongside the data in the read-buffer.
            From the read-buffer the integrity is passed through in u_tl_adapter_host to tl_host.
            The path from RRAM to the read-buffer is integrity protected through secondary read operation.
            '''
    }
    { name: "MEM.BUS.INTEGRITY",
      desc: '''
            End-to-end bus integrity scheme.
            Integrity is added in rram_phy_rd and stored alongside the data in the read-buffer; for reads, the TL-UL requester is expected to check this integrity.
            For writes, integrity is checked in rram_phy_wr; software should perform a readback to fully verify a write completed correctly.
            '''
    }
    { name: "MEM.ADDR_INFECTION",
      desc: '''
            The write data is XORed with its address in rram_phy_wr on every RRAM write operation.
            The XOR is then removed for every read operation.
            For host reads, the address is removed in u_tl_adapter_host.
            For all controller reads, the address is removed in u_rram_ctrl_rd.
            '''
    }
    { name: "SCRAMBLE.KEY.SIDELOAD",
      desc: "The scrambling key is sideloaded from OTP and thus unreadable by SW."
    }
    { name: "LC_CTRL.INTERSIG.MUBI",
      desc: '''
            Life cycle control signals are used to control information partition access
            and RRAM debug access. See the documentation on the secret information partition,
            isolated information partitions, and JTAG connection for more details.
            '''
    }
    { name: "CTRL.CONFIG.REGWEN",
      desc: "Configurations cannot be changed when an operation is ongoing."
    }
    { name: "DATA_REGIONS.CONFIG.REGWEN",
      desc: "Each data region has a configurable REGWEN."
    }
    { name: "INFO_PAGE.CONFIG.REGWEN",
      desc: "Each info page has a configurable REGWEN."
    }
    { name: "MEM.CTRL.GLOBAL_ESC",
      desc: "Global escalation causes memory to no longer be accessible."
    }
    { name: "MEM.CTRL.LOCAL_ESC",
      desc: '''
            A subset of fatal errors cause memory to no longer be accessible.
            All errors in !!STD_FAULT_STATUS and !!FAULT_STATUS are part of this subset.
            !!FAULT_STATUS.PHY_RELBL_ERR is only part of it once enabled via !!DIS.LOCAL_ESC_RELBL_ERR.
            '''
    }
    { name: "MEM_DISABLE.CONFIG.MUBI",
      desc: '''
            Software control for RRAM disable is multibit.
            The register is !!DIS.
            '''
    }
    { name: "EXEC.CONFIG.REDUN",
      desc: '''
            Software control for RRAM enable is 32-bit constant.
            The register is !!EXEC.
            '''
    }
    { name: "MEM.SCRAMBLE",
      desc: '''
            The RRAM supports XEX scrambling.
            The cipher used is PRINCE.
            The scrambling scheme is enabled by software, please see RRAM scrambling in documentation for more details.
            '''
    }
    { name: "RMA_ENTRY.MEM.SEC_WIPE",
      desc: "RMA entry wipes RRAM memory and overwrites it with random data."
    }
    { name: "CTRL.FSM.SPARSE",
      desc: '''
            The following controller FSMs are sparesly encoded:
            - rram_ctrl_lcmgr (RMA + seed FSM)
            - rram_ctrl_otp
            - rram_ctrl_arb
            - rram_ctrl_rd/wr
            '''
    }
    { name: "PHY_WR.FSM.SPARSE",
      desc: "The rram_phy_wr FSM is sparsely encoded."
    }
    { name: "CTR.REDUN",
      desc: '''
            The following counters are redundantly encoded:
            - rram_ctrl_otp
            - rram_ctrl_rd/wr
            - rram_phy_wr
            This includes seed count and address count used during seed reading phase, as well as word count, page count and wipe index in RMA entry phase.
            '''
    }
    { name: "PHY_ARBITER.CTRL.REDUN",
      desc: '''
            The phy arbiters for controller/host arbitration and in the shared scrambling module are redundant.
            The arbiters have two instances underneath that are constantly compared to each other.
            '''
    }
    { name: "PHY_HOST_GRANT.CTRL.CONSISTENCY",
      desc: '''
            The host grant is consistency checked.
            If the host is ever granted with info partition access, it is an error.
            If the host is ever granted while no request has been sent, it is an error.
            '''
    }
    { name: "PHY_RSP.CTRL.CONSISTENCY",
      desc: '''
            If the host or controller ever receive an unexpected transaction done signal, it is an error.
            '''
    }
    { name: "PHY_RD_RSP.CTRL.INTEGRITY",
      desc: '''
            The following control flow errors are detected and result in an error:
            - data_valid_o is set while there is no pending request (meta_fifo empty).
            - data_valid_o is set while a verify operation completes.
            - A request is sent to the RRAM while no internal request is generated.
            - The integrity of the response in the read-buffer does not match the integrity of the current request in the meta fifo.
            '''
    }
    { name: "PHY_RD_BUF.CTRL.INTEGRITY",
      desc: "If the verify operation does not return the same data as the original read, it is an error."
    }
    { name: "PHY_RD_BUF.CTRL.CONSISTENCY",
      desc: '''
            Operations on a read-buffer are only legal in specific read-buffer states.
            It is an error if an update is performed on a read-buffer that is not allocated, if a verify is performed on a read-buffer that is not valid, or if a read-buffer hit is served from a read-buffer that is neither valid nor verified.
            '''
    }
    { name: "FIFO.CTR.REDUN",
      desc: "The FIFO pointers of several FIFOs are implemented with duplicate counters."
    }
    { name: "TLUL_FIFO.MEM.REDUN",
      desc: "The FIFOs in the host TL-UL adapter are duplicated and their outputs compared."
    }
    { name: "HOST_TL_LC_GATE.FSM.SPARSE",
      desc: "The control FSM inside the TL-UL gating primitive is sparsely encoded."
    }
    { name: "WR_TL_LC_GATE.FSM.SPARSE",
      desc: "The control FSM inside the TL-UL gating primitive is sparsely encoded."
    }
    { name: "MEM.READBACK",
      desc: '''
            Every RRAM read is issued twice (a shadow read).
            If the two results differ, it indicates the data was manipulated during the read process (e.g. by a fault injection attack), and a fatal alert is raised.
            '''
    }
    { name: "MEM.INTEGRITY",
      desc: '''
            The RRAM macro computes ECC for every stored word.
            rram_ctrl controls whether ECC is enabled per region or info page (ecc_en), and captures the location and count of correctable errors in [`CORR1_ERR_LOC`](registers.md#corr1_err_loc)/[`CORR1_ERR_CNT`](registers.md#corr1_err_cnt) (single-bit) and [`CORR2_ERR_LOC`](registers.md#corr2_err_loc)/[`CORR2_ERR_CNT`](registers.md#corr2_err_cnt) (double-bit).
            '''
    }
    { name: "OTP.MEM.INTEGRITY",
      desc: '''
            Each OTP word is protected with an additional 8-bit Hamming(72,64) integrity syndrome, stored separately in the OTP integrity page, on top of the RRAM macro's own ECC.
            '''
    }
  ]

  param_list: [
    // The reg parameters can be modified directly through top_*.hjson.
    // The template will automatically propagate the appropriate values.

    // Random netlist constants
    { name:      "RndCnstAddrKey",
      desc:      "Compile-time random bits for default address key",
      type:      "rram_ctrl_pkg::rram_key_t"
      randcount: "128",
      randtype:  "data", // randomize randcount databits
    },
    { name:      "RndCnstDataKey",
      desc:      "Compile-time random bits for default data key",
      type:      "rram_ctrl_pkg::rram_key_t"
      randcount: "128",
      randtype:  "data", // randomize randcount databits
    },
    { name:      "RndCnstAllSeeds",
      desc:      "Compile-time random bits for default seeds",
      type:      "rram_ctrl_pkg::all_seeds_t"
      randcount: "512",
      randtype:  "data", // randomize randcount databits
    },
    { name:      "RndCnstLfsrSeed",
      desc:      "Compile-time random bits for initial LFSR seed",
      type:      "rram_ctrl_pkg::lfsr_seed_t"
      randcount: "64",
      randtype:  "data",
    },
    { name:      "RndCnstLfsrPerm",
      desc:      "Compile-time random permutation for LFSR output",
      type:      "rram_ctrl_pkg::lfsr_perm_t"
      randcount: "64",
      randtype:  "perm",
    },
    { name:      "ExecEn",
      desc:      "Constant value that enables RRAM execution",
      type:      "int unsigned"
      default:   "2724870391",
      local:     "true"
    },
    { name:      "SecScrambleEn",
      desc:      "Compile-time option to enable RRAM scrambling",
      type:      "bit",
      default:   "1",
      local:     "false",
      expose:    "true",
    },
    // Write FIFO depth
    { name:      "WrFifoDepth",
      desc:      "Depth of write fifo",
      type:      "int"
      default:   "16",
      local:     "false",
      expose:    "true"
    },
    // Read FIFO depth
    { name:      "RdFifoDepth",
      desc:      "Depth of read fifo",
      type:      "int"
      default:   "16",
      local:     "false",
      expose:    "true"
    },
    { name:      "NumRegions",
      desc:      "Number of configurable rram regions",
      type:      "int",
      default:   "10",
      local:     "true"
    },
    { name:      "NumInfoPages",
      desc:      "Number of info pages",
      type:      "int",
      default:   "8",
      local:     "true"
    },
    { name:      "NumEmulInfoRegions",
      desc:      "Number of emulated info page regions (windows) on the data partition",
      type:      "int",
      default:   "2",
      local:     "true"
    },
    { name:      "NumEmulInfoSubregions",
      desc:      "Total number of emulated info subregions across all emulated info regions",
      type:      "int",
      default:   "24",
      local:     "true"
    },
    { name:      "NumDataPages",
      desc:      "Number of data pages",
      type:      "int",
      default:   "4096",
      local:     "true"
    },
    { name:      "NumOtpPages",
      desc:      "Number of data pages reserved for OTP",
      type:      "int",
      default:   "6",
      local:     "true"
    },
    { name:      "WordsPerPage",
      desc:      "Number of words per page",
      type:      "int",
      default:   "32",
      local:     "true"
    },
    { name:      "BytesPerWord",
      desc:      "Number of bytes per word",
      type:      "int",
      default:   "16",
      local:     "true"
    },
    { name:      "BytesPerPage",
      desc:      "Number of bytes per page",
      type:      "int",
      default:   "512",
      local:     "true"
    },
  ],

  features: [
    {
     name: "RRAM_CTRL.ESCALATION"
     desc: '''The RRAM controller has two sources of escalation.
           1. Global escalation: This is initiated by the life cycle controller through lc_escalate_en.
           2. Local escalation: This is activated in response to standard faults detected within the RRAM.
                                 These faults are monitored through RRAM_CTRL.STD_FAULT_STATUS.
           '''
    }
    {
      name: "RRAM_CTRL.FETCH_CODE"
      desc: '''If SW programs RRAM_CTRL.EXEC to 0xA26A38F7, code fetch from RRAM device is allowed.
            All top-level tests make use of this feature. No dedicated test is required.
            '''
    }
    {
      name: "RRAM_CTRL.INFO.CREATOR_PARTITION"
      desc: '''This partition stores creator root seed.
            It is accessed by the RRAM controller after scramble key is received.
            SW can read or program the contents when both of the following conditions are satisfied:
              1. Life cycle state is one of DEV, PROD, PROD_END, or RMA.
              2. OTP SECRET2_DIGEST partition has not been written and locked.
            '''
    }
    {
      name: "RRAM_CTRL.INFO.ISOLATED_PARTITION"
      desc: '''This partition can hold extra manufacturing details (e.g., the wafer authentication secret).
            SW can read or program the contents when life cycle state is one of PROD, PROD_END, or RMA.
            SW can only program the contents when life cycle state is TEST_UNLOCKED* or DEV.
            '''
    }
    {
      name: "RRAM_CTRL.INFO.OWNER_PARTITION"
      desc: '''This partition stores owner root seed.
            It is accessed by the RRAM controller after scramble key is received.
            SW can read or program the contents when life cycle state is one of DEV, PROD, PROD_END, or RMA.
            '''
    }
    {
      name: "RRAM_CTRL.INIT.ROOT_SEEDS"
      desc: "After the scrambling keys are requested, the RRAM controller reads root seeds from secret partitions and provides them to the key manager."
    }
    {
      name: "RRAM_CTRL.INIT.SCRAMBLING_KEYS"
      desc: "When RRAM_CTRL.INIT is set, RRAM controller requests scrambling keys from otp controller."
    }
    {
      name: "RRAM_CTRL.MEM_PROTECTION"
      desc: '''For data partitions, SW can designate up to 10 regions.
            Each of these regions can contain more than one page, up to a maximum limit (which is 512 in earlgrey).
            For each region, SW can establish the access policy by programming RRAM_CTRL.MP_REGION_CFG.
            In the case of information partitions, the access policy can be configured on a per page basis.
            To achieve this, SW must configure RRAM_CTRL.INFO_PAGE_CFG*.
            '''
    }
    {
      name: "RRAM_CTRL.MEM_PROTECTION.EMULATED_INFO_PAGES"
      desc: '''RRAM has only 8 physical info pages, fewer than firmware needs.
            SW can define up to two windows on the data partition through RRAM_CTRL.EMUL_INFO_REGION, each enabled by its own mubi EN field and locked by its own RRAM_CTRL.EMUL_INFO_REGWEN.
            Each window can be split into up to 12 subregions using TOR-style (relative-offset) addressing, configured through RRAM_CTRL.EMUL_INFO_SUBREGION and locked individually by RRAM_CTRL.EMUL_INFO_SUBREGION_REGWEN.
            Each subregion has its own read, write, scramble, and ECC permissions, configured through RRAM_CTRL.EMUL_INFO_SUBREGION_CFG and locked separately by RRAM_CTRL.EMUL_INFO_SUBREGION_CFG_REGWEN.
            Host reads always deny the whole window, regardless of subregion configuration.
            Emulated info subregions take priority over the generic memory-protection regions, but never over the fixed OTP exclusion region.
            '''
    }
    {
      name: "RRAM_CTRL.OP.HOST_READ"
      desc: "Host can read any data partition by providing a valid physical address."
    }
    {
      name: "RRAM_CTRL.OP.PROTOCOL_CTRL"
      desc: '''As opposed to the host, the RRAM controller can read and write both data and info partitions.
            Simultaneous host and controller requests are arbitrated round-robin.
            Only one controller operation can be outstanding at a time.
            While a controller write is in progress, host reads are held off until it completes.
            While a controller read is outstanding, host reads can still be issued and are interleaved with it.
            Read responses are returned in the order the requests were issued.
            While an operation is in progress, other HW-initiated requests, i.e. RMA, are held until the operation is finished.
            '''
    }
    {
      name: "RRAM_CTRL.RMA"
      desc: '''Upon receiving an RMA request from the LC (Lifecycle Controller), the RRAM controller ensures the completion of all ongoing processes.
            Subsequently, it overwrites the following partitions with random data:
              - Creator partition
              - Owner partition
              - Isolated partition
              - Data partition
            This procedure is implemented to guarantee that any sensitive information previously stored in these partitions remains unrecoverable.
            From the start of the RMA request until the next reset, new software initiated controller operations are rejected with an error and host reads are answered with an error.
            '''
    }
  ],

  regwidth: "32",
  registers: {
    core: [
      { name: "DIS",
        desc: '''
              Disable RRAM functionality.
              Note: Each write access to this register affects all fields.
              To leave a field unchanged, write MuBi4False to it.
              Writing any other value to a field that is still MuBi4False sets it, e.g. writing 0 results in an invalid mubi value, which is treated as set.
              ''',
        swaccess: "rw1s",
        hwaccess: "hro",
        fields: [
          { bits: "3:0",
            name: "SW_DIS",
            mubi: true,
            desc: '''
                  Disables RRAM functionality completely.
                  This is a shortcut mechanism used by the software to completely kill RRAM in case of emergency.
                  Since this register is rw1s instead of rw, to disable, write the value MuBi4True to the register to disable the RRAM.
                  Once disabled, RRAM functionality cannot be re-enabled until the next reset.
                  '''
            resval: false,
          },
          { bits: "7:4",
            name: "LOCAL_ESC_RELBL_ERR",
            mubi: true,
            desc: '''
                  Enables local escalation for reliability errors.
                  Once this config bit is set to any value other than MuBi4False, !!FAULT_STATUS.PHY_RELBL_ERR will disable the RRAM until the next reset.
                  Otherwise !!FAULT_STATUS.PHY_RELBL_ERR is excluded from the local escalation, to deal with firmware selection during the boot process.
                  The fatal_err alert is raised regardless of this setting.
                  Since this register is rw1s instead of rw, this configuration cannot be reverted.
                  '''
            resval: false,
          },
          { bits: "11:8",
            name: "DIS_ALL_REWRITE",
            mubi: true,
            desc: '''
                  Disables all Rewrite operations (!!CONTROL.OP = Rewrite).
                  Once this field is set to any value other than MuBi4False, every Rewrite operation is rejected by the memory protection, regardless of the target partition and address.
                  A rejected Rewrite does not modify the RRAM and completes with !!ERR_CODE.MP_ERR set.
                  Rewrite bypasses the configurable memory protection regions, so trusted firmware should set this field before handing over control to less trusted firmware.
                  Since this register is rw1s instead of rw, this configuration cannot be reverted once set.
                  '''
            resval: false,
          },
          { bits: "15:12",
            name: "DIS_OTP_REWRITE",
            mubi: true,
            desc: '''
                  Disables Rewrite operations (!!CONTROL.OP = Rewrite) to the OTP region of the data partition, i.e. the last NumOtpPages pages including the OTP integrity page.
                  Once this field is set to any value other than MuBi4False, every Rewrite operation targeting the OTP region is rejected by the memory protection.
                  A rejected Rewrite does not modify the RRAM and completes with !!ERR_CODE.MP_ERR set.
                  Since this register is rw1s instead of rw, this configuration cannot be reverted once set.
                  '''
            resval: false,
          },
          { bits: "19:16",
            name: "DIS_INFO_REWRITE",
            mubi: true,
            desc: '''
                  Disables Rewrite operations (!!CONTROL.OP = Rewrite) to the info partition.
                  Once this field is set to any value other than MuBi4False, every Rewrite operation targeting the info partition is rejected by the memory protection.
                  Emulated info pages reside in the data partition and are therefore not covered by this field.
                  Only !!DIS.DIS_ALL_REWRITE rejects Rewrites to them.
                  A rejected Rewrite does not modify the RRAM and completes with !!ERR_CODE.MP_ERR set.
                  Since this register is rw1s instead of rw, this configuration cannot be reverted once set.
                  '''
            resval: false,
          },
        ]
        tags: [// Dont touch disable, it has several side effects on the system
               "excl:CsrAllTests:CsrExclWrite"],
      },

      { name: "EXEC",
        desc: "Controls whether instructions can be fetched through host_tl",
        swaccess: "rw",
        hwaccess: "hro",
        fields: [
          { bits: "31:0",
            name: "EN",
            desc: '''
                  A value of 0xa26a38f7 allows instruction fetches through host_tl.
                  Any other value blocks instruction fetches.
                  Data reads through host_tl are not affected.
                  '''
            resval: 0
          },
        ]
      },

      { name: "INIT",
        desc: "Controller init register",
        swaccess: "rw1s",
        hwaccess: "hro",
        fields: [
          { bits: "0",
            name: "VAL",
            desc: '''
                  Write a '1' to initialize the RRAM controller.
                  During the initialization process, the RRAM controller requests the address and data scramble keys and reads out the root seeds stored in RRAM before allowing other usage of the RRAM controller.
                  '''
            resval: "0"
            tags: [// Dont init RRAM, it has several side effects on the status bits
                   "excl:CsrAllTests:CsrExclAll"],
          },
        ]
      },

      { name: "CTRL_REGWEN",
        swaccess: "ro",
        hwaccess: "hwo",
        hwext: "true",
        desc: '''
              Controls the configurability of the !!CONTROL register.
              This register ensures the contents of !!CONTROL cannot be changed by software once a RRAM operation has begun.
              It unlocks whenever the existing RRAM operation completes, regardless of success or error.
              ''',
        fields: [
          { bits: "0",
            name: "EN",
            desc: '''
                  Configuration enable.

                  This bit defaults to 1 and is set to 0 by hardware when RRAM operation is initiated.
                  When the controller completes the RRAM operation, this bit is set back to 1 to allow software configuration of !!CONTROL.
                  ''',
            resval: "1",
          },
        ]
        tags: [// This regwen is completely under HW management and thus cannot be manipulated
               // by software.
               "excl:CsrNonInitTests:CsrExclCheck"]
      },


      { name: "CONTROL",
        desc: "Control register",
        regwen: "CTRL_REGWEN",
        swaccess: "rw",
        hwaccess: "hro",
        fields: [
          { bits: "0",
            hwaccess: "hrw",
            name: "START",
            desc: '''
                  Start RRAM transaction.
                  This bit shall only be set at the same time or after the other fields of the !!CONTROL register and !!ADDR have been programmed.
                  '''
            resval: "0"
            tags: [// Dont issue RRAM transactions - it causes several side-effects.
                   "excl:CsrAllTests:CsrExclWrite"],
          },
          { bits: "5:4",
            name: "OP",
            desc: "RRAM operation selection",
            resval: "0"
            enum: [
              { value: "0",
                name: "Read",
                desc: '''
                      RRAM Read.
                      Read desired number of RRAM words.
                      '''
              },
              { value: "1",
                name: "Write",
                desc: '''
                      RRAM write.
                      Write desired number of RRAM words.
                      '''
              },
              { value: "2",
                name: "Rewrite",
                desc: '''
                      This operation reads a specific location and writes it back to the RRAM with the intention to fix errors that occurred in the RRAM over time.
                      '''
              },
            ]
          },

          { bits: "8",
            name: "PARTITION",
            desc: '''
                  When doing a read or write operation, selects either info or data partition for operation.
                  When 0, select data partition - this is the portion of RRAM that is accessible both by the host and by the controller.
                  When 1, select info partition - this is the portion of RRAM that is only accessible by the controller.
                  '''
            resval: "0"
          },
          { bits: "25:16",
            name: "NUM",
            desc: '''
                  One less than the number of bus words the RRAM operation should read or write.
                  For write operations, the number of bus words must be a multiple of 4.
                  Otherwise the write is rejected without accessing the RRAM.
                  !!OP_STATUS.ERR and !!ERR_CODE.OP_ERR are set when the write completes.
                  For example, to read 10 words, software should program this field with the value 9.
                  To write 16 words, the software should program this field to 15.
                  '''
            resval: "0"
          },
        ]
      },
      { name: "ADDR",
        desc: "Address for RRAM operation",
        swaccess: "rw",
        hwaccess: "hro",
        regwen: "CTRL_REGWEN",
        resval: "0",
        fields: [
          { bits: "20:0",
            name: "START",
            desc: '''
                  Start address of a RRAM transaction.
                  This is a byte address relative to the RRAM only.
                  I.e., an address of 0 will access address 0 of the requested partition.

                  For read operations, the RRAM controller will truncate to the closest, lower word aligned address.
                  For example, if 0x13 is supplied, the controller will perform a read at address 0x10.

                  For write and Rewrite operations, the address must be aligned to an RRAM word (128b).
                  Otherwise the operation is rejected without accessing the RRAM.
                  !!OP_STATUS.ERR and !!ERR_CODE.OP_ERR are set when the operation completes.
                  '''
            resval: "0"
          },
        ]
      },

      // Data partition memory properties region setup
      { multireg: {
          cname: "RRAM_CTRL",
          name: "REGION_CFG_REGWEN"
          desc: "Memory region registers configuration enable.",
          count: "NumRegions",
          swaccess: "rw0c",
          hwaccess: "none",
          compact: false,
          fields: [
              { bits: "0",
                name: "REGION",
                resval: "1"
                desc: '''
                      Region register write enable.
                      !!REGION_CFG_REGWEN[i] locks !!MP_REGION_CFG[i] and !!MP_REGION[i].
                      Once set to 0, it can no longer be configured to 1.
                      ''',
                enum: [
                  { value: "0",
                    name: "Region locked",
                    desc: '''
                          Region can no longer be configured until next reset.
                          '''
                  },
                  { value: "1",
                    name: "Region enabled",
                    desc: '''
                          Region can be configured.
                          '''
                  },
                ]
              },
          ],
        },
      },

      { multireg: {
          cname: "RRAM_CTRL",
          name: "MP_REGION_CFG",
          desc: '''
                Memory property configuration for data partition.
                All fields are MuBi4 values.
                '''
          count: "NumRegions",
          swaccess: "rw",
          hwaccess: "hro",
          regwen: "REGION_CFG_REGWEN",
          regwen_multi: true,
          fields: [
              { bits: "3:0",
                name: "EN",
                mubi: true,
                desc: '''
                      Write MuBi4True to enable the region.
                      While the region is enabled, the permissions and attributes in the other fields of this register apply to accesses within it.
                      With any other value, the region is disabled and not matched against any incoming transaction.
                      ''',
                resval: false
              },
              { bits: "7:4",
                name: "RD_EN",
                mubi: true,
                desc: '''
                      Region can be read.
                      ''',
                resval: false
              },
              { bits: "11:8",
                name: "WR_EN",
                mubi: true,
                desc: '''
                      Region can be written.
                      ''',
                resval: false
              }
              { bits: "15:12",
                name: "SCRAMBLE_EN",
                mubi: true,
                desc: '''
                      Data in the region is scrambled.
                      See [RRAM Scrambling](theory_of_operation.md#rram-scrambling).
                      ''',
                resval: false
              }
              { bits: "19:16",
                name: "ECC_EN",
                mubi: true,
                desc: '''
                      Region is integrity checked and reliability ECC enabled.
                      ''',
                resval: false
              }
          ],
        },
      },

      { multireg: {
          cname: "RRAM_CTRL",
          name: "MP_REGION",
          desc: "Memory base and size configuration for data partition",
          count: "NumRegions",
          swaccess: "rw",
          hwaccess: "hro",
          regwen: "REGION_CFG_REGWEN",
          regwen_multi: true,
          fields: [
            { bits: "11:0",
              name: "BASE",
              desc: '''
                    Region base page. Note the granularity is page, not byte or word.
                    ''',
              resval: "0"
            },
            { bits: "23:12",
              name: "SIZE",
              desc: '''
                    Region size, encoded as (number of pages - 1).
                    For example, if base is 0 and size is 0, then the region is defined by page 0.
                    If base is 0 and size is 1, then the region is defined by pages 0 and 1.
                    ''',
              resval: "0"
            },
          ],
        },
      },

      // Default region properties for data partition
      { name: "DEFAULT_REGION",
        desc: '''
              Default region properties.
              All fields are MuBi4 values.
              ''',
        swaccess: "rw",
        hwaccess: "hro",
        fields: [
          { bits: "3:0",
            name: "RD_EN",
            mubi: true,
            desc: '''
                  Region can be read
                  ''',
            resval: false
          },
          { bits: "7:4",
            name: "WR_EN",
            mubi: true,
            desc: '''
                  Region can be written
                  ''',
            resval: false
          }
          { bits: "11:8",
            name: "SCRAMBLE_EN",
            mubi: true,
            desc: '''
                  Data in the region is scrambled.
                  See [RRAM Scrambling](theory_of_operation.md#rram-scrambling).
                  ''',
            resval: false
          }
          { bits: "15:12",
            name: "ECC_EN",
            mubi: true,
            desc: '''
                  Region is ECC enabled (both integrity and reliability ECC).
                  ''',
            resval: false
          }
        ]
      },

      // Info partition memory properties setup
      { multireg: {
          cname: "RRAM_CTRL",
          name: "INFO_REGWEN"
          desc: "Memory region registers configuration enable.",
          count: "NumInfoPages",
          swaccess: "rw0c",
          hwaccess: "none",
          compact: false,
          fields: [
              { bits: "0",
                name: "REGION",
                resval: "1"
                desc: '''
                      Info page configuration write enable.
                      !!INFO_REGWEN[i] locks !!INFO_PAGE_CFG[i].
                      Once set to 0, it can no longer be configured to 1.
                      '''
                enum: [
                  { value: "0",
                    name: "Page locked",
                    desc: '''
                          Region can no longer be configured until next reset.
                          '''
                  },
                  { value: "1",
                    name: "Page enabled",
                    desc: '''
                          Region can be configured.
                          '''
                  },
                ]
              },
          ],
        },
      },

      { multireg: {
          cname: "RRAM_CTRL",
          name: "INFO_PAGE_CFG",
          desc: '''
                Memory property configuration for info partition.
                Unlike data partition, each page is individually configured.
                All fields are MuBi4 values.
                '''
          count: "NumInfoPages",
          swaccess: "rw",
          hwaccess: "hro",
          regwen: "INFO_REGWEN",
          regwen_multi: true,
          fields: [
            { bits: "3:0",
              name: "EN",
              mubi: true,
              desc: '''
                    Write MuBi4True to enable the info page.
                    While the info page is enabled, the permissions and attributes in the other fields of this register apply to accesses to it.
                    With any other value, the info page is disabled and all accesses to it are denied.
                    ''',
              resval: false
            },
            { bits: "7:4",
              name: "RD_EN",
              mubi: true,
              desc: '''
                    Region can be read.
                    ''',
              resval: false
            },
            { bits: "11:8",
              name: "WR_EN",
              mubi: true,
              desc: '''
                    Region can be written.
                    ''',
              resval: false
            }
            { bits: "15:12",
              name: "SCRAMBLE_EN",
              mubi: true,
              desc: '''
                    Data in the info page is scrambled.
                    See [RRAM Scrambling](theory_of_operation.md#rram-scrambling).
                    ''',
              resval: false
            }
            { bits: "19:16",
              name: "ECC_EN",
              mubi: true,
              desc: '''
                    Region is ECC enabled (both integrity and reliability ECC).
                    ''',
              resval: false
            }
          ],
        },
      },

      { multireg: {
          cname: "RRAM_CTRL",
          name: "EMUL_INFO_REGWEN"
          desc: '''
                Emulated info region registers configuration enable.
                Subregions within a window are only considered once this is locked, see !!EMUL_INFO_SUBREGION.
                '''
          count: "NumEmulInfoRegions",
          swaccess: "rw0c",
          hwaccess: "hro",
          compact: false,
          fields: [
              { bits: "0",
                name: "REGION",
                resval: "1"
                desc: "Region register write enable. Once set to 0, it can no longer be configured to 1.",
                enum: [
                  { value: "0",
                    name: "Region locked",
                    desc: '''
                          Region can no longer be configured until next reset.
                          '''
                  },
                  { value: "1",
                    name: "Region enabled",
                    desc: '''
                          Region can be configured.
                          '''
                  },
                ]
              },
          ],
        },
      },

      { multireg: {
          cname: "RRAM_CTRL",
          name: "EMUL_INFO_REGION",
          desc: '''
                Base and size configuration for an emulated info page region (window).
                Unlike !!MP_REGION, this register carries no access permissions of its own.
                See !!EMUL_INFO_SUBREGION_CFG for per-subregion permissions.
                Once EN is set, host access to this window through host_tl is always blocked in hardware.
                Software can access it through the controller (core_tl and the FIFOs) if allowed by the subregion configuration.
                Once EN is set, any access to the window that is not covered by an enabled subregion is denied.
                Enabling this and locking it via !!EMUL_INFO_REGWEN is a precondition for using any subregions configured through !!EMUL_INFO_SUBREGION and !!EMUL_INFO_SUBREGION_CFG within this window.
                '''
          count: "NumEmulInfoRegions",
          swaccess: "rw",
          hwaccess: "hro",
          regwen: "EMUL_INFO_REGWEN",
          regwen_multi: true,
          fields: [
            { bits: "11:0",
              name: "BASE",
              desc: '''
                    Region base page. Note the granularity is page, not byte or word.
                    ''',
              resval: "0"
            },
            { bits: "23:12",
              name: "SIZE",
              desc: '''
                    Region size, encoded as (number of pages - 1).
                    ''',
              resval: "0"
            },
            { bits: "27:24",
              name: "EN",
              mubi: true,
              desc: '''
                    Window enabled.
                    If enabled, accesses to the window that are not covered by an enabled subregion are denied.
                    If two enabled windows overlap, the subregions of both windows are disabled and both windows are denied entirely.
                    If disabled, neither the window nor any of its subregions is matched against any incoming transaction.
                    ''',
              resval: false
            },
          ],
        },
      },

      { multireg: {
          cname: "RRAM_CTRL",
          name: "EMUL_INFO_SUBREGION_REGWEN"
          desc: '''
                Emulated info subregion size registers configuration enable.
                Independent from !!EMUL_INFO_SUBREGION_CFG_REGWEN.
                A subregion's placement and its permissions can be locked separately.
                A subregion is only considered once its placement is locked.
                '''
          count: "NumEmulInfoSubregions",
          swaccess: "rw0c",
          hwaccess: "hro",
          compact: false,
          fields: [
              { bits: "0",
                name: "REGION",
                resval: "1"
                desc: "Subregion write enable. Once set to 0, it can no longer be configured to 1.",
                enum: [
                  { value: "0",
                    name: "Subregion locked",
                    desc: '''
                          Subregion size can no longer be configured until next reset.
                          Locking this is one of the conditions for the subregion to become active.
                          See !!EMUL_INFO_SUBREGION for the full conditions.
                          '''
                  },
                  { value: "1",
                    name: "Subregion enabled",
                    desc: '''
                          Subregion size can be configured.
                          '''
                  },
                ]
              },
          ],
        },
      },

      { multireg: {
          cname: "RRAM_CTRL",
          name: "EMUL_INFO_SUBREGION",
          desc: '''
                Subregions are configured with TOR (top of range) addressing, but relative to the window's base.
                A subregion's range runs from the prior subregion's TOP plus one up to its own TOP.
                Configure subregions in increasing TOP order, locking each starting from the first subregion of its window.
                A subregion is enabled once all of the following hold.
                Its window is enabled via !!EMUL_INFO_REGION.EN and locked via !!EMUL_INFO_REGWEN.
                Its own placement and that of every lower-indexed subregion of its window are locked via !!EMUL_INFO_SUBREGION_REGWEN, i.e., the whole lock chain back to the first subregion of its window.
                Its TOP does not exceed its window's SIZE.
                Its window does not overlap any other enabled window.
                '''
          count: "NumEmulInfoSubregions",
          swaccess: "rw",
          hwaccess: "hro",
          regwen: "EMUL_INFO_SUBREGION_REGWEN",
          regwen_multi: true,
          fields: [
            { bits: "7:0",
              name: "TOP",
              desc: '''
                    Subregion's last page, as an offset in pages from its window's base page.
                    ''',
              resval: "0"
            },
          ],
        },
      },

      { multireg: {
          cname: "RRAM_CTRL",
          name: "EMUL_INFO_SUBREGION_CFG_REGWEN"
          desc: '''
                Emulated info subregion permission registers configuration enable.
                Independent from !!EMUL_INFO_SUBREGION_REGWEN.
                A subregion's permissions and its placement can be locked separately.
                '''
          count: "NumEmulInfoSubregions",
          swaccess: "rw0c",
          hwaccess: "none",
          compact: false,
          fields: [
              { bits: "0",
                name: "REGION",
                resval: "1"
                desc: "Subregion write enable. Once set to 0, it can no longer be configured to 1.",
                enum: [
                  { value: "0",
                    name: "Subregion locked",
                    desc: '''
                          Subregion permissions can no longer be configured until next reset.
                          '''
                  },
                  { value: "1",
                    name: "Subregion enabled",
                    desc: '''
                          Subregion permissions can be configured.
                          '''
                  },
                ]
              },
          ],
        },
      },

      { multireg: {
          cname: "RRAM_CTRL",
          name: "EMUL_INFO_SUBREGION_CFG",
          desc: '''
                Memory property configuration for an emulated info subregion.
                There is no separate EN field.
                Bits 3:0 are reserved, so RD_EN, WR_EN, SCRAMBLE_EN, and ECC_EN sit at the same bit positions as in !!MP_REGION_CFG and !!INFO_PAGE_CFG.
                See !!EMUL_INFO_SUBREGION for the full conditions under which a subregion is enabled.
                All fields are MuBi4 values.
                '''
          count: "NumEmulInfoSubregions",
          swaccess: "rw",
          hwaccess: "hro",
          regwen: "EMUL_INFO_SUBREGION_CFG_REGWEN",
          regwen_multi: true,
          fields: [
            { bits: "7:4",
              name: "RD_EN",
              mubi: true,
              desc: '''
                    Subregion can be read.
                    ''',
              resval: false
            },
            { bits: "11:8",
              name: "WR_EN",
              mubi: true,
              desc: '''
                    Subregion can be written.
                    ''',
              resval: false
            }
            { bits: "15:12",
              name: "SCRAMBLE_EN",
              mubi: true,
              desc: '''
                    Data in the subregion is scrambled.
                    See [RRAM Scrambling](theory_of_operation.md#rram-scrambling).
                    ''',
              resval: false
            }
            { bits: "19:16",
              name: "ECC_EN",
              mubi: true,
              desc: '''
                    Subregion is ECC enabled (both integrity and reliability ECC).
                    ''',
              resval: false
            }
          ],
        },
      },

      { name: "HW_INFO_CFG_OVERRIDE",
        desc: '''
              HW interface info configuration rule overrides.
              The hardwired rules apply to the info page accesses of the life cycle manager: the creator and owner seed reads during initialization and the RMA wipe of the creator, owner and isolated pages.
              All fields are MuBi4 values.
              ''',
        swaccess: "rw",
        hwaccess: "hro",
        fields: [
          { bits: "3:0",
            name: "SCRAMBLE_DIS",
            mubi: true,
            desc: '''
                  If this field is MuBi4True, scrambling is disabled for the lcmgr info page.
                  If this field is MuBi4False, scrambling is controlled by the hardwired hardware info configuration rules.
                  This allows software to disable scrambling if needed.

                  The behaviour is not specified when this field is not a valid MuBi4 value.

                  By default this field is MuBi4False.
                  ''',
            resval: false
          }
          { bits: "7:4",
            name: "ECC_DIS",
            mubi: true,
            desc: '''
                  If this field is MuBi4True, ECC calculation and checks are disabled for the lcmgr info page.
                  If this field is MuBi4False, the use of ECC is controlled by the hardwired hardware info configuration rules.
                  This allows software to disable ECC checks if needed.

                  The behaviour is not specified when this field is not a valid MuBi4 value.

                  By default this field is MuBi4False.
                  ''',
            resval: false
          }
        ]
      },

      { name: "OP_STATUS",
        desc: "RRAM Operation Status",
        swaccess: "rw",
        hwaccess: "hwo",
        fields: [
          { bits: "0", name: "done",
            desc: "RRAM operation done. Set by HW, cleared by SW" },
          { bits: "1", name: "err",
            desc: "RRAM operation error. Set by HW, cleared by SW. See !!ERR_CODE for more details."},
        ]
      },

      { name: "STATUS",
        desc: "RRAM Controller Status",
        swaccess: "ro",
        hwaccess: "hwo",
        fields: [
          { bits: "0",    name: "rd_full",    desc: "RRAM read FIFO full, software must consume data"},
          { bits: "1",    name: "rd_empty",   desc: "RRAM read FIFO empty", resval: "1"},
          { bits: "2",    name: "wr_full",    desc: "RRAM write FIFO full"},
          { bits: "3",    name: "wr_empty",   desc: "RRAM write FIFO empty, software must provide data", resval: "1"},
          { bits: "4",    name: "init_done",  desc: "RRAM controller is initilized"
            tags: [ // Bit changes immediately after start from reset value to 1b1 due to initialization
            "excl:CsrAllTests:CsrExclAll"]
          },
          { bits: "5",    name: "keys_valid", desc: "RRAM controller scrambling keys are loaded"
            tags: [ // Bit changes immediately after start from reset value to 1b1 due to initialization
            "excl:CsrAllTests:CsrExclAll"]
          },
        ]
      },

      { name: "ERR_CODE",
        desc: '''
              RRAM error code register.
              This register tabulates detailed error status of the RRAM.
              This is separate from !!OP_STATUS, which is used to indicate the current state of the software initiated RRAM operation.

              Note, all errors in this register are considered recoverable errors, i.e., errors that could have been generated by software.
              '''
        swaccess: "rw1c",
        hwaccess: "hwo",
        fields: [
          { bits: "0",
            name: "op_err",
            desc: '''
                  Software has supplied an undefined operation.
                  See !!CONTROL.OP for list of valid operations.
                  This error is also set if a software operation is started before the initialization has completed, see !!STATUS.INIT_DONE and !!STATUS.KEYS_VALID, or while software access is disabled from the start of the RMA entry process.
                  It is also set for a write or Rewrite whose start address in !!ADDR is not aligned to an RRAM word, and for a write whose number of bus words (!!CONTROL.NUM + 1) is not a multiple of 4.
                  '''
          },
          { bits: "1",
            name: "mp_err",
            desc: '''
                  RRAM access has encountered an access permission error.
                  Please see !!ERR_ADDR for exact address.
                  This and !!OP_STATUS.ERR are set when the software operation causing the error completes.
                  '''
          },
          { bits: "2",
            name: "rd_err",
            desc: '''
                  An RRAM read had an error.
                  This could be a reliability ECC error or integrity error encountered during a software issued controller read, see !!STD_FAULT_STATUS.
                  See !!ERR_ADDR for exact address.
                  This and !!OP_STATUS.ERR are set when the software operation causing the error completes.
                  '''
          },
          { bits: "3",
            name: "wr_err",
            desc: '''
                  An RRAM write had an error.
                  This could be a write integrity error, see !!STD_FAULT_STATUS.
                  This and !!OP_STATUS.ERR are set when the software operation causing the error completes.
                  '''
          },
        ]
      },

      { name: "STD_FAULT_STATUS",
        desc: '''
              This register tabulates standard fault status of the RRAM.

              These represent errors that occur in the standard structures of the design.
              For example fsm integrity, counter integrity and tlul integrity.
              '''
        swaccess: "ro",
        hwaccess: "hrw",
        fields: [
          { bits: "0",
            name: "reg_intg_err",
            desc: '''
                  The RRAM controller encountered a register integrity error.
                  '''
          },
          { bits: "1",
            name: "lcmgr_err",
            desc: '''
                  The life cycle management interface has encountered a fatal error.
                  The error is either an FSM sparse encoding error or a count error.
                  '''
          },
          { bits: "2",
            name: "lcmgr_intg_err",
            desc: '''
                  The life cycle management interface has encountered a transmission integrity error.
                  This is an integrity error on the generated integrity during a life cycle management interface read.
                  '''
          },
          { bits: "3",
            name: "otp_err",
            desc: '''
                  The otp interface has encountered a fatal error.
                  The error is either an FSM sparse encoding error or a count error.
                  '''
          },
          { bits: "4",
            name: "otp_intg_err",
            desc: '''
                  The otp interface has encountered a transmission integrity error.
                  This is an integrity error on the generated integrity during an OTP read.
                  '''
          },
          { bits: "5",
            name: "phy_wr_intg_err",
            desc: '''
                  The RRAM phy encountered a write data transmission integrity error.
                  '''
          },
          { bits: "6",
            name: "phy_fifo_err",
            desc: '''
                  A RRAM phy fifo has encountered a count error.
                  '''
          },
          { bits: "7",
            name: "phy_fsm_err",
            desc: '''
                  A RRAM phy fsm has encountered a sparse encoding error.
                  '''
          },
          { bits: "8",
            name: "phy_cnt_err",
            desc: '''
                  A RRAM phy wr/read has encountered a count error.
                  '''
          },
          { bits: "9",
            name: "phy_arb_err",
            desc: '''
                  A RRAM phy arbiter has encountered an error.
                  '''
          },
          { bits: "10",
            name: "ctrl_fsm_err",
            desc: '''
                  Any of the arbiter or rd/wr control FSMs have encountered a sparse encoding error.
                  '''
          },
          { bits: "11",
            name: "ctrl_cnt_err",
            desc: '''
                  RRAM controller read/write has encountered a count error.
                  '''
          },
          { bits: "12",
            name: "ctrl_fifo_err",
            desc: '''
                  RRAM controller write fifo has encountered an error.
                  '''
          },
        ]
      },

      { name: "FAULT_STATUS",
        desc: '''
              This register tabulates customized fault status of the RRAM.

              These are errors that are impossible to have been caused by software or unrecoverable in nature.

              All errors except for multi-bit ECC errors (!!FAULT_STATUS.PHY_RELBL_ERR).
              Once set, they remain set until reset.
              '''
        hwaccess: "hrw",
        fields: [
          { bits: "0",
            name: "lcmgr_op_err",
            swaccess: "ro",
            desc: '''
                  The RRAM life cycle management interface has supplied an undefined operation.
                  See !!CONTROL.OP for list of valid operations.
                  '''
          },
          { bits: "1",
            name: "lcmgr_mp_err",
            swaccess: "ro",
            desc: '''
                  The RRAM life cycle management interface encountered a memory permission error.
                  '''
          },
          { bits: "2",
            name: "lcmgr_rd_err",
            swaccess: "ro",
            desc: '''
                  The RRAM life cycle management interface encountered a read error.
                  This could be a reliability ECC error or an integrity ECC error encountered during a read, see !!STD_FAULT_STATUS for more details.
                  '''
          },
          { bits: "3",
            name: "lcmgr_wr_err",
            swaccess: "ro",
            desc: '''
                  The RRAM life cycle management interface encountered a write error.
                  This could be a write integrity error, see !!STD_FAULT_STATUS for more details.
                  '''
          },
          { bits: "4",
            name: "otp_op_err",
            swaccess: "ro",
            desc: '''
                  The RRAM OTP interface has supplied an undefined operation.
                  See !!CONTROL.OP for list of valid operations.
                  '''
          },
          { bits: "5",
            name: "otp_mp_err",
            swaccess: "ro",
            desc: '''
                  The RRAM OTP interface encountered a memory permission error.
                  '''
          },
          { bits: "6",
            name: "otp_rd_err",
            swaccess: "ro",
            desc: '''
                  The RRAM OTP interface encountered a read error.
                  This could be a reliability ECC error or an integrity ECC error encountered during a read, see !!STD_FAULT_STATUS for more details.
                  '''
          },
          { bits: "7",
            name: "otp_wr_err",
            swaccess: "ro",
            desc: '''
                  The RRAM OTP interface encountered a write error.
                  This could be a write integrity error, see !!STD_FAULT_STATUS for more details.
                  '''
          },
          { bits: "8",
            name: "seed_err",
            swaccess: "ro",
            desc: '''
                  The seed reading process encountered an unexpected error.
                  '''
          },
          { bits: "9",
            name: "phy_relbl_err",
            swaccess: "rw0c",
            desc: '''
                  The RRAM macro encountered a reliability ECC error that cannot be corrected.

                  Note that this error bit can be cleared to allow firmware to deal with multi-bit ECC errors during firmware selection and verification.
                  After passing this stage, it is recommended that firmware classifies the corresponding alert as fatal on the receiver end, i.e, inside the alert handler.
                  Clearing this bit does not revoke a local escalation it has already caused while !!DIS.LOCAL_ESC_RELBL_ERR was set.
                  '''
          },
          { bits: "10",
            name: "phy_rd_intg_err",
            swaccess: "ro",
            desc: '''
                  The RRAM phy encountered an integrity error. The shadow response was not identical to the original response.
                  '''
          },
          { bits: "11",
            name: "phy_rd_ctrl_err",
            swaccess: "ro",
            desc: '''
                  The RRAM phy detected one of the following errors:
                  - a mismatch of command request integrity and command response integrity.
                  - a spurious valid.
                  - a spurious rram read request.
                  - a read-buffer update, verify or hit in an illegal read-buffer state.
                  '''
          },
          { bits: "12",
            name: "spurious_done",
            swaccess: "ro",
            desc: '''
                  The RRAM emitted an unexpected acknowledgement.
                  '''
          },
          { bits: "13",
            name: "host_gnt_err",
            swaccess: "ro",
            desc: '''
                  A host transaction was granted with illegal properties.
                  '''
          },
        ]
      },

      { name: "ERR_ADDR",
        desc: '''
              This register is set whenever a software operation ends with !!ERR_CODE.MP_ERR, !!ERR_CODE.RD_ERR or !!ERR_CODE.WR_ERR.
              It contains the address of the first word to cause an error for the operation.
              ''',
        swaccess: "ro",
        hwaccess: "hwo",
        fields: [
          { bits: "20:0",
            resval: 0,
          },
        ]
      },

      { name: "CORR1_ERR_CNT",
        desc: "Count of correctable single-bit ECC errors",
        swaccess: "rw",
        hwaccess: "hrw",
        fields: [
          { bits: "7:0",
            name: "val",
            desc: "This count will not wrap when saturated",
            resval: 0,
          },
        ]
      },

      { name: "CORR2_ERR_CNT",
        desc: "Count of correctable double-bit ECC errors",
        swaccess: "rw",
        hwaccess: "hrw",
        fields: [
          { bits: "7:0",
            name: "val",
            desc: "This count will not wrap when saturated",
            resval: 0,
          },
        ]
      },

      { name: "CORR1_ERR_LOC",
        desc: "Last address that was corrected by the ECC decoder with a single-bit error",
        swaccess: "ro",
        hwaccess: "hwo",
        fields: [
          { bits: "20:0",
            name: "addr",
            desc: "Last corrected address",
            resval: 0,
          },
          { bits: "24",
            name: "part"
            desc: "Last corrected partition",
            resval: 0,
          },
        ]
      }

      { name: "CORR2_ERR_LOC",
        desc: "Last address that was corrected by the ECC decoder with a double-bit error",
        swaccess: "ro",
        hwaccess: "hwo",
        fields: [
          { bits: "20:0",
            name: "addr",
            desc: "Last corrected address",
            resval: 0,
          },
          { bits: "24",
            name: "part"
            desc: "Last corrected partition",
            resval: 0,
          },
        ]
      }

      { name: "PHY_STATUS",
        desc: "RRAM Phy Status",
        swaccess: "ro",
        hwaccess: "hwo",
        fields: [
          { bits: "0",
            name: "wr_busy",
            desc: "RRAM phy is currently writing to RRAM"
          },
          { bits: "1",
            name: "init_done",
            desc: "RRAM phy is initialized (including RRAM)"
            tags: [ // Bit changes after start from reset value to 1b1 due to initialization
            "excl:CsrAllTests:CsrExclAll"]
          },
        ]
      },

      { name: "SCRATCH",
        desc: '''
              RRAM controller scratch register.
              It has no hardware function and can be used by software, e.g. for a basic register access check.
              ''',
        swaccess: "rw",
        fields: [
          { bits: "31:0", name: "data",  desc: "RRAM controller scratch register" },
        ]
      },

      { name: "FIFO_LVL",
        desc: "Programmable depth where FIFOs should generate interrupts",
        swaccess: "rw",
        hwaccess: "hro",
        fields: [
          { bits: "4:0",
            name: "WR",
            desc: '''
                  When the write FIFO drains to this level, trigger an interrupt.
                  The wr_lvl interrupt is a status interrupt that stays asserted while the write FIFO level is at or below this value.
                  Since the write FIFO is empty after reset, !!INTR_STATE.WR_LVL is set from reset for any value of this field.
                  The interrupt only reaches the processor if it is enabled in !!INTR_ENABLE.
                  '''
            resval: "0xF"
          },
          { bits: "12:8",
            name: "RD",
            desc: '''
                  When the read FIFO fills to this level, trigger an interrupt.
                  Default value is set such that interrupt does not trigger at reset.
                  '''
            resval: "0xF"
          },
        ]
      }

      { name: "FIFO_CLR",
        desc: "Clears RRAM controller FIFOs",
        swaccess: "wo",
        hwaccess: "hro",
        hwext: "true",
        hwqe: "true",
        fields: [
          { bits: "0",
            name: "WR",
            desc: '''
                  Writing 1 clears the content of the controller write FIFO.
                  Writing 0 has no effect.
                  '''
            resval: "0"
          },
          { bits: "1",
            name: "RD",
            desc: '''
                  Writing 1 clears the content of the controller read FIFO.
                  Writing 0 has no effect.
                  '''
            resval: "0"
          },
        ]
      },

      { name: "CURR_FIFO_LVL",
        desc: "Current write and read fifo level",
        swaccess: "ro",
        hwaccess: "hwo",
        hwext: "true",
        fields: [
          { bits: "4:0",
            name: "WR",
            desc: '''
                  Current write fifo level.
                  '''
            resval: "0x0"
          },
          { bits: "12:8",
            name: "RD",
            desc: '''
                  Current read fifo level.
                  '''
            resval: "0x0"
          },
        ]
      }

      { window: {
          name: "wr_fifo",
          items: "1",
          validbits: "32",
          data-intg-passthru: "true",
          byte-write: "false",
          unusual: "false"
          swaccess: "wo",
          desc: '''
                RRAM write FIFO.

                The FIFO is 4 entries of 4B words. This FIFO can only be programmed by software after a write operation has been initiated via the !!CONTROL register.
                Writes while no software operation is in progress complete without an error response and the data is discarded.
                This ensures accidental programming of the write FIFO cannot lock up the system.
                '''
        },
      },

      { window: {
          name: "rd_fifo",
          items: "1",
          validbits: "32",
          data-intg-passthru: "true",
          byte-write: "false",
          unusual: "false"
          swaccess: "ro",
          desc: '''
                RRAM read FIFO.

                The FIFO is 16 entries of 4B words.
                '''
        },
      },
    ]
  }
  memory: {
    host: {}
  }
}
