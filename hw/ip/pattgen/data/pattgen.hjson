// Copyright lowRISC contributors.
// Licensed under the Apache License, Version 2.0, see LICENSE for details.
// SPDX-License-Identifier: Apache-2.0

{ name: "pattgen",
  clock_primary: "clk_i",
  bus_device: "tlul",
  bus_host: "none",
  estimated_gate: "1k",
  regwidth: "32",
  // OUTPUT pins
  available_output_list: [
    { name: "pda0_tx", desc: "Serial output data bit for pattern generation on channel 0" }
    { name: "pcl0_tx", desc: "Bit-banging output clock for pattern generation on channel 0" }
    { name: "pda1_tx", desc: "Serial output data bit for pattern generation on channel 1" }
    { name: "pcl1_tx", desc: "Bit-banging output clock for pattern generation on channel 1" }
  ]
  // INTERRUPT pins
  interrupt_list: [
    { name: "intr_patt_done_ch0",
      desc: "raise if pattern generation on channel 0 is complete"
    }
    { name: "intr_patt_done_ch1",
      desc: "raise if pattern generation on channel 1 is complete"
    }
  ],
  param_list: [
    { name:    "NumRegsPrediv",
      type:    "int",
      default: "2",
      desc:    "Number pre-dividers egister",
      local:   "true"
    }
    { name:    "NumRegsData",
      type:    "int",
      default: "2",
      desc:    "Number data register per each channel",
      local:   "true"
    }
  ],
  // REGISTER definition
  registers: [
    // CTRL register
    { name: "PATT_CTRL",
      desc: "PATTGEN control register (function tbd ...)",
      swaccess: "rw",
      hwaccess: "hro",
      fields: [
        { bits: "0",
          resval: "0",
          name: "ENABLE",
          desc: "Enable pattern generator functionality"
        }
      ]
    }
    { name: "PATT_START",
      desc: "PATTGEN start generating patterns on output channels",
      swaccess: "wo",
      hwaccess: "hro",
      hwqe: "true",
      fields: [
        { bits: "0",
          resval: "0",
          name: "CH0_START",
          desc: "Start generating pattern on channel 0"
        }
        { bits: "1",
          resval: "0",
          name: "CH1_START",
          desc: "Start generating pattern on channel 1"
        }
      ]
    }
    { multireg: {
        name: "PATT_PREDIV",
        desc: "PATTGEN pre-divider multi-registers",
        count: "NumRegsPrediv",
        cname: "PATTGEN",
        swaccess: "wo",
        hwaccess: "hro",
        hwqe: "true",
        fields: [
          { bits: "31:0",
            resval: "0",
            name: "CLK_RATIO",
            desc: "Dividend ratio from based I/O clock for channel 0 (base is 2)"
          }
        ]
      }
    },
    { multireg: {
        name: "PATT_DATA_CH0",
        desc: "PATTGEN Seed pattern multi-registers for channel 0",
        count: "NumRegsData",
        cname: "PATTGEN",
        swaccess: "wo",
        hwaccess: "hro",
        hwqe: "true",
        fields: [
          { bits: "31:0",
            resval: "0",
            name: "DATA",
            desc: "Seed pattern for channel 0 (2-64 bits)"
          }
        ]
      }
    },
    { multireg: {
        name: "PATT_DATA_CH1",
        desc: "PATTGEN Seed pattern multi-registers for channel 1",
        count: "NumRegsData",
        cname: "PATTGEN",
        swaccess: "wo",
        hwaccess: "hro",
        hwqe: "true",
        fields: [
          { bits: "31:0",
            resval: "0",
            name: "DATA",
            desc: "Seed pattern for channel 1 (2-64 bits)"
          }
        ]
      }
    },
    { name: "PATT_LEN",
      desc: "PATTGEN pattern length (base is 2)",
      swaccess: "wo",
      hwaccess: "hro",
      hwqe: "true",
      fields: [
        { bits: "5:0",
          resval: "0",
          name: "CH0_LEN",
          desc: "Length of the seed pattern for channel 0 (2-64 bits)"
        }
        { bits: "12:7",
          resval: "0",
          name: "CH1_LEN",
          desc: "Length of the seed pattern for channel 1 (2-64 bits)"
        }
      ]
    }
    { name: "PATT_LOOP",
      desc: "PATTGEN number of pattern repeatedly generated before halt (base is 1)",
      swaccess: "wo",
      hwaccess: "hro",
      hwqe: "true",
      fields: [
        { bits: "9:0",
          resval: "0",
          name: "CH0_LOOP",
          desc: "Number of the seed patterns repeatedly generated on channel 0 (base is 1)"
        }
        { bits: "19:10",
          resval: "0",
          name: "CH1_LOOP",
          desc: "Number of the seed patterns repeatedly generated on channel 1 (base is 1)"
        }
      ]
    }
  ]
}
