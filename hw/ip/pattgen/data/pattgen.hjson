// Copyright lowRISC contributors.
// Licensed under the Apache License, Version 2.0, see LICENSE for details.
// SPDX-License-Identifier: Apache-2.0

{ name: "pattgen"
  clock_primary: "clk_fixed"
  bus_device: "tlul"
  bus_host: "none"
  estimated_gate: "1k"
  // OUTPUT pins
  available_output_list: [
    { name: "pda1_tx", desc: "Serial output data bit for pattern generation on channel 1" }
    { name: "pcl1_tx", desc: "Bit-banging output clock for pattern generation on channel 1" }
    { name: "pda2_tx", desc: "Serial output data bit for pattern generation on channel 2" }
    { name: "pcl2_tx", desc: "Bit-banging output clock for pattern generation on channel 2" }
  ]
  // INTERRUPT pins
  interrupt_list: [
    { name: "patt_done1"
      desc: "raise if pattern generation on channel 1 is complete"
    }
    { name: "patt_done2"
      desc: "raise if pattern generation on channel 2 is complete"
    }
  ]

  // REGISTER definition
  regwidth: "32"
  registers: [
    // CTRL register
    { name: "CTRL"
      desc: "PATTGEN control register (Functions TBD)"
      swaccess: "rw"
      hwaccess: "hro"
      fields: [
        { bits: "0"
          resval: "0"
          name: "ENABLE"
          desc: '''
                Enable pattern generator functionality
                '''
        }
      ]
    }
    { name: "START"
      desc: "PATTGEN start pattern generation"
      swaccess: "wo"
      hwaccess: "hro"
      hwqe: "true"
      fields: [
        { bits: "0"
          resval: "0"
          name: "START0"
          desc: "Start generating pattern on channel 1"
        }
        { bits: "1"
          resval: "0"
          name: "START1"
          desc: "Start generating pattern on channel 1"
        }
      ]
    }
    { name: "PREDIV1"
      desc: "PATTGEN pre-divider of I/O clock for chanel 1 (base is 2)"
      swaccess: "rw"
      hwaccess: "hro"
      hwqe: "true"
      fields: [
        { bits: "31:0"
          resval: "0"
          name: "RATIO"
          desc: "Dividend ratio for channel 1 (base is 2)"
        }
      ]
    }
    { name: "PREDIV2"
      desc: "PATTGEN pre-divider of I/O clock for chanel 2 (base is 2)"
      swaccess: "rw"
      hwaccess: "hro"
      hwqe: "true"
      fields: [
        { bits: "31:0"
          resval: "0"
          name: "RATIO"
          desc: "Dividend ratio for channel 2 (base is 2)"
        }
      ]
    }
    { name: "PATT_LEN"
      desc: "PATTGEN pattern length (base is 2)"
      swaccess: "rw"
      hwaccess: "hro"
      hwqe: "true"
      fields: [
        { bits: "5:0"
          resval: "0"
          name: "LEN1"
          desc: "Length of pattern generated on channel 1 (base is 2)"
        }
        { bits: "12:7"
          resval: "0"
          name: "LEN2"
          desc: "Length of pattern generated on channel 2 (base is 2)"
        }
      ]
    }
    { name: "PATT_LOOP"
      desc: "PATTGEN number of pattern repeatedly generated before halt (base is 1)"
      swaccess: "rw"
      hwaccess: "hro"
      hwqe: "true"
      fields: [
        { bits: "9:0"
          resval: "0"
          name: "LOOP1"
          desc: "Pattern repeatedly generated on channel 1 (base is 1)"
        }
        { bits: "19:10"
          resval: "0"
          name: "LOOP2"
          desc: "Pattern repeatedly generated on channel 2 (base is 1)"
        }
      ]
    }
    { name: "INTR_MASK"
      desc: "PATTGEN mask registers for channel interrupts"
      swaccess: "rw"
      hwaccess: "hro"
      hwqe: "true"
      fields: [
        { bits: "0"
          resval: "0"
          name: "MASK1"
          desc: "Enable pattern_done interrupt of channel 1 if set to 1"
        }
        { bits: "1"
          resval: "0"
          name: "MASK2"
          desc: "Enable pattern_done interrupt of channel 2 if set to 1"
        }
      ]
    }
  ]
}
