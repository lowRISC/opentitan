// Copyright lowRISC contributors.
// Licensed under the Apache License, Version 2.0, see LICENSE for details.
// SPDX-License-Identifier: Apache-2.0
{ name: "otp_ctrl",
  clock_primary: "clk_i",
  bus_device: "tlul",
  bus_host: "none",

  ///////////////////////////
  // Interrupts and Alerts //
  ///////////////////////////

  interrupt_list: [
    { name: "otp_operation_done",
      desc: "A direct access command or digest calculation operation has completed."
    }
    { name: "otp_error",
      desc: "An error has occurred in the OTP controller. Check the ERR_CODE register to get more information."
    }
  ],

  alert_list: [
    { name: "otp_fatal_error",
      desc: "This alert triggers if hardware detects a parity bit or digest error in the buffered partitions.",
    }
    { name: "otp_check_failed",
      desc: "This alert triggers if the digest over the buffered registers does not match with the digest stored in OTP.",
    }
  ],

  ////////////////
  // Parameters //
  ////////////////
  param_list: [
    { name: "OtpByteAddrWidth",
      desc: "Width of the OTP Byte address.",
      type: "int",
      default: "11",
      local: "true"
    },
    { name: "NumErrorEntries",
      desc: "Number of error register entries.",
      type: "int",
      default: "9", // 7 partitions + DAI/LCI
      local: "true"
    },
    { name: "NumDaiWords",
      desc: "Number of 32bit words in the DAI.",
      type: "int",
      default: "2",
      local: "true"
    },
    { name: "NumDigestWords",
      desc: "Size of the digest fields in 32bit words.",
      type: "int",
      default: "2",
      local: "true"
    },
    { name: "NumLcHalfwords",
      desc: "Number of 16bit life cycle fields.",
      type: "int",
      default: "12",
      local: "true"
    },
    { name: "NumCreatorSwCfgWindowWords",
      desc: "Size of the TL-UL window in 32bit words. Note that the effective partition size is smaller than that.",
      type: "int",
      default: "256",
      local: "true"
    },
    { name: "NumOwnerSwCfgWindowWords",
      desc: "Size of the TL-UL window in 32bit words. Note that the effective partition size is smaller than that.",
      type: "int",
      default: "256",
      local: "true"
    },
    { name: "NumDebugWindowWords",
      desc: "Size of the TL-UL window in 32bit words.",
      type: "int",
      default: "512",
      local: "true"
    },
  ]

  /////////////////////////////
  // Intermodule Connections //
  /////////////////////////////
  // TODO: these need to be refined during implementation and integration
  inter_signal_list: [
    // CSRNG interface
    { struct: "otp_csrng"
      type:   "req_rsp"
      name:   "otp_csrng"
      act:    "req"
      package: "otp_ctrl_pkg"
    }
    // Power manager init command
    { struct: "pwr_otp"
      type:   "req_rsp"
      name:   "pwr_otp_init"
      act:    "rsp"
      package: "pwrmgr_pkg"
    }
    // Status output to power manager
    { struct: "otp_pwr_state"
      type:   "uni"
      name:   "otp_pwr_state"
      act:    "req"
      package: "otp_ctrl_pkg"
    }
    // LC transition command
    { struct: "lc_otp_program"
      type:   "req_rsp"
      name:   "lc_otp_program"
      act:    "rsp"
      package: "otp_ctrl_pkg"
    }
    // Broadcast to LC
    { struct: "otp_lc_data"
      type:   "uni"
      name:   "otp_lc_data"
      act:    "req"
      package: "otp_ctrl_pkg"
    }
    // Broadcast from LC
    { struct: "lc_tx"
      type:   "uni"
      name:   "lc_escalate_en"
      act:    "rcv"
      package: "lifecycle_pkg" // TODO: move to LC package?
    }
    { struct: "lc_tx"
      type:   "uni"
      name:   "lc_provision_en"
      act:    "rcv"
      package: "lifecycle_pkg" // TODO: move to LC package?
    }
    { struct: "lc_tx"
      type:   "uni"
      name:   "lc_test_en"
      act:    "rcv"
      package: "lifecycle_pkg" // TODO: move to LC package?
    }
    // Broadcast to Key Manager
    { struct: "keymgr_key"
      type:   "uni"
      name:   "otp_keymgr_key"
      act:    "req"
      package: "otp_ctrl_pkg" // TODO: move this to keymgr package?
    }
    // Broadcast to Flash Controller
    { struct: "flash_key"
      type:   "uni"
      name:   "otp_flash_key"
      act:    "req"
      package: "otp_ctrl_pkg"
    }
    // Key request from Main RAM Scrambler
    { struct: "ram_main_key"
      type:   "req_rsp"
      name:   "otp_ram_main_key"
      act:    "rsp"
      package: "otp_ctrl_pkg"
    }
    // Key request from Retention RAM Scrambler
    { struct: "ram_ret_aon_key"
      type:   "req_rsp"
      name:   "otp_ram_ret_aon_key"
      act:    "rsp"
      package: "otp_ctrl_pkg"
    }
    // Key request from OTBN RAM Scrambler
    { struct: "otbn_ram_key"
      type:   "req_rsp"
      name:   "otp_otbn_ram_key"
      act:    "rsp"
      package: "otp_ctrl_pkg"
    }
  ] // inter_signal_list

  regwidth: "32",
  registers: [

    ////////////////////////
    // Ctrl / Status CSRs //
    ////////////////////////

    { name: "STATUS",
      desc: "OTP status register.",
      swaccess: "ro",
      hwaccess: "hwo",
      hwext:    "true",
      fields: [
        { bits: "0"
          name: "CREATOR_SW_CFG_ERROR"
          desc: '''
                Set to 1 if an error occurred in this partition. If set to 1, SW should
                check the !!ERR_CODE register at the corresponding index to root-cause the error.
                '''
        }
        { bits: "1"
          name: "OWNER_SW_CFG_ERROR"
          desc: '''
                Set to 1 if an error occurred in this partition. If set to 1, SW should
                check the !!ERR_CODE register at the corresponding index to root-cause the error.
                '''
        }
        { bits: "2"
          name: "HW_CFG_ERROR"
          desc: '''
                Set to 1 if an error occurred in this partition. If set to 1, SW should
                check the !!ERR_CODE register at the corresponding index to root-cause the error.
                '''
        }
        { bits: "3"
          name: "SECRET0"
          desc: '''
                Set to 1 if an error occurred in this partition. If set to 1, SW should
                check the !!ERR_CODE register at the corresponding index to root-cause the error.
                '''
        }
        { bits: "4"
          name: "SECRET1"
          desc: '''
                Set to 1 if an error occurred in this partition. If set to 1, SW should
                check the !!ERR_CODE register at the corresponding index to root-cause the error.
                '''
        }
        { bits: "5"
          name: "SECRET2"
          desc: '''
                Set to 1 if an error occurred in this partition. If set to 1, SW should
                check the !!ERR_CODE register at the corresponding index to root-cause the error.
                '''
        }
        { bits: "6"
          name: "LIFE_CYCLE"
          desc: '''
                Set to 1 if an error occurred in this partition. If set to 1, SW should
                check the !!ERR_CODE register at the corresponding index to root-cause the error.
                '''
        }
        { bits: "7"
          name: "DAI_ERROR"
          desc: '''
                Set to 1 if an error occurred in the DAI. If set to 1, SW should
                check the !!ERR_CODE register at the corresponding index to root-cause the error.
                '''
        }
        { bits: "8"
          name: "LCI_ERROR"
          desc: '''
                Set to 1 if an error occurred in the LCI. If set to 1, SW should
                check the !!ERR_CODE register at the corresponding index to root-cause the error.
                '''
        }
        { bits: "9"
          name: "DAI_IDLE"
          desc: "Set to 1 if the DAI is idle and ready to accept commands."
        }
      ]
    }
    { multireg: {
        name:     "ERR_CODE",
        desc:     '''
                  This register holds information on error conditions and should be
                  checked when any of the partitions or the DAI flags an error in the
                  !!STATUS registers, or when an !!INTR_STATE.otp_error has been triggered.
                  Note that all errors trigger an otp_error interrupt, and in addition some
                  errors may trigger either an otp_fatal_error or an otp_check_failed alert.
                  ''',
        count:     "NumErrorEntries",
        swaccess:  "ro",
        hwaccess:  "hwo",
        hwext:     "true",
        cname:     "MODULE",
        fields: [
          {
            bits: "3:0"
            enum: [
              { value: "0",
                name: "NO_ERR",
                desc: '''
                No error condition has occurred.
                '''
              },
              { value: "1",
                name: "OTP_CMD_INV_ERR",
                desc: '''
                An invalid command has been written to the OTP macro.
                This error should never occur during normal operation and is not recoverable.
                If this error is present this may be a sign that the device is malfunctioning.
                This error triggers an otp_fatal_error alert.
                '''
              },
              { value: "2",
                name: "OTP_INIT_ERR",
                desc: '''
                The OTP macro initialization sequence has failed.
                This error should never occur during normal operation and is not recoverable.
                If this error is present this may be a sign that the device is malfunctioning.
                This error triggers an otp_fatal_error alert.
                '''
              },
              { value: "3",
                name: "OTP_READ_CORR_ERR",
                desc: '''
                A correctable error has occured during an OTP read operation.
                The corresponding controller automatically recover from this error when
                issuing a new command.
                '''
              },
              { value: "4",
                name: "OTP_READ_UNCORR_ERR",
                desc: '''
                An uncorrectable error has occurred during an OTP read operation.
                This error should never occur during normal operation and is not recoverable.
                If this error is present this may be a sign that the device is malfunctioning.
                This error triggers an otp_fatal_error alert.
                '''
              },
              { value: "5",
                name: "OTP_READ_ERR",
                desc: '''
                A unspecified error has occurred during an OTP read operation.
                This error should never occur during normal operation and is not recoverable.
                If this error is present this may be a sign that the device is malfunctioning.
                This error triggers an otp_fatal_error alert.
                '''
              },
              { value: "6",
                name: "OTP_WRITE_BLANK_ERR",
                desc: '''
                A blank write check has failed during an OTP write operation.
                This effectively aborts the write operation such that no harm is done to the OTP.
                The corresponding controller automatically recovers from this error when issuing
                a new command.
                '''
              },
              { value: "7",
                name: "OTP_WRITE_ERR",
                desc: '''
                A unspecified error has occurred during an OTP write operation.
                This error should never occur during normal operation and is not recoverable.
                If this error is present this may be a sign that the device is malfunctioning.
                This error triggers an otp_fatal_error alert.
                '''
              },
              { value: "8",
                name: "CMD_INV_ERR",
                desc: '''
                This error indicates that an invalid command has been written to the DAI.
                The DAI controller automatically recovers from this error when issuing
                a new command.
                '''
              },
              { value: "9",
                name: "ACCESS_ERR",
                desc: '''
                This error indicates that a locked memory region has been accessed.
                The corresponding controller automatically recovers from this error when
                issuing a new command.
                '''
              },
              { value: "10",
                name: "PARITY_ERROR",
                desc: '''
                A parity mismatch has been detected in the buffer registers.
                This error should never occur during normal operation and is not recoverable.
                This error triggers an otp_check_failed alert.
                '''
              },
              { value: "11",
                name: "INTEG_ERR",
                desc: '''
                An integrity check mismatch has been detected in the buffer registers.
                This error should never occur during normal operation and is not recoverable.
                This error triggers an otp_check_failed alert.
                '''
              },
              { value: "12",
                name: "CNSTY_ERR",
                desc: '''
                A consistency check mismatch has been detected in the buffer registers.
                This error should never occur during normal operation and is not recoverable.
                This error triggers an otp_check_failed alert.
                '''
              },
              { value: "13",
                name: "FSM_ERR",
                desc: '''
                The FSM of the corresponding controller has reached a parasitic state.
                This error should never occur during normal operation and is not recoverable.
                If this error is present, this is a sign that the device has fallen victim to
                a glitch attack.
                This error triggers an otp_check_failed alert.
                '''
              },
              { value: "14",
                name: "ESC_ERR",
                desc: '''
                This error is the result of an escalation action in the alert subsystem, and
                indicates that the corresponding controller FSM has been moved into a terminal
                state due to escalation via the alert subsystem.
                '''
              },
            ]
          }
        ]
      }
    }
    { name: "DIRECT_ACCESS_REGWEN",
      desc: '''
            Register write enable for all direct access interface registers.
            ''',
      swaccess: "ro",
      hwaccess: "hwo",
      hwext:    "true",
      fields: [
        {
            bits:   "0",
            desc: ''' This bit is hardware-managed and only readable by software. The DAI sets this bit temporarily to 0 during an OTP operation such that the corresponding address and data
            registers cannot be modified while the operation is pending.
            '''
            resval: 1,
        },
      ]
    },
    { name: "DIRECT_ACCESS_CMD",
      desc: "Command register for direct accesses.",
      swaccess: "r0w1c",
      hwaccess: "hro",
      hwqe:     "true",
      regwen:   "DIRECT_ACCESS_REGWEN",
      fields: [
        { bits: "0",
          name: "READ",
          desc: '''
          Initiates a readout sequence that reads the location specified
          by !!DIRECT_ACCESS_ADDRESS. The command places the data read into
          !!DIRECT_ACCESS_RDATA_0 and !!DIRECT_ACCESS_RDATA_1 (for 64bit partitions).
          '''
        }
        { bits: "1",
          name: "WRITE",
          desc: '''
                Initiates a programming sequence that writes the data in !!DIRECT_ACCESS_WDATA_0
                and !!DIRECT_ACCESS_WDATA_1 (for 64bit partitions) to the location specified by
                !!DIRECT_ACCESS_ADDRESS.
                '''
        }
        { bits: "2",
          name: "DIGEST",
          desc: '''
                Initiates the digest calculation and locking sequence for the partition specified by
                !!DIRECT_ACCESS_ADDRESS.
                '''
        }
      ]
    }
    { name: "DIRECT_ACCESS_ADDRESS",
      desc: "Address register for direct accesses.",
      swaccess: "rw",
      hwaccess: "hro",
      hwqe:     "false",
      regwen:   "DIRECT_ACCESS_REGWEN",
      fields: [
        { bits: "OtpByteAddrWidth-1:0",
          desc: '''
                This is the address for the OTP word to be read or written through
                the direct access interface. Note that the address is aligned to the access size
                internally, hence bits 1:0 are ignored for 32bit accesses, and bits 2:0 are ignored
                for 64bit accesses.

                For the digest calculation command, set this register to the appropriate partition index
                (0x2: !!HW_CFG_DIGEST, 0x4: !!SECRET0_DIGEST, 0x5: !!SECRET1_DIGEST and 0x6: !!SECRET2_DIGEST).
                '''
        }
      ]
    }
    { multireg: {
        name:     "DIRECT_ACCESS_WDATA",
        desc:     '''Write data for direct accesses.
                  Hardware automatically determines the access granule (32bit or 64bit) based on which
                  partition is being written to.
                  ''',
        count:    "NumDaiWords", // 2 x 32bit = 64bit
        swaccess: "rw",
        hwaccess: "hro",
        hwqe:     "false",
        regwen:   "DIRECT_ACCESS_REGWEN",
        cname:    "WORD",
        fields: [
          { bits: "31:0"
          }
        ]
      }
    },
    { multireg: {
        name:     "DIRECT_ACCESS_RDATA",
        desc:     '''Read data for direct accesses.
                  Hardware automatically determines the access granule (32bit or 64bit) based on which
                  partition is read from.
                  ''',
        count:    "NumDaiWords", // 2 x 32bit = 64bit
        swaccess: "ro",
        hwaccess: "hwo",
        hwext:    "true",
        cname:    "WORD",
        fields: [
          { bits: "31:0"
          }
        ]
      }
    },
    { name: "CHECK_PERIOD_REGEN",
      desc: '''
            Register write enable for !!INTEGRITY_CHECK_PERIOD_MSB and !!CONSISTENCY_CHECK_PERIOD_MSB.
            ''',
      swaccess: "rw1c",
      hwaccess: "hro",
      fields: [
        { bits:   "0",
          desc: '''
          When true, !!INTEGRITY_CHECK_PERIOD_MSB and !!CONSISTENCY_CHECK_PERIOD_MSB registers cannot be written anymore.
          '''
          resval: 1,
        },
      ]
    },
    { name: "INTEGRITY_CHECK_PERIOD_MSB",
      desc: '''
            This value specifies the maximum period that can be generated pseudo-randomly.
            Only applies to the HW_CFG and SECRET partitions if they are locked.
            '''
      swaccess: "rw",
      hwaccess: "hro",
      regwen:   "CHECK_PERIOD_REGEN",
      fields: [
        { bits: "5:0",
          desc: '''
          The pseudo-random period is generated using a 40bit LFSR internally, and this value defines
          the bit mask to be applied to the LFSR output in order to limit its range. A value of N will generate
          an internal mask of 2^N-1. So for N=16 this would allow the maximum pseudo-random period to be 0xFFFF cycles.
          The default value has been set to 25, which corresponds to a maximum period of a bit more than 1.3s at 25MHz.
          '''
          resval: "25"
        }
      ]
    }
    { name: "CONSISTENCY_CHECK_PERIOD_MSB",
      desc: '''
            This value specifies the maximum period that can be generated pseudo-randomly.
            This applies to the LIFE_CYCLE partition and the HW_CFG and SECRET partitions (but only if they are locked).
            '''
      swaccess: "rw",
      hwaccess: "hro",
      regwen:   "CHECK_PERIOD_REGEN",
      fields: [
        { bits: "5:0",
          desc: '''
          The pseudo-random period is generated using a 40bit LFSR internally, and this value defines
          the bit mask to be applied to the LFSR output in order to limit its range. A value of N will generate
          an internal mask of 2^N-1. So for N=16 this would allow the maximum pseudo-random period to be 0xFFFF cycles.
          The default value has been set to 34, which corresponds to a maximum period of a bit more than 687s at 25MHz.
          '''
          resval: "34"
        }
      ]
    }

    ////////////////////////////////////
    // Dynamic Locks of SW Parititons //
    ////////////////////////////////////
    { name: "CREATOR_SW_CFG_READ_LOCK",
      desc: '''
            Runtime read lock for the creator software partition.
            ''',
      swaccess: "rw1c",
      hwaccess: "hro",
      fields: [
        { bits:   "0",
          desc: '''
          When true, read access to the !!CREATOR_SW_CFG partition is locked.
          '''
          resval: 1,
        },
      ]
    },
    { name: "OWNER_SW_CFG_READ_LOCK",
      desc: '''
            Runtime read lock for the owner software partition.
            ''',
      swaccess: "rw1c",
      hwaccess: "hro",
      fields: [
        { bits:   "0",
          desc: '''
          When true, read access to the !!OWNER_SW_CFG partition is locked.
          '''
          resval: 1,
        },
      ]
    },

    ///////////////////////
    // Integrity Digests //
    ///////////////////////
    { multireg: {
        name:     "CREATOR_SW_CFG_DIGEST",
        desc:     '''
                  Integrity digest for the creator software config partition.
                  The integrity digest is 0 by default. Software must write this
                  digest value via the direct access interface in order to lock the partition.
                  After a reset, write access to the !!OWNER_SW_CFG partition is locked and
                  the digest becomes visible in this CSR.
                  ''',
        count:     "NumDigestWords",
        swaccess:  "ro",
        hwaccess:  "hwo",
        hwext:     "true",
        cname:     "WORD",
        fields: [
          { bits: "31:0"
          }
        ]
      }
    },
    { multireg: {
        name:     "OWNER_SW_CFG_DIGEST",
        desc:     '''
                  Integrity digest for the owner software config partition.
                  The integrity digest is 0 by default. Software must write this
                  digest value via the direct access interface in order to lock the partition.
                  After a reset, write access to the !!OWNER_SW_CFG partition is locked and
                  the digest becomes visible in this CSR.
                  ''',
        count:     "NumDigestWords",
        swaccess:  "ro",
        hwaccess:  "hwo",
        hwext:     "true",
        cname:     "WORD",
        fields: [
          { bits: "31:0"
          }
        ]
      }
    },
    { multireg: {
        name:     "HW_CFG_DIGEST",
        desc:     '''
                  Hardware config partition integrity digest.
                  The integrity digest is 0 by default. The digest calculation can be triggered via the !!DIRECT_ACCESS_CMD.
                  After a reset, the digest then becomes visible in this CSR, and the corresponding partition becomes write-locked.
                  ''',
        count:     "NumDigestWords",
        swaccess:  "ro",
        hwaccess:  "hwo",
        hwext:     "true",
        cname:     "WORD",
        fields: [
          { bits: "31:0"
          }
        ]
      }
    },
    { multireg: {
        name:     "SECRET0_DIGEST",
        desc:     '''
                  Integrity digest for the SECRET0 partition.
                  The integrity digest is 0 by default. The digest calculation can be triggered via the !!DIRECT_ACCESS_CMD.
                  After a reset, the digest then becomes visible in this CSR, and the corresponding partition becomes write-locked.
                  ''',
        count:     "NumDigestWords",
        swaccess:  "ro",
        hwaccess:  "hwo",
        hwext:     "true",
        cname:     "WORD",
        fields: [
          { bits: "31:0"
          }
        ]
      }
    },
    { multireg: {
        name:     "SECRET1_DIGEST",
        desc:     '''
                  Integrity digest for the SECRET1 partition.
                  The integrity digest is 0 by default. The digest calculation can be triggered via the !!DIRECT_ACCESS_CMD.
                  After a reset, the digest then becomes visible in this CSR, and the corresponding partition becomes write-locked.
                  ''',
        count:     "NumDigestWords",
        swaccess:  "ro",
        hwaccess:  "hwo",
        hwext:     "true",
        cname:     "WORD",
        fields: [
          { bits: "31:0"
          }
        ]
      }
    },
    { multireg: {
        name:     "SECRET2_DIGEST",
        desc:     '''
                  Integrity digest for the SECRET2 partition.
                  The integrity digest is 0 by default. The digest calculation can be triggered via the !!DIRECT_ACCESS_CMD.
                  After a reset, the digest then becomes visible in this CSR, and the corresponding partition becomes write-locked.
                  ''',
        count:     "NumDigestWords",
        swaccess:  "ro",
        hwaccess:  "hwo",
        hwext:     "true",
        cname:     "WORD",
        fields: [
          { bits: "31:0"
          }
        ]
      }
    },

    //////////////////////
    // Life Cycle State //
    //////////////////////
    { multireg: {
        name:     "LC_STATE",
        desc:     '''
                  Life cycle state, comprised of 12 16bit words.
                  TODO: add link to LC controller spec.
                  Other values than specified below are invalid.
                  ''',
        count:    "NumLcHalfwords",
        swaccess: "ro",
        hwaccess: "hwo",
        cname:    "HALFWORD",
        fields: [
          { bits: "15:0"
            enum: [
              { value: "0",
                name: "BLANK",
                desc: '''
                0x0000
                '''
              },
              { value: "62970",
                name: "SET",
                desc: '''
                0xF5FA
                '''
              },
            ]
          }
        ]
      }
    },
    { name: "LC_TRANSITION_CNT",
      desc: "Counter for total amount of state transition attempts.",
      swaccess: "ro",
      hwaccess: "hwo",
      fields: [
        { bits: "31:0",
          desc: '''
          This counter will be incremented upon each state transition attempt,
          or when the transition command coming from the life cycle controller is invalid.
          '''
        }
      ]
    }

    ////////////////////////////////
    // Software Config Partitions //
    ////////////////////////////////
    { skipto: "0x400" }

    { window: {
        name: "CREATOR_SW_CFG"
        items: "NumCreatorSwCfgWindowWords"
        swaccess: "ro",
        desc: '''
        Any read to this window directly maps to the corresponding offset in the creator software
        config partition, and triggers an OTP readout of the Bytes requested. Note that the transaction
        will block until OTP readout has completed.
        '''
      }
    }

    { skipto: "0x800" }

    { window: {
        name: "OWNER_SW_CFG"
        items: "NumOwnerSwCfgWindowWords"
        swaccess: "ro",
        desc: '''
        Any read to this window directly maps to the corresponding offset in the owner software
        config partition, and triggers an OTP readout of the Bytes requested. Note that the transaction
        will block until OTP readout has completed.
        '''
      }
    }

    //////////////////////
    // Test Access Port //
    //////////////////////
    { skipto: "0xC00" }

    // TODO: may have to update description, once it is known how RAW unlock is handled.
    { window: {
        name: "TEST_ACCESS"
        items: "NumDebugWindowWords"
        swaccess: "rw",
        desc: '''
        This maps to the register file of the proprietary OTP macro. Note that this is only
        accessible during the TEST life cycle state.
        '''
      }
    }
  ],
}
