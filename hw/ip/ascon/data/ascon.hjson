// Copyright lowRISC contributors (OpenTitan project).
// Licensed under the Apache License, Version 2.0, see LICENSE for details.
// SPDX-License-Identifier: Apache-2.0
//
# Ascon register template
{
  name:          "ascon",
  human_name:    "Ascon accelerator",
  one_line_desc: "Ascon authenticated encryption and decryption engine",
  one_paragraph_desc: '''
  [Ascon][graz-ascon] is the winner of the NIST lightweight competition and soon to be
  [standardized][nist-ascon].

  [graz-ascon]: https://ascon.iaik.tugraz.at/
  [nist-ascon]: https://csrc.nist.gov/Presentations/2023/update-on-standardization-of-ascon-family
  '''
  regwidth:      "32",
  cip_id:        "40",
  version:       "0.0.1",
  clocking: [
    {clock: "clk_i", reset: "rst_ni", idle: "idle_o", primary: true},
    {clock: "clk_edn_i", reset: "rst_edn_ni", idle: "idle_o"}
  ],
  bus_interfaces: [
    { protocol: "tlul", direction: "device" }
  ],

  alert_list: [
    { name: "recov_ctrl_update_err",
      desc: '''
        This recoverable alert is triggered upon detecting an update error in the shadowed Control Register.
        The content of the Control Register is not modified (See Control Register).
        The Ascon unit can be recovered from such a condition by restarting the Ascon operation, i.e., by re-writing the Control Register.
        This should be monitored by the system.
      '''
    }
    { name: "fatal_fault",
      desc: '''
        This fatal alert is triggered upon detecting a fatal fault inside the Ascon unit.
        Examples for such faults include
        i) storage errors in the shadowed Control Register,
        ii) any internal FSM entering an invalid state,
        iii) any sparsely encoded signal taking on an invalid value,
        iv) errors in the internal round counter,
        v) escalations triggered by the life cycle controller, and
        vi) fatal integrity failures on the TL-UL bus.
        The Ascon unit cannot recover from such an error and needs to be reset.
      '''
    }
  ],

  param_list: [
    # Note: All parameters below are local, they are not actually configurable.
    # Selecting values different from the default values below might cause undefined behavior.
    { name:    "NumRegsKey",
      type:    "int",
      default: "4",
      desc:    "Number registers for key",
      local:   "true"
    },
    { name:    "NumRegsNonce",
      type:    "int",
      default: "4",
      desc:    "Number registers for nonce",
      local:   "true"
    },
    { name:    "NumRegsData",
      type:    "int",
      default: "4",
      desc:    "Number registers for input and output data (ad/plaintext/ciphertext)",
      local:   "true"
    },
    { name:    "NumRegsTag",
      type:    "int",
      default: "4",
      desc:    "Number registers for input and output tag",
      local:   "true"
    }
  ],

  /////////////////////////////
  // Intermodule Connections //
  /////////////////////////////

  inter_signal_list: [
    { name:    "idle",
      type:    "uni",
      act:     "req",
      package: "prim_mubi_pkg",
      struct:  "mubi4",
      width:   "1"
    },
    { struct:  "lc_tx"
      type:    "uni"
      name:    "lc_escalate_en"
      act:     "rcv"
      default: "lc_ctrl_pkg::Off"
      package: "lc_ctrl_pkg"
    }
    { struct:  "edn"
      type:    "req_rsp"
      name:    "edn"
      act:     "req"
      package: "edn_pkg"
    }
    { struct:  "hw_key_req"
      type:    "uni"
      name:    "keymgr_key"
      act:     "rcv"
      package: "keymgr_pkg"
    }
  ],

  registers: [
    { multireg: {
      name: "KEY_SHARE0",
      resval: "0",
      desc: '''
        Initial Key Registers Share 0.

        The actual initial key corresponds to Initial Key Registers Share 0 XORed with Initial Key Registers Share 1.
        Loaded into the internal Full Key register upon starting encryption/decryption.
        All key registers (Share 0 and Share 1) must be written at least once when the key is changed.
        The order in which the registers are updated does not matter.
        Can only be updated when the Ascon unit is idle.
        If the Ascon unit is non-idle, writes to these registers are ignored.
        Upon reset, these registers are cleared with pseudo-random data.
      '''
      count: "NumRegsKey",
      cname: "KEY_SHARE0",
      swaccess: "wo",
      hwaccess: "hrw",
      hwext:    "true",
      hwqe:     "true",
      fields: [
        { bits: "31:0", name: "key_share0", desc: "Initial Key Share 0" }
      ],
      }
    },
    { multireg: {
      name: "KEY_SHARE1",
      resval: "0",
      desc: '''
        Initial Key Registers Share 1.

        The actual initial key corresponds to Initial Key Registers Share 0 XORed with Initial Key Registers Share 1.
        Loaded into the internal Full Key register upon starting encryption/decryption.
        All key registers (Share 0 and Share 1) must be written at least once when the key is changed.
        The order in which the registers are updated does not matter.
        Can only be updated when the Ascon unit is idle.
        If the Ascon unit is non-idle, writes to these registers are ignored.
        Upon reset, these registers are cleared with pseudo-random data.
      '''
      count: "NumRegsKey",
      cname: "KEY_SHARE1",
      swaccess: "wo",
      hwaccess: "hrw",
      hwext:    "true",
      hwqe:     "true",
      fields: [
        { bits: "31:0", name: "key_share1", desc: "Initial Key Share 1" }
      ],
      }
    },
    { multireg: {
      name: "NONCE_SHARE0",
      desc: '''
        Input Nonce Register Share 0.
        The actual data corresponds to Nonce Input Registers Share 0 XORed with Nonce Input Registers Share 1.
        If SW does not want to provide the Nonce masked, it can simply set one share to all zeros and provide the unmasked nonce in the other share.
        All nonce registers (Share 0 and Share 1) must be written each time a new message is processed.
        Ascon requires the nonce to be unique for each message.
        However there are no hardware checks to enforce this.
        The order in which the registers are updated does not matter.
        If the user fails to update the register the !!ERROR.NO_NONCE Register is set.
        Can only be updated when the Ascon unit is idle.
        If the Ascon unit is non-idle, writes to these registers are ignored.
        Upon reset, these registers are cleared with pseudo-random data.
      '''
      count: "NumRegsNonce",
      cname: "NONCE_SHARE0",
      swaccess: "wo",
      hwaccess: "hrw",
      hwext:    "true"
      hwqe:     "true",
      fields: [
        { bits: "31:0", name: "nonce", desc: "Input Nonce Share 0" }
      ],
      }
    },
    { multireg: {
      name: "NONCE_SHARE1",
      desc: '''
        Input Nonce Register Share 1.
        The actual data corresponds to Nonce Input Registers Share 0 XORed with Nonce Input Registers Share 1.
        If SW does not want to provide the Nonce masked, it can simply set one share to all zeros and provide the unmasked nonce in the other share.
        All nonce registers (Share 0 and Share 1) must be written each time a new message is processed.
        Ascon requires the nonce to be unique for each message
        However there are no hardware checks to enforce this.
        The order in which the registers are updated does not matter.
        If the user fails to update the register the !!ERROR.NO_NONCE Register is set.
        Can only be updated when the Ascon unit is idle.
        If the Ascon unit is non-idle, writes to these registers are ignored.
        Upon reset, these registers are cleared with pseudo-random data.
      '''
      count: "NumRegsNonce",
      cname: "NONCE_SHARE1",
      swaccess: "wo",
      hwaccess: "hrw",
      hwext:    "true"
      hwqe:     "true",
      fields: [
        { bits: "31:0", name: "nonce", desc: "Input Nonce Share 1" }
      ],
      }
    },
    { multireg: {
      name: "DATA_IN_SHARE0",
      desc: '''
        Input Data Register 0.
        The actual data corresponds to Data Input Registers Share 0 XORed with Data Input Registers Share 1.
        This register holds Share 0 of one input block.
        This is either the associated data, plaintext or the ciphertext, depending on the mode.
        All registers must be written each time a new block is processed.
        Otherwise the engine stalls until all registers have been written.
        For Ascon 128 the upper 64 bit can be set to any value
        For partial blocks the unused bytes can be set to any value.
        The order in which the registers are updated does not matter.
      '''
      count: "NumRegsData",
      cname: "MSG_IN_SHARE0",
      swaccess: "wo",
      hwaccess: "hrw",
      hwext:    "true",
      hwqe:     "true",
      fields: [
        { bits: "31:0", name: "msg_in", desc: "Input Data Share 0" }
      ],
      }
    },
    { multireg: {
      name: "DATA_IN_SHARE1",
      desc: '''
        Data Input Register Share 1
        The actual message corresponds to Data Input Registers Share 0 XORed with Data Input Registers Share 1.
        This register holds Share 1 of one data input block.
        This is either the associated data, plaintext or the ciphertext, depending on the mode.
        If CTRL_SHADOWED.masked_{ad,msg}_input = 1, all registers must be written each time a block of associated data
        or message is processed
        If CTRL_SHADOWED.masked_{ad,msg}_input = 0, the write operation tracking for these registers is disabled.
        Software should set Share 1 to all zeros before the first block of associated data / message is written to
        Share 0.
        This basically disables input masking.
        For Ascon 128 the upper 64 bit can be set to any value.
        For partial blocks the unused bytes can be set to any value.
        The order in which the registers are updated does not matter.
      '''
      count: "NumRegsData",
      cname: "MSG_IN_SHARE1",
      swaccess: "wo",
      hwaccess: "hrw",
      hwext:    "true",
      hwqe:     "true",
      fields: [
        { bits: "31:0", name: "msg_in", desc: "Input Data Share 1" }
      ],
      }
    },
    { multireg: {
      name: "TAG_IN",
      desc: '''
        Input TAG Register.
        This register holds the expected tag for authenticated decryption.
        All registers must be written each time a new decryption is started.
        The order in which the registers are updated does not matter.
        Upon reset, these registers are cleared with pseudo-random data.
      '''
      count: "NumRegsTag",
      cname: "TAG_IN",
      swaccess: "wo",
      hwaccess: "hro",
      hwqe:     "true",
      fields: [
        { bits: "31:0", name: "tag_in", desc: "Input TAG" }
      ],
      }
    },
    { multireg: {
      name: "MSG_OUT",
      desc: '''
        Output Data Register.
        Holds the output data produced by the Ascon unit during the last encryption/decryption operation.
        If CTRL_AUX_SHADOWED.force_data_overwrite = 0 (see Control Register),
        the Ascon unit is stalled when the previous output data has not yet been read and is about to be overwritten.
        Each register has to be read at least once.
        The order in which the registers are read does not matter.
        Upon reset, these registers are cleared with pseudo-random data.
      '''
      count: "NumRegsData",
      cname: "MSG_OUT",
      swaccess: "ro",
      hwaccess: "hrw",
      hwext:    "true",
      hwre:     "true",
      fields: [
        { bits: "31:0", name: "msg_out", desc: "Output Data" }
      ],
      }
    },
    { multireg: {
      name: "TAG_OUT",
      desc: '''
        Output Tag Register.
        Holds the computed tag that is produced by the Ascon unit during an authenticated encryption/decryption.
        Each register has to be read at least once for encryption.
        For decryption the read is optional, but allows software to double check the result.
        The order in which the registers are read does not matter.
        Upon reset, these registers are cleared with pseudo-random data.
      '''
      count: "NumRegsTag",
      cname: "TAG_OUT_OUT",
      swaccess: "ro",
      hwaccess: "hrw",
      hwext:    "true",
      hwre:     "true",
      fields: [
        { bits: "31:0", name: "tag_out", desc: "Output Tag" }
      ],
      }
    },
    { name: "CTRL_SHADOWED",
      desc: '''
        Control Register.
        Can only be updated when the Ascon unit is idle.
        If the Ascon unit is non-idle, writes to this register are ignored.
        This register is shadowed, meaning two subsequent write operations are required to change its content.
        If the two write operations try to set a different value, a recoverable alert is triggered (See Status Register).
        A read operation clears the internal phase tracking:
        The next write operation is always considered a first write operation of an update sequence.
        Any write operation to this register will clear the status tracking required for automatic mode (See !!CTRL_AUX_SHADOWED.manual_start_trigger).
        A write to the Control Register is considered the start of a new message.
        Hence, software needs to provide a new Nonce and input data afterwards.
      '''
      swaccess: "rw",
      hwaccess: "hro",
      hwext:    "false"
      hwqe:     "false"
      shadowed: "true"
      fields: [
        { bits: "2:0",
          name: "OPERATION",
          desc:  '''
            Specifies which operation ascon should perform.
            There are:
            Enc, Dec, XOF (not implemented yet)
            They are one-hot encoded
          '''
          enum: [
            { value: "1",
              name: "ASCON_ENC",
              desc: '''
                3'b001: Encryption.
                Invalid input values are mapped to this.
              '''
            },
            { value: "2",
              name: "ASCON_DEC",
              desc: '''
                3'b010: Decryption.
              '''
            },
            { value: "4",
              name: "ASCON_XOF",
              desc: '''
                3'b100: XOF.
                This mode is currently not supported and treated as an invalid input, that is mapped to ASCON_ENC.
              '''
            },
          ]
        }
        { bits: "4:3",
          name: "ASCON_VARIANT",
          desc: '''
            Specifies which variant of Ascon is used.
            It can be either Ascon-128 (2'b01) or Ascon-128a (2'b10).
            They only differ in the input block size and the number of permutations per round.
            The size of the key, nonce, tag is 128 bits for both variants.
            This field is only relevant for encryption or decryption.
            It is ignored for Ascon-XOF.
          '''
          enum: [
            { value: "1",
              name: "ASCON_128",
              desc: '''
                Ascon-128 is the primary choice.
                In this mode, the rate and thus the input block size is 64 bit.
                There are 6 rounds of permutation between different inputs.
              '''
            },
            { value: "2",
              name: "ASCON_128a",
              desc: '''
                Ascon-128a is the secondary choice.
                In this mode, the rate and thus the input block size is 128 bit.
                There are 8 rounds of permutation between different inputs.
              '''
            },
          ]
        }
        { bits: "5",
          name: "SIDELOAD_KEY",
          desc:  '''
            Controls whether the Ascon unit uses the key provided by the key manager via key sideload interface (1)
            or the key provided by software via Initial Key Registers KEY_SHARE1 and KEY_SHARE_0 (0).
          '''
        }
        { bits: "6",
          name: "MASKED_AD_INPUT",
          desc:  '''
            Controls whether the associated data input is provided in shares (1) or not (0).
            If the input is provided in shares all registers of both shares must be written for each input block.
            If set to 0, the write operation tracking of Share 1 is disabled.
            Software should set Share 1 to all zeros before the first block of associated data is written to Share 0.
            It does not need to be rewritten for each block.
            Once all registers of Share 0 have been written, Ascon starts to process the data depending on the !!CTRL_AUX_SHADOWED.manual_start_trigger.
          '''
        }
        { bits: "7",
          name: "MASKED_MSG_INPUT",
          desc:  '''
            Controls whether the message input is provided in shares (1) or not (0).
            If the input is provided in shares all registers of both shares must be written for each input block.
            If set to 0, the write operation tracking of Share 1 is disabled.
            Software should set Share 1 to all zeros before the first block of the message is written to Share 0.
            It does not need to be rewritten for each block.
            Once all registers of Share 0 have been written, Ascon starts to process the data depending on the !!CTRL_AUX_SHADOWED.manual_start_trigger.
          '''
        }
        { bits: "11:8",
          name: "NO_MSG",
          resval: "0x6",
          desc:  '''
            This field is mubi4 encoded.
            There is no (4'h6) message (plaintext/ciphertext) to be processed.
            There is (4'h9) a message.
          '''
        }
        { bits: "15:12",
          name: "NO_AD",
          resval: "0x9",
          desc:  '''
            This field is mubi4 encoded.
            There is no (4'h6) associated data to be processed.
            There is (4'h9) associated data.
          '''
        }
      ]
    },
    { name: "CTRL_AUX_SHADOWED",
      desc: '''
        Auxiliary Control Register.
        This register is shadowed, meaning two subsequent write operations are required to change its content.
        If the two write operations try to set a different value, a recoverable alert is triggered (See Status Register).
        A read operation clears the internal phase tracking: The next write operation is always considered a first write operation of an update sequence.
        These configuration options are only used for special cases during development and can therefore be locked to the default values.
        For normal operation these options should all be set to zero.
      '''
      swaccess: "rw",
      hwaccess: "hro",
      hwext:    "false"
      hwqe:     "false"
      shadowed: "true"
      regwen:   "CTRL_AUX_REGWEN"
      fields: [
        { bits: "0",
          name: "MANUAL_START_TRIGGER",
          desc:  '''
            Control whether the Ascon unit should automatically start to encrypt/decrypt when it receives new input data (0)
            or wait for a separate trigger signal before starting (1) (see Trigger Register).
            Default: 0
          '''
        }
        { bits: "1",
          name: "FORCE_DATA_OVERWRITE",
          desc:  '''
            Control whether the Ascon unit is stalled during the last
            encryption/decryption cycle if the previous output data has not yet been read (0)
            or finishes the operation and overwrites the previous output data (1).
            Default: 0
          '''
        }
      ]
    },
    { name: "CTRL_AUX_REGWEN",
      desc: '''
        Lock bit for Auxiliary Control Register.
        '''
      swaccess: "rw0c",
      hwaccess: "none",
      fields: [
      {   bits: "0",
          desc: '''
            Auxiliary Control Register configuration enable bit.
            If this is cleared to 0, the Auxiliary Control Register cannot be written until the next reset.
            ''',
          resval: 1,
        }
      ]
    },
    { name: "BLOCK_CTRL_SHADOWED",
      desc: '''
        Block Control Register.
        This register is shadowed, meaning two subsequent write operations are required to change its content.
        If the two write operations try to set a different value, a recoverable alert is triggered (See Status Register).
        A read operation clears the internal phase tracking:
        The next write operation is always considered a first write operation of an update sequence.
        This register has to be written at least for each first and last block of message, associated data.
        Intermediate blocks are expected to be of full block size.
        If there's only one block of data, all three fields: valid_bytes, data_type_last and data_type_start must be set.
      '''
      swaccess: "rw",
      hwaccess: "hro",
      hwext:    "false"
      hwqe:     "false"
      shadowed: "true"
      fields: [
        { bits: "11:0",
          name: "DATA_TYPE_START",
          desc:  '''
            Specifies which input the Ascon unit shall process next.
            There are:
            PT_IN, CT_IN, AD_IN.
            They are internally mubi4 encoded.
            Only one type is allowed to be true at the same time.
            NONE sets all mubi4 encoded values to False.
          '''
        }
        { bits: "23:12",
          name: "DATA_TYPE_LAST",
          desc:  '''
            Specifies that the next read from an input is the last of its kind.
            There are:
            PT_IN, CT_IN, AD_IN.
            They are internally mubi4 encoded.
            Only one type is allowed to be true at the same time.
            NONE sets all mubi4 values to false.
          '''
        }
        { bits: "28:24",
          name: "VALID_BYTES",
          resval: "31",
          desc:  '''
            Indicates the number of valid bytes [0 to 16] bytes.
            Default: 16 bytes for ASCON 128a
            Default:   8 bytes for ASCON 128
          '''
        }
      ]
    },
    { name: "TRIGGER",
      desc: '''
      Trigger Register.
      Each bit is individually cleared to zero when executing the corresponding trigger.
      While executing any of the triggered operations, the Ascon unit will set the IDLE bit in the Status Register to zero.
      The processor must check the Status Register before triggering further actions.
      For example, writes to Initial Key and nonce Registers are ignored while the Ascon unit is busy.
      Writes to the Message and associated data Registers are not ignored but the data will be cleared if a WIPE operation is pending.
      '''
      swaccess: "rw",
      hwaccess: "hrw",
      fields: [
        { bits: "0",
          name: "START",
          desc:  '''
            If CTRL_SHADOWED_AUX.manual_start_trigger = 1: Keep Ascon unit paused (0) or trigger the authenticated encryption/decryption of one data block (1).
            If CTRL_SHADOWED_AUX.manual_start_trigger = 0: writes to this bit are ignored.
          '''
        }
        { bits: "1",
          name: "WIPE",
          desc:  '''
            Performs a secure wipe of sensitive data.
          '''
        }
      ]
    },
    { name: "STATUS",
      desc: "Status Register",
      swaccess: "ro",
      hwaccess: "hwo",
      fields: [
        { bits: "0",
          name: "IDLE",
          desc:  '''
            The Ascon unit is idle (0) or busy (1).
          '''
        }
        { bits: "1",
          name: "STALL",
          desc:  '''
            The Ascon unit is not stalled (0) or stalled (1) because there is previous
            output data that must be read by the processor before the Ascon unit can
            overwrite this data.
          '''
        }
        { bits: "2",
          name: "WAIT_EDN",
          desc:  '''
            The Ascon unit is waiting for new entropy.
          '''
        }
        { bits: "3",
          name: "ASCON_ERROR",
          desc:  '''
            An error due to a misconfiguration has happened.
            The user should read out the error register for more information
          '''
        }
        { bits: "4",
          name: "ALERT_RECOV_CTRL_UPDATE_ERR",
          resval: "0",
          desc:  '''
            An update error has not occurred (0) or has occurred (1) in the shadowed Control Register.
            Ascon operation needs to be restarted by re-writing the Control Register.
          '''
        }
        { bits: "5",
          name: "ALERT_RECOV_CTRL_AUX_UPDATE_ERR",
          resval: "0",
          desc:  '''
            An update error has not occurred (0) or has occurred (1) in the shadowed Auxiliary Control Register.
            The register has to be rewritten.
          '''
        }
        { bits: "6",
          name: "ALERT_RECOV_BLOCK_CTRL_UPDATE_ERR",
          resval: "0",
          desc:  '''
            An update error has not occurred (0) or has occurred (1) in the shadowed block Control Register.
            The register has to be rewritten.
          '''
        }
        { bits: "7",
          name: "ALERT_FATAL_FAULT",
          resval: "0",
          desc:  '''
            No fatal fault has occurred inside the Asconunit (0).
            A fatal fault has occurred and the Ascon unit needs to be reset (1).
            Examples for fatal faults include
            i) storage errors in the Control Register,
            ii) if any internal FSM enters an invalid state,
            iii) if any sparsely encoded signal takes on an invalid value,
            iv) errors in the internal round counter,
            v) escalations triggered by the life cycle controller, and
            vi) fatal integrity failures on the TL-UL bus.
          '''
        }
      ]
    },
    { name: "OUTPUT_VALID",
      desc: '''
        Output Valid Register
        This register specifies which output register contains valid data and should be read next.
        It also contains the status information whether the TAG comparison was valid or not.
      ''',
      swaccess: "ro",
      hwaccess: "hwo",
      fields: [
        { bits: "2:0",
          name: "DATA_TYPE",
          desc:  '''
            Specifies which output type/register is valid.
            There are:
            PT_OUT, CT_OUT, TAG_OUT, NONE
          '''
        }
        { bits: "4:3",
          name: "TAG_COMPARISON_VALID",
          desc:  '''
            Indicates if the tag could be successfully compared 2'b01, or not 2'b10
            2'b00 indicates that the tag hasn't been calculated, yet
            2'b11 is invalid.
          '''
        }
      ]
    },
    { name: "FSM_STATE",
      desc: '''
        Main FSM State register.
        These registers can be used for debugging the internal state of ASCON's FSM.
        The read can be blocked with the FSM_STATE_REGREN register
      '''
      swaccess: "ro",
      hwaccess: "hrw",
      hwext:    "true"
      hwqe:     "true"
      fields: [
        { bits: "31:0",
          name: "MAIN_FSM",
          desc:  '''
            These fields are directly mapped to the ASCON's main state registers.
          '''
        }
      ]
    },
    { name: "FSM_STATE_REGREN",
      desc: '''
        Lock bit for Auxiliary Control Register.
        '''
      swaccess: "rw0c",
      hwaccess: "none",
      fields: [
      {   bits: "0",
          desc: '''
            FSM_STATE register configuration enable bit.
            If this is cleared to 0, the FSM_STATE register returns all zeros on any read until the next reset.
            ''',
          resval: 1,
        }
      ]
    },
    { name: "ERROR",
      desc: '''
        Error Register.
        Error register for errors caused by user's misconfiguration.
        To clear the error, a wipe must be triggered.
      '''
      swaccess: "ro",
      hwaccess: "hwo",
      hwext:    "false"
      fields: [
        { bits: "0",
          name: "NO_KEY",
          desc:  '''
            No Key was provided
        '''
        },
        { bits: "1",
          name: "NO_NONCE",
          desc:  '''
            No Nonce was provided
        '''
        },
        { bits: "2",
          name: "WRONG_ORDER",
          desc:  '''
            The ordering of associated data and message was wrong.
        '''
        }
        { bits: "3",
          name: "FLAG_INPUT_MISSMATCH",
          desc:  '''
            A flag for an empty input was set, but a non empty input was provided.
        '''
        }
      ]
    },
  ],
}
