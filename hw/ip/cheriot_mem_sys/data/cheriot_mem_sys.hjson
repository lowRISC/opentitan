// Copyright lowRISC contributors (OpenTitan project).
// Licensed under the Apache License, Version 2.0, see LICENSE for details.
// SPDX-License-Identifier: Apache-2.0
{
  name:               "cheriot_mem_sys",
  human_name:         "CHERIoT Memory Subsystem",
  one_line_desc:      "CHERIoT-aware memory subsystem",
  one_paragraph_desc: '''
    The CHERIoT memory subsystem sits between a CHERIoT-capable Ibex core and the system
    interconnect.  It enforces capability tag semantics on data-memory accesses, transparently
    remapping capability accesses and revocation bitmap reads into a dedicated meta SRAM.
    By default, its logic runs in lockstep with a delayed second copy.
  '''
  // Unique comportable IP identifier defined under KNOWN_CIP_IDS in the regtool.
  cip_id:             "48",
  design_spec:        "../doc",
  dv_doc:             "../doc/dv",
  hw_checklist:       "../doc/checklist",
  version:            "1.0.0",
  life_stage:         "L1",
  design_stage:       "D1",
  verification_stage: "V0",

  clocking: [
    {clock: "clk_i", reset: "rst_ni", primary: true}
  ],

  bus_interfaces: [
    {protocol: "tlul", direction: "device", name: "regs"},
    {protocol: "tlul", direction: "device", name: "revbm"},
    {protocol: "tlul", direction: "host", name: "cored"},
    {protocol: "tlul", direction: "host", name: "tbre"}
  ],

  scan: "true",       // Enable `scanmode_i` port
  scan_reset: "true", // Enable `scan_rst_ni` port

  ///////////////////////////
  // Interrupts and Alerts //
  ///////////////////////////

  interrupt_list: [
    { name: "tbre_done",
      desc: "Raised when the revocation engine has resolved every capability of a sweep.",
    }
  ],

  alert_list: [
    { name: "fatal_fault",
      desc: '''
            This fatal alert is triggered when the two copies of the lockstep disagree, when an
            integrity fault is detected, when a core data request carries an invalid encoding of
            the capability tag, when the meta SRAM path returns a device error, when the revocation
            engine reports a fault, when a capability store to the NVM is partial, when a request
            breaks the core's capability store sequence, when a shadow register has a storage
            error, or when the enables of the two lockstep copies differ or one is not valid while
            their comparison is on.
            '''
    }
    { name: "recov_ctrl_update_err",
      desc: '''
            This recoverable alert is triggered when the two writes of an update to a shadow
            register disagree. The register keeps its previous value.
            '''
    }
  ],

  ////////////////
  // Parameters //
  ////////////////

  param_list: [

    /////////////////////
    // Address map     //
    /////////////////////

    { name:    "MainSramBaseAddr",
      desc:    "Base address of the main SRAM region (inclusive).",
      type:    "logic [top_pkg::TL_AW-1:0]",
      default: "32'h1000_0000",
      local:   "false",
      expose:  "true"
    },
    { name:    "MainSramTopAddr",
      desc:    "Top address of the main SRAM region (exclusive).",
      type:    "logic [top_pkg::TL_AW-1:0]",
      default: "32'h1003_0000",
      local:   "false",
      expose:  "true"
    },
    { name:    "NvmBaseAddr",
      desc:    "Base address of the NVM region (inclusive).",
      type:    "logic [top_pkg::TL_AW-1:0]",
      default: "32'h3000_0000",
      local:   "false",
      expose:  "true"
    },
    { name:    "NvmTopAddr",
      desc:    "Top address of the NVM region (exclusive).",
      type:    "logic [top_pkg::TL_AW-1:0]",
      default: "32'h3020_0000",
      local:   "false",
      expose:  "true"
    },
    { name:    "MetaSramBaseAddr",
      desc:    '''
               Base address of the CHERIoT meta SRAM region.
               ''',
      type:    "logic [top_pkg::TL_AW-1:0]",
      default: "32'h1100_0000",
      local:   "false",
      expose:  "true"
    },
    // Overridden by topgen with the size of the `revbm` memory window.
    { name:    "MemSizeRevbm",
      desc:    '''
               Size of the revocation bitmap window (in bytes).
               Must match the size derived from the main SRAM region; this is checked by an
               assertion in the RTL.
               ''',
      type:    "int",
      default: "3072"
    },

    /////////////////////
    // Lockstep        //
    /////////////////////

    { name:    "SecLockstep",
      desc:    '''
               Run a second copy of the logic in lockstep with the main copy (LOGIC.SHADOW).
               ''',
      type:    "bit",
      default: "1'b1",
      local:   "false",
      expose:  "true"
    },
    { name:    "LockstepOffset",
      desc:    "Cycles the second copy of the logic runs behind the main copy, from 1 to 3.",
      type:    "int unsigned",
      default: "1",
      local:   "false",
      expose:  "true"
    },

    /////////////////////
    // Register widths //
    /////////////////////

    { name:    "TbreNumCapsW",
      desc:    '''
               Width of TBRE_NUM_CAPS_SHADOWED. A sweep reads two words per capability, and that
               word count fits the TL-UL address width.
               ''',
      type:    "int unsigned",
      default: "31",
      local:   "true"
    },
    { name:    "TbreEpochW",
      desc:    "Width of TBRE_EPOCH.count, the sweep count above the active bit.",
      type:    "int unsigned",
      default: "31",
      local:   "true"
    },
  ],

  //////////////
  // Features //
  //////////////

  features: [
    { name: "CHERIOT_MEM_SYS.TAG_SPLIT",
      desc: '''
        A data access from the core is split into the data access towards the interconnect and a
        capability tag access towards the meta SRAM. Their responses are joined so that data and
        tag are returned together.
      '''
    },
    { name: "CHERIOT_MEM_SYS.TAG_READ",
      desc: '''
        On a hinted capability load, the tag bit of the addressed capability is looked up in the
        meta SRAM and returned.
      '''
    },
    { name: "CHERIOT_MEM_SYS.TAG_WRITE_RMW",
      desc: '''
        Because tags are stored at bit granularity, a write performs a read-modify-write on the
        addressed meta SRAM word.
      '''
    },
    { name: "CHERIOT_MEM_SYS.TAG_CLEAR_ON_DATA_WRITE",
      desc: '''
        Any non-capability write clears the tag bit of the addressed location, so that data stores
        cannot modify a valid capability.
      '''
    },
    { name: "CHERIOT_MEM_SYS.NVM_CAP_STORE",
      desc: '''
        A store of a tagged capability to the read-only NVM does not write data. It sets the tag of
        the capability only if the NVM already holds the stored capability. Any other store of a
        tagged capability to the NVM is answered with an error and leaves the tag unchanged.
      '''
    },
    { name: "CHERIOT_MEM_SYS.REVOCATION_BITMAP",
      desc: '''
        The revocation bitmap is exposed as a memory window on the `revbm` device interface and is
        read by the core's TRVK filter through the `corerevbm` port.
      '''
    },
    { name: "CHERIOT_MEM_SYS.ACCESS_CHECK",
      desc: '''
        Every meta SRAM access is checked against the region and the operations permitted for its
        originating port.
      '''
    },
    { name: "CHERIOT_MEM_SYS.MODE_GATING",
      desc: '''
        In ePMP mode the entire meta SRAM is inaccessible through all four ports of the
        subsystem. No tag lookups are issued.
      '''
    },
    { name: "CHERIOT_MEM_SYS.TBRE_SWEEP",
      desc: '''
        The background revocation engine sweeps a range of capabilities in the main SRAM or the NVM
        region and clears the tag of every tagged, non-sealing capability whose base has its
        revocation bit set, without modifying memory data.
      '''
    },
    { name: "CHERIOT_MEM_SYS.TBRE_CORE_WRITE_SNOOP",
      desc: '''
        A capability the core writes while the revocation engine resolves it keeps the tag the
        core wrote.
      '''
    },
    { name: "CHERIOT_MEM_SYS.TBRE_STATUS",
      desc: '''
        The revocation engine reports a sweep in progress, flags ignored starts and errors during a
        sweep until software clears them, raises an interrupt when a sweep completes, and keeps an
        epoch, odd while a sweep runs, that counts the sweeps that ended without an error.
      '''
    },
    { name: "CHERIOT_MEM_SYS.FATAL_ALERT",
      desc: '''
        The subsystem raises the fatal_fault alert on a mismatch between the two lockstep copies, in
        their outputs or in their mode enables, an integrity fault, a shadow register storage error,
        an invalid encoding of the capability tag of a core request, a meta SRAM device error, a
        fault the revocation engine reports, a partial capability store to the NVM, or a request
        that breaks the core's capability store sequence.
      '''
    },
  ],

  /////////////////////////////
  // Intermodule Connections //
  /////////////////////////////

  inter_signal_list: [
    // CHERIoT mode enable
    { struct:  "mubi4",
      type:    "uni",
      name:    "cheriot_ena",
      act:     "rcv",
      package: "prim_mubi_pkg",
      default: "prim_mubi_pkg::MuBi4False",
      desc:    "CHERIoT mode enable."
    },
    { struct:  "mubi4",
      type:    "uni",
      name:    "cheriot_ena_shadow",
      act:     "rcv",
      package: "prim_mubi_pkg",
      default: "prim_mubi_pkg::MuBi4False",
      desc:    "CHERIoT mode enable of the second lockstep copy, one cycle after cheriot_ena."
    },
    { struct:  "mubi4",
      type:    "uni",
      name:    "cheriot_ena_cmp",
      act:     "rcv",
      package: "prim_mubi_pkg",
      default: "prim_mubi_pkg::MuBi4True",
      desc:    "Any value except MuBi4False compares the enables of the two lockstep copies."
    },
    // Data TL-UL interface from the core
    { struct:  "tl",
      type:    "req_rsp",
      name:    "cored_tl_d",
      act:     "rsp",
      package: "tlul_pkg",
      desc:    "Data port from the core."
    },
    // Capability tag sideband - request direction (from core to subsystem)
    { struct:  "mubi4",
      type:    "uni",
      name:    "cored_tag_h2d",
      act:     "rcv",
      package: "prim_mubi_pkg",
      default: "prim_mubi_pkg::MuBi4False",
      desc:    "CHERIoT capability tag carried with the A-channel of cored_tl_d."
    },
    // Capability tag sideband - response direction (from subsystem to core)
    { struct:  "mubi4",
      type:    "uni",
      name:    "cored_tag_d2h",
      act:     "req",
      package: "prim_mubi_pkg",
      default: "prim_mubi_pkg::MuBi4False",
      desc:    "Capability tag returned on the D-channel of cored_tl_d."
    },
    // TRVK revocation bitmap TL-UL host port
    { struct:  "tl",
      type:    "req_rsp",
      name:    "corerevbm_tl",
      act:     "rsp",
      package: "tlul_pkg",
      desc:    "TRVK (tag revocation) revocation bitmap port from the core."
    },
    // Meta SRAM host TL-UL port (to external sram_ctrl RAM interface)
    { struct:  "tl",
      type:    "req_rsp",
      name:    "meta_sram_tl",
      act:     "req",
      package: "tlul_pkg",
      desc:    "Host TL-UL port to the external meta SRAM controller's RAM interface."
    },
  ],

  /////////////////////
  // Countermeasures //
  /////////////////////

  countermeasures: [
    { name: "BUS.INTEGRITY",
      desc: '''
        End-to-end bus integrity between the Ibex lockstep and the storage cells.
        Relies on LOGIC.SHADOW.
      '''
    },
    { name: "LOGIC.SHADOW",
      desc: '''
        The CHERIoT memory subsystem, including the background revocation engine, is
        instantiated in lockstep: with the SecLockstep parameter set (the default), a second copy
        of its logic runs LockstepOffset cycles behind the main copy. A mismatch between the
        outputs of the two copies, or a fatal error in either copy, raises the fatal_fault alert.
        This also covers the pointers of the subsystem's FIFOs, which therefore are not
        redundantly encoded (CTR.REDUN). The registers, the interrupt and the alert senders are
        not duplicated, so the register values are common to both lockstep copies:
        TBRE.CONFIG.SHADOW protects the stored sweep configuration, and each lockstep copy
        captures it when a sweep starts. With SecLockstep set to 0, there is no second copy and
        the FIFO pointers are unprotected.
      '''
    },
    { name: "TBRE.CONFIG.SHADOW",
      desc: '''
        The sweep configuration registers of the revocation engine are shadowed.
      '''
    },
    { name: "MEM.SW_NOACCESS",
      desc: '''
        The capability tag store is not memory mapped.
      '''
    },
    { name: "INTERSIG.MUBI",
      desc: '''
        The CHERIoT mode enables and the compare enable are multi-bit encoded.
      '''
    },
    { name: "CHERIOT_ENABLE.CTRL.REDUN",
      desc: '''
        With SecLockstep set, the two lockstep copies have separate CHERIoT mode enables, raised one
        cycle apart by the mode switch in rv_core_ibex. While cheriot_ena_cmp_i is not MuBi4False,
        both enables must be valid and equal, else the fatal_fault alert is raised. This covers the
        enables from the mode switch's enable flops in rv_core_ibex to the subsystem's receivers at
        all times except during the staging steps of a switch to CHERIoT mode, in which the mode
        switch turns the compare enable off; the mode switch's state and checks are covered by its
        countermeasures in rv_core_ibex.
      '''
    },
    { name: "CORED_TAG.INTERSIG.MUBI",
      desc: '''
        The capability tags of the core data port are multi-bit encoded between Ibex and the
        CHERIoT memory subsystem. Only MuBi4True reads as tagged, and a core data request with an
        invalid encoding raises the fatal_fault alert.
      '''
    },
  ],

  ///////////
  // Memory //
  ///////////

  memory: {
    revbm: {}
  }

  ///////////////
  // Registers //
  ///////////////

  regwidth: "32",
  registers: {
    regs: [
      { name: "RECOV_ERR_CODE",
        desc: "Recoverable error code.",
        swaccess: "rw1c",
        hwaccess: "hwo",
        fields: [
          { bits: "0",
            name: "shadow_update_err",
            desc: '''
              The second write of a shadow register update did not match the first. Stays set until
              software writes 1 to it.
            ''',
            resval: "0"
          }
        ]
      },
      { name: "FATAL_ERR_CODE",
        desc: "Fatal error code.",
        swaccess: "ro",
        hwaccess: "hwo",
        fields: [
          { bits: "0",
            name: "reg_intg",
            desc: '''
              A request to the register interface failed its integrity check. Stays set until reset.
            ''',
            resval: "0"
          },
          { bits: "1",
            name: "shadow_storage_err",
            desc: '''
              The two stored copies of a shadow register differed. Stays set until reset.
            ''',
            resval: "0"
          }
        ]
      },
      { name: "TBRE_REGWEN",
        desc: "Write enable for the revocation engine registers.",
        swaccess: "ro",
        hwaccess: "hwo",
        hwext: "true",
        fields: [
          { bits: "0",
            name: "en",
            desc: '''
              Low while the revocation engine is active, locking !!TBRE_BASE_ADDR_SHADOWED,
              !!TBRE_NUM_CAPS_SHADOWED and !!TBRE_START. !!TBRE_STATUS.busy follows the same state
              one cycle later.
            ''',
            resval: "1"
          }
        ]
      },
      { name: "TBRE_BASE_ADDR_SHADOWED",
        desc: "Address of the first capability the revocation engine sweeps.",
        regwen: "TBRE_REGWEN",
        swaccess: "rw",
        hwaccess: "hro",
        shadowed: "true",
        update_err_alert: "recov_ctrl_update_err",
        storage_err_alert: "fatal_fault",
        fields: [
          { bits: "31:3",
            name: "addr",
            desc: '''
              Bits 31:3 of the address. The sweep starts at a capability boundary; bits 2:0 read as
              zero. The address must lie in a tagged region, the main SRAM or the NVM; the sweep
              stops at the top of that region.
            ''',
            resval: "0"
          }
        ]
      },
      { name: "TBRE_NUM_CAPS_SHADOWED",
        desc: "Number of capabilities the revocation engine sweeps, each of them two 32-bit words.",
        regwen: "TBRE_REGWEN",
        swaccess: "rw",
        hwaccess: "hro",
        shadowed: "true",
        update_err_alert: "recov_ctrl_update_err",
        storage_err_alert: "fatal_fault",
        fields: [
          { bits: "TbreNumCapsW-1:0",
            name: "num",
            desc: '''
              Number of capabilities. A sweep reaching past the top of its tagged region ends at its
              top; the register keeps the value written.
            ''',
            resval: "0"
          }
        ]
      },
      { name: "TBRE_START",
        desc: '''
          Starts a sweep over the capabilities !!TBRE_BASE_ADDR_SHADOWED and
          !!TBRE_NUM_CAPS_SHADOWED describe. !!TBRE_STATUS.busy reflects the sweep in progress. A
          start outside CHERIoT mode, with !!TBRE_NUM_CAPS_SHADOWED zero, or with
          !!TBRE_BASE_ADDR_SHADOWED outside the tagged regions, is ignored and sets
          !!TBRE_STATUS.start_err.
        ''',
        regwen: "TBRE_REGWEN",
        swaccess: "wo",
        hwaccess: "hro",
        hwext: "true",
        hwqe: "true",
        // Writing it starts a sweep over whatever the other registers hold.
        tags: ["excl:CsrAllTests:CsrExclWrite"],
        fields: [
          { bits: "0",
            name: "start",
            desc: "Write 1 to start a sweep.",
            resval: "0"
          }
        ]
      },
      { name: "TBRE_STATUS",
        desc: "Status of the revocation engine.",
        swaccess: "ro",
        hwaccess: "hwo",
        fields: [
          { bits: "0",
            name: "busy",
            desc: '''
              The revocation engine is sweeping; it is low once every capability of the sweep is
              resolved.
            ''',
            resval: "0"
          },
          { bits: "8",
            name: "start_err",
            swaccess: "rw1c",
            desc: '''
              A start was ignored because the subsystem was not in CHERIoT mode,
              !!TBRE_NUM_CAPS_SHADOWED was zero or !!TBRE_BASE_ADDR_SHADOWED was outside the tagged
              regions. Stays set until software writes 1 to it.
            ''',
            resval: "0"
          },
          { bits: "9",
            name: "sweep_err",
            swaccess: "rw1c",
            desc: '''
              A response to the revocation engine was an error, failed its integrity check or was
              malformed, or the RMW filter reported a fault, during a sweep. Except for an error
              response to a read of the swept memory, the fatal_fault alert is raised as well. Stays
              set until software writes 1 to it.
            ''',
            resval: "0"
          }
        ]
      }
      { name: "TBRE_EPOCH",
        desc: '''
          Sweep epoch, twice the number of sweeps that ended without an error, plus one while the
          revocation engine is active. It is odd from the cycle a start is taken, when !!TBRE_REGWEN
          falls, until the engine is inactive again, and even otherwise. A sweep that ends with an
          error (see !!TBRE_STATUS.sweep_err) is not counted, so the epoch returns to the even value
          it had before that start, and no software waiting for a completed sweep proceeds on it.
        ''',
        swaccess: "ro",
        hwaccess: "hwo",
        hwext: "true",
        fields: [
          { bits: "0",
            name: "active",
            desc: "The revocation engine is active; the inverse of !!TBRE_REGWEN.",
            resval: "0"
          },
          { bits: "TbreEpochW:1",
            name: "count",
            desc: '''
              Sweeps that ended without an error, modulo 2^31; a sweep counts in the cycle
              !!TBRE_EPOCH.active clears.
            ''',
            resval: "0"
          }
        ]
      }
    ]
  }
}
