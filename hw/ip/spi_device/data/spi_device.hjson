// Copyright lowRISC contributors (OpenTitan project).
// Licensed under the Apache License, Version 2.0, see LICENSE for details.
// SPDX-License-Identifier: Apache-2.0
{
  name:               "spi_device",
  human_name:         "SPI Device",
  one_line_desc:      "Serial peripheral interface supporting different device modes, suitable for bulk-load of data into and out of the chip",
  one_paragraph_desc: '''
  SPI Device is a configurable, versatile hardware block that implements three modes (SPI Flash emulation mode, SPI passthrough mode, and TPM over SPI mode) to support a variety of different applications.
  TPM over SPI operates in compliance with TPM PC Client Platform, unloading this protocol from a software solution.
  SPI Flash emulation mode supports many JEDEC standard commands such as Read Status, Read JEDEC ID, Read SFDP, EN4B/EX4B, WREN/WRDI, and multiple other read commands, allowing OpenTitan to provide, for example, verified boot firmware to other external devices.
  '''
  // Unique comportable IP identifier defined under KNOWN_CIP_IDS in the regtool.
  cip_id:             "26",
  design_spec:        "../doc",
  dv_doc:             "../doc/dv",
  hw_checklist:       "../doc/checklist",
  sw_checklist:       "/sw/device/lib/dif/dif_spi_device",
  revisions: [
    { version:            "2.0.0",
      life_stage:         "L1",
      design_stage:       "D2S",
      verification_stage: "V2S",
      dif_stage:          "S1",
      commit_id:          "abcdce404a54f2f4f925e9f396b8f69c8cb491e0",
    }
    { version:            "2.1.0",
      life_stage:         "L1",
      design_stage:       "D2S",
      verification_stage: "V2S",
      dif_stage:          "S1",
    }
  ]
  clocking: [
    {clock: "clk_i", reset: "rst_ni", primary: true},
    // The scan_rst_ni port isn't listed here because it's generated by the
    // "scan_reset: true" below.
    {clock: "scan_clk_i"}
  ]
  bus_interfaces: [
    { protocol: "tlul", direction: "device", racl_support: true }
  ],
  available_input_list: [
    { name: "sck",     desc: "SPI Clock" },
    { name: "csb",     desc: "Chip Select#" },
    { name: "tpm_csb", desc: "TPM Chip Select#"}
  ],
  available_output_list: [
  ],
  available_inout_list: [
    { name: "sd",
      width: "4",
      desc: "SPI IO, IO2/IO3 has multi-purpose (/WP, /HOLD)"
    }
  ]
  interrupt_list: [
    { name: "upload_cmdfifo_not_empty"
      desc: "Upload Command FIFO is not empty."
    }
    { name: "upload_payload_not_empty"
      desc: '''Upload payload is not empty.

        The event occurs after a SPI transaction is completed.
        '''
    }
    { name: "upload_payload_overflow"
      desc: '''Upload payload overflow event.

        When a SPI Host system issues a command with payload more than 256B,
        this event is reported. When it happens, SW should read the last
        written payload index CSR to figure out the starting address of the
        last 256B.
        '''
      type: "event"
    }
    { name: "readbuf_watermark"
      desc: '''Read Buffer Threshold event.

        The host system accesses greater than or equal to the threshold of a
        buffer.
        '''
    }
    { name: "readbuf_flip"
      desc: '''Read buffer flipped event.

        The host system accesses other side of buffer.
        '''
      type: "event"
    }
    { name: "tpm_header_not_empty"
      desc: "TPM Header(Command/Address) buffer available"
      type: "status"
    }
    { name: "tpm_rdfifo_cmd_end"
      desc: '''TPM RdFIFO command ended.

        The TPM Read command targeting the RdFIFO ended.
        Check TPM_STATUS.rdfifo_aborted to see if the transaction completed.
        '''
      type: "event"
    }
    { name: "tpm_rdfifo_drop"
      desc: '''TPM RdFIFO data dropped.

        Data was dropped from the RdFIFO.
        Data was written while a read command was not active, and it was not accepted.
        This can occur when the host aborts a read command.
        '''
      type: "event"
    }
  ],
  alert_list: [
    { name: "fatal_fault",
      desc: '''
      This fatal alert is triggered when a fatal TL-UL bus integrity fault is detected.
      '''
    }
  ],
  scan: "true",       // Enable `scanmode_i` port
  scan_reset: "true", // Enable `scan_rst_ni` port
  param_list: [
    { name:    "SramType"
      desc:    "Sram Entries. Word size is 32bit width."
      type:    "spi_device_pkg::sram_type_e"
      default: "spi_device_pkg::DefaultSramType"
      local:   "false"
      expose:  "true"
    }
    { name:    "SramDepth"
      desc:    "Sram Entries. Word size is 32bit width."
      type:    "int unsigned"
      default: "1024"
      local:   "true"
    }
    { name:    "SramEgressDepth"
      desc:    "Sram Egress Entries. Word size is 32bit width."
      type:    "int unsigned"
      default: "848"
      local:   "true"
    }
    { name:    "SramIngressDepth"
      desc:    "Sram Ingress Entries. Word size is 32bit width."
      type:    "int unsigned"
      default: "112"
      local:   "true"
    }
    { name:    "SramReadBufferOffset"
      desc:    "Sram eFlash read buffer offset (from egress buffer start). Word size is 32bit width."
      type:    "int unsigned"
      default: "0"
      local:   "true"
    }
    { name:    "SramReadBufferDepth"
      desc:    "Sram eFlash read buffer entries. Word size is 32bit width."
      type:    "int unsigned"
      default: "512"
      local:   "true"
    }
    { name:    "SramMailboxOffset"
      desc:    "Sram mailbox buffer offset (from egress buffer start). Word size is 32bit width."
      type:    "int unsigned"
      default: "512"
      local:   "true"
    }
    { name:    "SramMailboxDepth"
      desc:    "Sram mailbox entries. Word size is 32bit width."
      type:    "int unsigned"
      default: "256"
      local:   "true"
    }
    { name:    "SramSfdpOffset"
      desc:    "Sram SFDP buffer offset (from egress buffer start). Word size is 32bit width."
      type:    "int unsigned"
      default: "768"
      local:   "true"
    }
    { name:    "SramSfdpDepth"
      desc:    "Sram SFDP entries. Word size is 32bit width."
      type:    "int unsigned"
      default: "64"
      local:   "true"
    }
    { name:    "SramTpmRdFifoOffset"
      desc:    "Sram TPM RdFIFO offset (from egress buffer start). Word size is 32bit width."
      type:    "int unsigned"
      default: "832"
      local:   "true"
    }
    { name:    "SramTpmRdFifoDepth"
      desc:    "Sram TPM RdFIFO entries. Word size is 32bit width."
      type:    "int unsigned"
      default: "16"
      local:   "true"
    }
    { name:    "SramPayloadOffset"
      desc:    "Sram payload FIFO offset (from ingress buffer start). Word size is 32bit width."
      type:    "int unsigned"
      default: "0"
      local:   "true"
    }
    { name:    "SramPayloadDepth"
      desc:    "Sram payload FIFO entries. Word size is 32bit width."
      type:    "int unsigned"
      default: "64"
      local:   "true"
    }
    { name:    "SramCmdFifoOffset"
      desc:    "Sram command FIFO offset (from ingress buffer start). Word size is 32bit width."
      type:    "int unsigned"
      default: "64"
      local:   "true"
    }
    { name:    "SramCmdFifoDepth"
      desc:    "Sram command FIFO entries. Word size is 32bit width."
      type:    "int unsigned"
      default: "16"
      local:   "true"
    }
    { name:    "SramAddrFifoOffset"
      desc:    "Sram address FIFO offset (from ingress buffer start). Word size is 32bit width."
      type:    "int unsigned"
      default: "80"
      local:   "true"
    }
    { name:    "SramAddrFifoDepth"
      desc:    "Sram address FIFO entries. Word size is 32bit width."
      type:    "int unsigned"
      default: "16"
      local:   "true"
    }
    { name:    "SramTpmWrFifoOffset"
      desc:    "Sram TPM Write FIFO offset (from ingress buffer start). Word size is 32bit width."
      type:    "int unsigned"
      default: "96"
      local:   "true"
    }
    { name:    "SramTpmWrFifoDepth"
      desc:    "Sram TPM Write FIFO entries. Word size is 32bit width."
      type:    "int unsigned"
      default: "16"
      local:   "true"
    }
    { name:    "NumCmdInfo"
      desc:    "Define the number of Command Info slots."
      type:    "int unsigned"
      default: "24"
      local:   "true"
    }
    { name:    "NumLocality"
      desc:    "The number of locality TPM module supports."
      type:    "int unsigned"
      default: "5"
      local:   "true"
    } // p: NumLocality
    { name:    "TpmRdFifoPtrW"
      desc:    "TPM RdFIFO Pointer Bit Width. clog2(Depth(16+1))"
      type:    "int unsigned"
      default: "5"
      local:   "true"
    } // p: TpmRdFifoPtrW
    { name:    "TpmRdFifoWidth"
      desc:    "TPM Read FIFO Data Width. (TpmRdFifoWidth/8) shall be power of two"
      type:    "int unsigned"
      default: "32"
    } // p: TpmRdFifoWidth
  ],
  inter_signal_list: [
    { name:    "ram_cfg_sys2spi",
      package: "prim_ram_1r1w_pkg",
      struct:  "ram_1r1w_cfg",
      act:     "rsp",
      type:    "req_rsp"
    }
    { name:    "ram_cfg_spi2sys",
      package: "prim_ram_1r1w_pkg",
      struct:  "ram_1r1w_cfg",
      act:     "rsp",
      type:    "req_rsp"
    }
    { struct:  "passthrough",
      package: "spi_device_pkg"
      type:    "req_rsp"
      name:    "passthrough",
      act:     "req"
    }
    { struct:  "logic"
      package: ""
      type:    "uni"
      name:    "mbist_en"
      act:     "rcv"
    }
    { struct:  "logic"
      package: ""
      type:    "uni"
      name:    "sck_monitor"
      act:     "req"
    }
    { struct:  "racl_policy_vec",
      type:    "uni",
      name:    "racl_policies",
      act:     "rcv",
      package: "top_racl_pkg",
      desc:    '''
        Incoming RACL policy vector from a racl_ctrl instance.
        The policy selection vector (parameter) selects the policy for each register.
      '''
    }
    { struct:  "racl_error_log",
      type:    "uni",
      name:    "racl_error",
      act:     "req",
      width:   "1"
      package: "top_racl_pkg",
      desc:    '''
        RACL error log information of this module.
      '''
    }
  ],
  features: [
    {
      name: "SPI_DEVICE.MODE.FLASH_EMULATION",
      desc: '''Emulates the behaviour of a Serial Flash device when connected to an upstream SPI Host.
            In this mode, the block recognizes SPI Flash commands and can respond entirely in HW.
            '''
    }
    {
      name: "SPI_DEVICE.MODE.PASSTHROUGH",
      desc: '''The block acts as a proxy to a downstream external SPI Flash, with optional inline filtering and monitoring.

            In this mode, an upstream SPI Host communicates with a downstream external SPI Flash.
            Traffic received by this block is forwarded to a SPI_HOST instance, which then
            relays the traffic onto the downstream external SPI flash.
            Runtime-configurable filtering, payload interception, payload substitution and monitoring operations
            on the passthrough traffic are provided by the block.
            '''
    }
    {
      name: "SPI_DEVICE.MODE.TPM",
      desc: '''Acts as a device-side endpoint in compliance with TPM PC Client Platform over SPI.
            '''
    }
    {
      name: "SPI_DEVICE.HW.LANES",
      desc: '''1,2 or 4 lane operation is supported by the block.
            '''
    }
    {
      name: "SPI_DEVICE.HW.SERDES_ORDERING",
      desc: '''The block allows serialization ordering control for SDI/SDO that can be controlled at runtime.
            CSR.CFG.rx_order : "RX bit order on SDI. 0 for MSB first, 1 for LSB first."
            CSR.CFG.tx_order : "TX bit order on SDO. 0 for MSB first, 1 for LSB first.
            '''
    }
    {
      name: "SPI_DEVICE.HW.CSB_STATUS",
      desc: '''CSR.STATUS fields show the current status of the two CSb signals (.csb/.tpm_csb).
            '''
    }
    {
      name: "SPI_DEVICE.MODE.FLASH_EMULATION.COMMANDS",
      desc: '''Device should respond to all specified standard SPI Flash Commands.
            '''
    }
    {
      name: "SPI_DEVICE.HW.FLASH_EMULATION_BLOCKS",
      desc: '''Hardware contains a number of submodules for handling certain commands.
            cmdparse, READ, EN4B/EX4B, SFDP, JEDEC, status/busy

            - CSR.FLASH_STATUS contains SW-writable bits that define the response to a Read Status Register command.
            - Some fields in CSR.FLASH_STATUS may also be modified by HW.
              - WRDI/WREN commands modify the CSR.FLASH_STATUS.status.WEL bit.
              - CSR.FLASH_STATUS.status.BUSY may be modified by HW depending on command upload configuration of the
                CSR.CMDINFO[x].busy field.

            - CSR.JEDEC_CC and CSR.JEDEC_ID provide data for the JEDEC Read command.
            - The SFDP section of DPSRAM provides data for the Read SFDP command.
            '''
    }
    {
      name: "SPI_DEVICE.MODE.FLASH_EMULATION.READ_COMMAND_PROCESSOR",
      desc: '''SPI Flash Read commands are provided with data from a DPSRAM section with a ping-pong buffering scheme, or a fixed mailbox region.

            - The readptr crossing the buffer boundary creates a readbuf_flip interrupt.
            - The readptr crossing the offset CSR.READ_THRESHOLD within a buffer creates a readbuf_watermark interrupt.
            '''
    }
    {
      name: "SPI_DEVICE.MODE.FLASH_EMULATION.DUMMY_CYCLE",
      desc: '''Insertion of dummy cycles between SPI Flash opcode and data.
            '''
    }
    {
      name: "SPI_DEVICE.MODE.FLASH_EMULATION.WRITE_ENABLE_DISABLE",
      desc: '''The block supports SPI Flash WREN/WRDI commands from the external host.
            '''
    }
    {
      name: "SPI_DEVICE.HW.LAST_READ_ADDR",
      desc: '''The register CSR.LAST_READ_ADDR shows the last address a SPI Flash Read command accessed before CSb de-assertion.
            MODES : FLASH_EMULATION,PASSTHROUGH
            '''
    }
    {
      name: "SPI_DEVICE.HW.CMDINFOS",
      desc: '''Registers that can contain custom opcode + data for responding to SPI Flash Commands.
            '''
    }
    {
      name: "SPI_DEVICE.HW.COMMAND_UPLOAD",
      desc: '''HW can store the received command into the command/address FIFOs and payload buffer.
            MODES:FLASH_EMULATION,PASSTHROUGH

            - A received SPI Flash command can conditionally be written to the command,address and payload FIFOs.
            - SW can access data about the uploaded commands via CSR.UPLOAD_STATUS and CSR.UPLOAD_STATUS2.
            - SW can read CSR.UPLOAD_CMDFIFO to access the command FIFO.
            - SW can read CSR.UPLOAD_ADDRFIFO to access the address FIFO.
            - The payload FIFO can be read by accessing the DPSRAM window.
            '''
    }
    {
      name: "SPI_DEVICE.HW.3B4B_ADDRESSING",
      desc: '''Support CSR control of 3B/4B operation, plus host control with EN4B/EX4B
            '''
    }
    {
      name: "SPI_DEVICE.MODE.PASSTHROUGH.CMD_FILTER",
      desc: '''Passthrough logic filters the command based on the 256-bit value of the "CMD_FILTER_0" CSR.
            '''
    }
    {
      name: "SPI_DEVICE.MODE.PASSTHROUGH.ADDRESS_MANIPULATION",
      desc: '''By configuring ADDR_SWAP_MASK and ADDR_SWAP_DATA CSRs, certain address bits of Flash Commands can be overwritten on passthrough.
            '''
    }
    {
      name: "SPI_DEVICE.MODE.PASSTHROUGH.STATUS_MANIPULATION",
      desc: '''By configuring PAYLOAD_SWAP_MASK and PAYLOAD_SWAP_DATA CSRs, certain bits of the first 4 payload bytes may be overwritten on passthrough.
            '''
    }
    {
      name: "SPI_DEVICE.MODE.PASSTHROUGH.OUTPUT_ENABLE_CONTROL",
      desc: '''Passthrough module can control the output enable signals on both host and downstream side.
            '''
    }
    {
      name: "SPI_DEVICE.MODE.PASSTHROUGH.INTERCEPT_EN",
      desc: '''Allow the block to reply to SPI Flash commands, taking precedence over the data returned by the passthrough device.
            '''
    }
    {
      name: "SPI_DEVICE.MODE.PASSTHROUGH.MAILBOX",
      desc: '''Return data from the 1kB Mailbox read/write buffer if the command address falls in the range (MAILBOX_ADDR:MAILBOX_ADDR+1kB).
            '''
    }
    {
      name: "SPI_DEVICE.MODE.TPM.RETURN-BY-HW_REGS",
      desc: '''Block can auto-respond to a TPM host when the address falls within a configured range using the RETURN-BY-HW registers.
            '''
    }
    {
      name: "SPI_DEVICE.MODE.TPM.AUTO_WAIT",
      desc: '''If the address of a command does not fall into a pre-configured range, the block automatically returns a WAIT on the bus.
            '''
    }
    {
      name: "SPI_DEVICE.MODE.TPM.READ_FIFO_MODE",
      desc: '''If not activating the RETURN-BY-HW mode, the block responds to a Host TPM commands when the TPM_READ_FIFO has data >= requested transfer size.
            '''
    }
    {
      name: "SPI_DEVICE.MODE.TPM.CAPABILITY",
      desc: '''TPM-mode can advertise the capabilities it supports to the upstream Host by setting CSR.TPM_CAP.
            '''
    }
  ],
  countermeasures: [
    { name: "BUS.INTEGRITY",
      desc: "End-to-end bus integrity scheme."
    }
  ]
  regwidth: "32",
  registers: [
    { name: "CONTROL",
      desc: "Control register.",
      swaccess: "rw",
      hwaccess: "hro",
      fields: [
        { bits: "0",
          name: "FLASH_STATUS_FIFO_CLR",
          swaccess: "rw1s",
          hwaccess: "hrw",
          desc: '''Set to clear the flash status FIFO.

            When set to 1, resets the flash status FIFO used for synchronizing changes from firmware.
            The reset should only be used when the upstream SPI host is known to be inactive.
            This function is intended to allow restoring initial values when the upstream SPI host is reset.

            This CSR automatically resets to 0.
            '''
          resval: "0",
          tags: [// This CSR only briefly pulses to anything other than 0.
                 "excl:CsrNonInitTests:CsrExclWrite"]
        },
        { bits: "1",
          name: "FLASH_READ_BUFFER_CLR",
          swaccess: "rw1s",
          hwaccess: "hrw",
          desc: '''Set to clear the read buffer state.

            When set to 1, resets the flash read buffer state that tracks the host read address.
            The reset should only be used when the upstream SPI host is known to be inactive.
            This function is intended to allow restoring initial values when the upstream SPI host is reset.

            This CSR automatically resets to 0.
            '''
          resval: "0",
          tags: [// This CSR only briefly pulses to anything other than 0.
                 "excl:CsrNonInitTests:CsrExclWrite"]
        },
        { bits: "5:4",
          name: "MODE",
          desc: "SPI Device flash operation mode.",
          resval: "1"
          enum: [
            { value: "0",
              name: "disabled",
              desc: '''SPI Flash operations disabled.

                SPI Device operations are disabled, and all transactions are ignored.
                Note that SPI TPM operation is controlled by !!TPM_CFG.
                '''
            },
            { value: "1"
              name: "flashmode"
              desc: '''SPI Flash Emulation mode.

                In Flash mode, the SPI Device IP accepts SPI Flash commands and
                processes internally, then returns data for the read commands.
                HW processes the Status, JEDEC ID, SFDP commands.

                The current version does not support Dual/Quad IO and QPI
                commands.
                '''
            }
            { value: "2"
              name: "passthrough"
              desc: '''
                In Passthrough mode, SPI Device IP forwards the incoming SPI
                flash traffics to the attached downstream flash device. HW may
                processes commands internally and returns data.

                SW may configure the device to drop inadmissible commands.
                '''
            }
          ]
          tags: [// Changing modes randomly can result in unknown values being
                 // passed between spi_dev/host due to passthrough
                 "excl:CsrNonInitTests:CsrExclWrite"]
        },
      ]
    },
    { name: "CFG",
      desc: "Configuration Register.",
      swaccess: "rw",
      hwaccess: "hro",
      fields: [
        { bits: "2",
          name: "tx_order",
          desc: "TX bit order on SDO. 0 for MSB to LSB, 1 for LSB to MSB.",
          resval: "0",
        },
        { bits: "3",
          name: "rx_order",
          desc: "RX bit order on SDI. Module stores bitstream from MSB to LSB if value is 0.",
          resval: "0",
        },
        { bits: "24"
          name: "mailbox_en"
          desc: '''Mailbox enable.

            If 1, in the flash and passthrough mode, the IP checks the incoming
            address and return from the internal Mailbox buffer if the address
            falls into the MAILBOX range
            (MAILBOX_ADDR:MAILBOX_ADDR+MAILBOX_SIZE)}.
            '''
        } // f: mailbox_en
      ]
    },
    { name: "STATUS",
      desc: "SPI Device status register.",
      swaccess: "ro",
      hwaccess: "hwo",
      hwext: "true",
      fields: [
        { bits: "5"
          name: "csb"
          desc: "Direct input of CSb signal."
          resval: "1"
          tags: [
            // the value of csb is determined by the
            // value on the pins, hence it cannot be predicted.
            "excl:CsrAllTests:CsrExclCheck"
          ]
        }
        { bits: "6"
          name: "tpm_csb"
          desc: "Direct input of the TPM CSb signal."
          resval: "1"
          tags: [
            // the value of tpm_csb is determined by the
            // value on the pins, hence it cannot be predicted.
            "excl:CsrAllTests:CsrExclCheck"
          ]
        }
      ]
    },
    //=========================================================================
    // Flash & Passthrough CSRs
    { name: "INTERCEPT_EN"
      desc: '''Intercept Passthrough datapath.

        '''
      swaccess: "rw"
      hwaccess: "hro"
      fields: [
        { bits: "0"
          name: "status"
          desc: "If set, Read Status commands are processed internally."
        } // f: status
        { bits: "1"
          name: "jedec"
          desc: "If set, Read JEDEC ID commands are processed internally."
        } // f: jedec
        { bits: "2"
          name: "sfdp"
          desc: "If set, Read SFDP commands are processed internally."
        } // f: sfdp
        { bits: "3"
          name: "mbx"
          desc: "If set, Read commands reading from the mailbox region are processed internally."
        } // f: mailbox
      ]
    } // R: INTERCEPT_EN
    { name: "ADDR_MODE"
      desc: '''Flash Address Mode configuration.

        This register shows the current address mode and pending changes to it.
        It is updated by the HW when the command opcode phase completes.
        '''
      swaccess: "ro"
      hwaccess: "hwo"
      hwext: true
      tags: [
        // SW is not able to read back the ADDR_MODE register right after write.
        // The pending field changes whenever the CSR is written, regardless of the value.
        // So, the CSR is excluded from most automated CSR tests.
        "excl:CsrNonInitTests:CsrExclWrite"
      ]
      fields: [
        { bits: "0"
          name: "addr_4b_en"
          swaccess: "rw"
          hwaccess: "hrw" // Updated by EN4B/EX4B
          hwqe: true
          desc: '''4B Address Mode enable.

            This field determines whether 4B address mode is currently enabled.

            If set, the size of addresses for SPI commands with !!CMD_INFO.addr_mode == `AddrCfg` is 4B, otherwise it is 3B. This field is modified by HW on receiving the EN4B and EX4B commands - see !!CMD_INFO_EN4B and !!CMD_INFO_EX4B.

            Read SFDP commands (!!CMD_INFO slot 4) are unaffected by the configuration of !!ADDR_MODE.addr_4b_en, and a 3-byte
            address will always be expected following the command opcode.

            If a SW-initiated change is still pending the sync to the SPI domain, this bit will reflect the value to be sent.
            Otherwise, this field will reflect the current value observed in the SPI domain. See !!ADDR_MODE.pending.

            It is expected that software only sets this field during early configuration. Modifying this field mid-operation is
            almost always a protocol violation.
            '''
        },
        { bits: "31"
          name: "pending"
          desc: '''SW-initiated change is pending.

            This bit is set whenever the current value of !!ADDR_MODE.addr_4b_en is not yet in sync with the SPI domain.
            If an EN4B or EX4B command arrives next, the current value in !!ADDR_MODE.addr_4b_en will be ignored
            and the command will take priority.
            '''
        }
      ]
    } // R: ADDR_MODE
    { name: "LAST_READ_ADDR"
      desc: '''Last Read Address.

        This register shows the last address accessed by the host system.
        It is updated by the HW when CSb is de-asserted.
        '''
      swaccess: "ro"
      hwaccess: "hwo"
      hwext: true
      fields: [
        { bits: "31:0"
          name: "addr"
          desc: "Last address."
        }
      ]
    } // R: LAST_READ_ADDR
    { name: "FLASH_STATUS"
      desc: '''SPI Flash Status register.

        This register emulates the SPI Flash Status 1-3 registers.
        Bits [7:0], [15:8], and [23:16] contain the values for the Status 1, 2, and 3 registers respectively.
        It is the responsibility of SW to keep the value of this register up-to-date.

        When software writes a value here, it is delivered to a staging async FIFO, where it waits for the SPI side to commit it.
        Any updates require at least 8 SPI clocks before they commit on the SPI side, which is the source-of-truth.
        After committing on the SPI side, the CSRs will eventually update with the latest value.
      '''
      swaccess: "rw"
      hwaccess: "hrw"
      hwext: true
      hwqe: true
      tags: [
        // SW is not able to read back the STATUS register right after write.
        // The read back value is the committed value, and pending values need at least 8 SPI clocks to commit.
        // So excluded from CSR automation test.
        "excl:CsrNonInitTests:CsrExclWrite"
      ]
      fields: [
        { bits: "0"
          name: "busy"
          desc: '''The BUSY signal.

            This bit is set by HW when a matched command with !!CMD_INFO.upload and !!CMD_INFO.busy set is received.
            SW may only clear this bit.
            SW should read back the register to confirm the bit is cleared.

            Note that the observable state of the BUSY bit updates every 8 SPI clocks.
            This enables continuous polling of the BUSY bit.
            However, the passthrough gate (for passthrough mode) only updates when CSb is de-asserted, not on SPI clocks.
          '''
          swaccess: "rw0c"
          hwaccess: "hrw"
        } // f: busy
        { bits: "1"
          name: "wel"
          desc: '''The Write Enable Latch signal.

            This bit is set or unset by HW when a WREN or WRDI command is received - see !!CMD_INFO_WREN and !!CMD_INFO_WRDI.
            SW may only clear this bit.
            SW should read back the register to confirm the bit is cleared.
          '''
          swaccess: "rw0c"
          hwaccess: "hrw"
        } // f: busy
        { bits: "23:2"
          name: "status"
          desc: '''Rest of the status register.
            HW reads will return the value stored.
            This field is managed by SW and the bits have no special significance to the HW - SW should use the bits according to the specific flash chip emulated.
            The following is a normative list of common uses for each bit:

            | Bit | Common Usage |
            |:---:|:-------------|
            |  2  | `BP0`        |
            |  3  | `BP1`        |
            |  4  | `BP2`        |
            |  5  | `TB`         |
            |  6  | `SEC`        |
            |  7  | `SRP0`       |
            |  8  | `SRP1`       |
            |  9  | `QE`         |
            | 11  | `LB1`        |
            | 12  | `LB2`        |
            | 13  | `LB3`        |
            | 14  | `CMP`        |
            | 15  | `SUS`        |
            | 18  | `WPS`        |
            | 21  | `DRV0`       |
            | 22  | `DRV1`       |
            | 23  | `HOLD /RST`  |
            '''
        } // f: status
      ]
    } // R: FLASH_STATUS
    {
      name: "JEDEC_CC"
      desc: '''JEDEC Continuation Code configuration register.

        Read JEDEC ID must return the continuation code if the manufacturer ID
        is not shown in the first page of JEDEC table. This register controls
        the Continuation Code.
        '''
      swaccess: "rw"
      hwaccess: "hro"
      fields: [
        { bits: "15:8"
          name: "num_cc"
          desc: "The number of Continuation Code repeats."
        } // f: num_cc
        { bits: "7:0"
          name: "cc"
          desc: "Continuation Code byte value, typically `0x7F`."
          resval: "0x7F"
        } // f: cc
      ]
    } // R: JEDEC_CC
    {
      name: "JEDEC_ID"
      desc: '''JEDEC ID register.
        '''
      swaccess: "rw"
      hwaccess:  "hro"
      fields: [
        { bits: "23:16"
          name: "mf"
          desc: "Manufacturer ID"
        } // f: manufacturer id
        { bits: "15:0"
          name: "id"
          desc: "Device ID"
        } // f: device id
      ]
    } // R: JEDEC_ID
    { name: "READ_THRESHOLD"
      desc: '''Read Buffer threshold register.

        '''
      swaccess: "rw"
      hwaccess: "hro"
      fields: [
        { bits: "9:0"
          name: "threshold"
          desc: '''Threshold value in bytes.
            If zero, the threshold is disabled. Otherwise, when the host
            accesses bytes beyond or equal to this threshold in the Read Buffer,
            a readbuf_watermark interrupt is generated.
            '''
        } // f: threshold
      ]
    } // R: READ_THRESHOLD
    { name: "MAILBOX_ADDR"
      desc: '''Mailbox Base address register.

        The mailbox size is fixed. In this version of IP, the size is 1kB.
        The least-significant 10 bits of the Mailbox address are tied to 0.
        '''
      swaccess: "rw"
      hwaccess: "hro"
      fields: [
        { bits: "31:0"
          name: "addr"
          desc: "Mailbox Address. The least-significant 10 bits are tied to 0."
        } // f: addr
      ]
    } // R: MAILBOX_ADDR
    { name: "UPLOAD_STATUS"
      desc: '''Upload Module status register.
        '''
      swaccess: "ro"
      hwaccess: "hwo"
      fields: [
        { bits: "4:0"
          name: "cmdfifo_depth"
          desc: "Number of entries in the Command Upload FIFO."
        } // f: cmdfifo_depth
        { bits: "7"
          name: "cmdfifo_notempty"
          desc: "If set, the Command Upload FIFO is not empty."
        } // f: cmdfifo_notempty
        { bits: "12:8"
          name: "addrfifo_depth"
          desc: "Number of entries in the Address Upload FIFO."
        } // f: addrfifo_depth
        { bits: "15"
          name: "addrfifo_notempty"
          desc: "If set, the Address Upload FIFO is not empty."
        } // f: addrfifo_notempty
      ]
    } // R: UPLOAD_STATUS
    { name: "UPLOAD_STATUS2"
      desc: '''Upload Module second status register.

        This register contains information related to the uploaded command payload.
        !!UPLOAD_STATUS2.payload_depth indicates the length of the command payload, in bytes.

        !!UPLOAD_STATUS2.payload_start_idx indicates the start position of this command payload within
        the Payload Buffer, in bytes. This field is usually 0, unless more than 256 bytes of payload
        have been issued.

        For example, if 258 bytes of payload are issued, !!UPLOAD_STATUS2.payload_depth will be 256
        (as the Payload Buffer only has capacity for 256 bytes), but !!UPLOAD_STATUS2.payload_start_idx will be 2.
        SW should read bytes 2-255 followed by bytes 0-1 to read the intact portion of the payload in the correct order.
        '''
      swaccess: "ro"
      hwaccess: "hwo"
      fields: [
        { bits: "8:0"
          name: "payload_depth"
          desc: '''Payload buffer depth.
            '''
        } // f: payload_depth
        { bits: "23:16"
          name: "payload_start_idx"
          desc: '''Payload start index.'''
        } // f: payload_start_idx
      ]
    } // R: UPLOAD_STATUS2
    { name: "UPLOAD_CMDFIFO"
      desc: '''Command FIFO Read Port.
        '''
      swaccess: "ro"
      hwaccess: "hrw"
      hwre:  "true"
      hwext: "true"
      fields: [
        { bits: "7:0"
          name: "data"
          desc: "Uploaded command's opcode."
        }
        { bits: "13"
          name: "busy"
          desc: "State of !!FLASH_STATUS.busy bit when the command was received."
        }
        { bits: "14"
          name: "wel"
          desc: "State of !!FLASH_STATUS.wel bit when the command was received."
        }
        { bits: "15"
          name: "addr4b_mode"
          desc: "State of !!ADDR_MODE.addr_4b_en when the command was received."
        }
      ]
    } // R: UPLOAD_CMDFIFO
    { name: "UPLOAD_ADDRFIFO"
      desc: '''Address FIFO Read Port.

        '''
      swaccess: "ro"
      hwaccess: "hrw"
      hwre:  "true"
      hwext: "true"
      fields: [
        { bits: "31:0"
          name: "data"
          desc: "read data"
        }
      ]
    } // R: UPLOAD_ADDRFIFO
    { multireg: {
        cname: "SPI_DEVICE"
        name:  "CMD_FILTER"
        desc:  '''Passthrough mode: Command Filter.

          If the bit corresponding to a received command's opcode is set,
          the command is filtered (CSb is de-asserted) and does not reach the
          downstream flash device.
          '''
        count: "256"
        swaccess: "rw"
        hwaccess: "hro"
        compact: true
        fields: [
          { bits: "0"
            name: "filter"
            resval: "0"
            desc: "If set, this command will be filtered."
          }
        ]
      }
    }
    { name: "ADDR_SWAP_MASK"
      desc: '''Passthrough mode: Address Swap Mask.

        This register is used in the SPI passthrough mode. If any of bits in
        this register is set, the corresponding address bit in the SPI Read
        commands is replaced with the data from !!ADDR_SWAP_DATA.

        If the command's address size is 3B, the upper byte (bits [31:24]) are not used.
        '''
      swaccess: "rw"
      hwaccess: "hro"
      fields: [
        { bits:   "31:0"
          resval: "0",
          name:   "mask"
          desc:   '''For any bit set in this register, the value of the corresponding bit
            in !!ADDR_SWAP_DATA is used for that address bit.'''
        }
      ]
    }
    { name: "ADDR_SWAP_DATA"
      desc: '''Passthrough mode: Address Swap Data.
        '''
      swaccess: "rw"
      hwaccess: "hro"
      fields: [
        { bits:   "31:0"
          resval: "0"
          name:   "data"
          desc:   '''For any bit set in !!ADDR_SWAP_MASK, the value of the corresponding bit
            in this register is used for that address bit.'''
        }
      ]
    }
    { name: "PAYLOAD_SWAP_MASK"
      desc: '''Passthrough mode: Payload Swap Mask.

        Passthrough mode payload swapping can set or unset any bits in the first 4 bytes of
        the payload written to the downstream flash.
        For any bit set in !!PAYLOAD_SWAP_MASK, the passthrough logic instead uses the value of
        the corresponding bit in !!PAYLOAD_SWAP_DATA for that payload bit.

        For example, if !!PAYLOAD_SWAP_MASK is set to `0x0000000f` and !!PAYLOAD_SWAP_DATA is set to `0x00000005`,
        bits 0 and 2 of the first payload byte are set to 1, bits 1 and 3 of the first payload byte are set to 0,
        and the rest of the payload is unchanged.

        Payload swapping is applied least-significant bit first - bits [7:0] are applied to the first received byte,
        followed by bits [15:8], and so on.
        '''
      swaccess: "rw"
      hwaccess: "hro"
      fields: [
        { bits:   "31:0"
          resval: "0"
          name:   "mask"
          desc:   '''For any bit set in this register, the value of the corresponding bit
            in !!PAYLOAD_SWAP_DATA is used for that payload bit.'''
        } // f: mask
      ]
    } // R: PAYLOAD_SWAP_MASK
    { name: "PAYLOAD_SWAP_DATA"
      desc: '''Passthrough mode: Payload Swap Data.

        Passthrough mode payload swapping can set or unset any bits in the first 4 bytes of
        the payload written to the downstream flash.
        For any bit set in !!PAYLOAD_SWAP_MASK, the passthrough logic instead uses the value of
        the corresponding bit in !!PAYLOAD_SWAP_DATA for that payload bit.

        For example, if !!PAYLOAD_SWAP_MASK is set to `0x0000000f` and !!PAYLOAD_SWAP_DATA is set to `0x00000005`,
        bits 0 and 2 of the first payload byte are set to 1, bits 1 and 3 of the first payload byte are set to 0,
        and the rest of the payload is unchanged.

        Payload swapping is applied least-significant bit first - bits [7:0] are applied to the first received byte,
        followed by bits [15:8], and so on.
        '''
      swaccess: "rw"
      hwaccess: "hro"
      fields: [
        { bits:   "31:0"
          resval: "0"
          name:   "data"
          desc:   '''For any bit set in !!PAYLOAD_SWAP_MASK, the value of the corresponding bit
            in this register is used for that payload bit.'''
        } // f: data
      ]
    } // R: PAYLOAD_SWAP_DATA
    { multireg: {
        cname: "SPI_DEVICE"
        name:  "CMD_INFO"
        desc: '''Command Information register.

            For !!CMD_INFO slots assigned to HW functionality, HW ignores the setting of some configurable fields and the
            behaviour is hard-coded.

            Read SFDP commands (!!CMD_INFO slot 4) are unaffected by the configuration of !!ADDR_MODE.addr_4b_en, and a 3-byte
            address will always be expected following the command opcode.
          '''
        count: "NumCmdInfo"
        swaccess: "rw"
        hwaccess: "hro"
        fields: [
          { bits:   "7:0"
            resval: "0"
            name:   "opcode"
            desc: '''Command opcode
              '''
          } // f: opcode
          { bits:   "9:8"
            resval: "0"
            name:   "addr_mode"
            desc:   "The size of the command's address field."
            enum: [
              { value: "0"
                name:  "AddrDisabled"
                desc:  "The command has no address field."
              } // e: AddrDisabled
              { value: "1"
                name:  "AddrCfg"
                desc:  "The size of the command's address field is determined by !!ADDR_MODE.addr_4b_en."
              } // e: AddrCfg
              { value: "2"
                name:  "Addr3B"
                desc:  "The size of the command's address field is always 3B."
              } // e: Addr3B
              { value: "3"
                name:  "Addr4B"
                desc:  "The size of the command's address field is always 4B."
              } // e: Addr4B
            ]
          } // f: addr_mode
          { bits:   "10"
            resval: "0"
            name:   "addr_swap_en"
            desc:   '''Passthrough mode: Swap the command's address bytes.

              If set, passthrough logic swaps the bytes of the command's address field,
              according to the values !!ADDR_SWAP_MASK and !!ADDR_SWAP_DATA.

              This bit is only effective if !!CMD_INFO.addr_mode is not `AddrDisabled`.
              '''
          } // f: addr_swap_en
          { bits:   "11"
            name:   "mbyte_en"
            desc:   '''If set, the command has an MByte field following the
              address field. This should be set for Dual IO and Quad IO commands.

              This field is currently unimplemented.
              '''
          } // f: mbyte_en
          { bits:   "14:12"
            resval: "7"
            name:   "dummy_size"
            desc:   '''The number of dummy cycles between this command's
              opcode/address phase and the payload phase, minus one.

              This field has no effect if !!CMD_INFO.dummy_en is unset.
              '''
          } // f: dummy_size
          { bits:   "15"
            name:   "dummy_en"
            desc:   '''If set, the command has at least one dummy cycle between
              the opcode/address phase and the payload phase.
              '''
          } // f: dummy_en
          { bits:   "19:16"
            name:   "payload_en"
            desc:   '''Payload Enable per SPI lane.

              Represents which SPI lines this command's payload is transmitted over, if any.
              Each bit corresponds to one of the SPI IO lines.

              For example, if the command is a Single IO command with a payload that is written to
              the SPI Device IP or downstream flash, this should be set to `0b0001` for the MOSI
              line (IO[0]). If the payload is read from the SPI Device IP or downstream flash, this
              should be set to `0b0010` for the MISO line (IO[1]). !!CMD_INFO.payload_dir should
              also be configured with the appropriate payload direction.
              '''
          } // f: payload_en
          { bits: "20"
            name: "payload_dir"
            desc: '''The direction of the command's payload phase.

              If set, the payload is from the downstream flash or SPI Device IP to the host, otherwise it is from the host to the downstream flash or SPI Device IP.

              This field has no effect if the command has no payload phase - see also !!CMD_INFO.payload_en.
              '''
            enum: [
              { value: "0"
                name:  "PayloadIn"
                desc:  "From host to the downstream flash device."
              } // e: PayloadIn
              { value: "1"
                name:  "PayloadOut"
                desc:  "From the downstream flash device to the host."
              } // e: PayloadOut
            ]
          } // f: payload_dir
          { bits: "21"
            name: "payload_swap_en"
            desc: '''Passthrough mode: Swap the first 4 bytes of the write payload.

              If set, passthrough logic swaps the first 4 bytes of the command's written payload,
              according to the values of !!PAYLOAD_SWAP_MASK and !!PAYLOAD_SWAP_DATA.

              Payload swapping only works with write payloads and in Single IO mode -
              !!CMD_INFO.payload_en must be `0b0001` and !!CMD_INFO.payload_dir must be `PayloadIn`.
              '''
          } // f: payload_swap_en
          { bits: "23:22"
            name: "read_pipeline_mode"
            desc: '''Add 2-stage pipeline to read payload.

              If `read_pipeline_mode` is not set to `zero_stages`, the read logic adds a 2-stage pipeline to the read data for this command.
              This read pipeline enables higher throughput for certain read commands in passthrough mode.

              `payload_dir` must be set to PayloadOut: `payload_pipeline_en` only works with read data.
              It may be used with any IO mode, but general host compatibility is likely limited to Quad Read.
              If this pipeline is used for passthrough, the internal SFDP should report 2 additional dummy cycles compared to the downstream flash.
              SFDP read commands should be processed internally, and `dummy_size` should still reflect the downstream device's dummy cycle count.
              '''
            enum: [
              { value: "0",
                name: "zero_stages",
                desc: '''Bypass the 2-stage read pipeline.

                  This mode is for ordinary SPI flash operation.
                  Passthrough read data flows combinatorially from input pads to output pads.
                  '''
              },
              { value: "1"
                name: "two_stages_half_cycle"
                desc: '''2-stage read pipeline with half-cycle sampling.

                  In this mode, the 2-stage read pipeline is enabled.
                  Read data appears 2 cycles later than the `zero_stages` option.
                  In addition, read data originating from the downstream flash is first sampled on the normal sampling edge for half-cycle sampling.
                  '''
              }
              { value: "2"
                name: "two_stages_full_cycle"
                desc: '''2-stage read pipeline with full-cycle sampling.

                  In this mode, the 2-stage read pipeline is enabled.
                  Read data appears 2 cycles later than the `zero_stages` option.
                  In addition, read data originating from the downstream flash is first sampled on the next launch edge.
                  In other words, the internal pipeline performs full-cycle sampling of the downstream flash's response.
                  '''
              }
            ]
          } // f: payload_pipeline_en
          { bits: "24"
            name: "upload"
            desc: '''If set, the command parser activates the upload submodule when this command is received
              and the command is uploaded.

              The command's opcode (!!CMD_INFO.opcode), as well as the state of the !!FLASH_STATUS.busy,
              !!FLASH_STATUS.wel, and !!ADDR_MODE.addr_4b_en bits at the time the command is received,
              are stored in the Command Upload FIFO, readable from !!UPLOAD_CMDFIFO.

              if !!CMD_INFO.addr_mode is not `AddrDisabled`, the command's address field is stored in the
              Address Upload FIFO, readable from !!UPLOAD_ADDRFIFO.

              The behaviour of !!CMD_INFO.upload with !!CMD_INFO.addr_mode == `AddrDisabled` is not defined.

              The command's payload is written to the Payload Buffer. See !!UPLOAD_STATUS and !!UPLOAD_STATUS2.

              The behaviour of !!CMD_INFO.upload with !!CMD_INFO.payload_dir is not defined.

              In Passthrough mode, uploaded commands are still delivered to the downstream flash device unless
              the bit corresponding to the opcode is set in !!CMD_FILTER.

              The behaviour of !!CMD_INFO.upload with !!CMD_INFO.addr_swap_en and !!CMD_INFO.payload_swap_en
              is not defined.

              In Passthrough mode, address and payload swapping (as controlled by !!CMD_INFO.addr_swap_en and
              !!CMD_INFO.payload_swap_en) are applied only to the data passed-through to the downstream flash,
              and not the uploaded address and payload. SW may manually apply address and payload swapping to see
              the values sent downstream using the same swap mask/data registers.
              '''
          } // f: upload
          { bits: "25"
            name: "busy"
            desc: '''If set, sets the !!FLASH_STATUS.busy bit when the command is received.
              This bit is only effective if the !!CMD_INFO.upload bit is set.
              '''
          } // f: busy
          { bits: "31"
            name: "valid"
            desc: '''If set, the command is active and can be matched on command receive.
              Otherwise, this command information entry is ignored.
            '''
          } // f: valid
        ]
      }
    }
    { name: "CMD_INFO_EN4B"
      swaccess: "rw"
      hwaccess: "hro"
      desc: '''EN4B command information register.

        This command is handled by HW in Flash and Passthrough modes.

        This command sets the !!ADDR_MODE.addr_4b_en bit.
        '''
      fields:  [
        { bits: "31"
          name: "valid"
          desc: '''If set, the command is active and can be matched on command receive.
            Otherwise, this command information entry is ignored.'''
        } // f: valid
        { bits: "7:0"
          name: "opcode"
          desc: "Vendor-specific opcode for EN4B, typically `0xb7`."
        } // f: opcode
      ]
    } // R: CMD_INFO_EN4B
    { name: "CMD_INFO_EX4B"
      swaccess: "rw"
      hwaccess: "hro"
      desc: '''EX4B command information register.

        This command is handled by HW in Flash and Passthrough modes.

        This command clears the !!ADDR_MODE.addr_4b_en bit.
        '''
      fields:  [
        { bits: "31"
          name: "valid"
          desc: '''If set, the command is active and can be matched on command receive.
            Otherwise, this command information entry is ignored.'''
        } // f: valid
        { bits: "7:0"
          name: "opcode"
          desc: "Vendor-specific opcode for EX4B, typically `0xe9`."
        } // f: opcode
      ]
    } // R: CMD_INFO_EX4B
    { name: "CMD_INFO_WREN"
      swaccess: "rw"
      hwaccess: "hro"
      desc: '''Write Enable (WREN) command information register.

        This command is handled by HW in Flash and Passthrough modes.

        This command sets the !!FLASH_STATUS.wel bit.
        '''
      fields: [
        { bits: "31"
          name: "valid"
          desc: '''If set, the command is active and can be matched on command receive.
            Otherwise, this command information entry is ignored.'''
        } // f: valid
        { bits: "7:0"
          name: "opcode"
          desc: "Vendor-specific opcode for WREN, typically `0x06`."
          // Leave default value 0 to be consistent
        } // f: opcode
      ]
    } // R: CMD_INFO_WREN
    { name: "CMD_INFO_WRDI"
      swaccess: "rw"
      hwaccess: "hro"
      desc: '''Write Disable (WRDI) command information register.

        This command is handled by HW in Flash and Passthrough modes.

        This command clears the !!FLASH_STATUS.wel bit.
        '''
      fields: [
        { bits: "31"
          name: "valid"
          desc: '''If set, the command is active and can be matched on command receive.
            Otherwise, this command information entry is ignored.'''
        } // f: valid
        { bits: "7:0"
          name: "opcode"
          desc: "Vendor-specific opcode for WRDI, typically `0x04`."
          // Leave default value 0 to be consistent
        } // f: opcode
      ]
    } // R: CMD_INFO_WRDI

    //===============================================================
    // TPM registers
    { skipto: "0x800"}
    { name: "TPM_CAP"
      desc: '''TPM HWIP Capability register.

        This register shows the features the current TPM HWIP supports.
        '''
      swaccess: "ro"
      hwaccess: "hwo"
      fields: [
        { bits: "7:0"
          name: "rev"
          desc: "Revision of the TPM submodule."
          resval: "0"
        } // f: rev
        { bits: "8"
          name: "locality"
          desc: '''If set, the TPM submodule supports 5 Localities, otherwise only one Locality is supported.'''
          resval: "1"
        } // f: locality
        { bits: "18:16"
          name: "max_wr_size"
          desc: '''The maximum write size in bytes the TPM submodule supports.
            The maximum write size is 2 to the power of the value in this field (between 4 and 64 byes).

            |   Value   | Maximum write size |
            |:---------:|:-------------------|
            |  `0b010`  |         4B         |
            |  `0b011`  |         8B         |
            |  `0b100`  |         16B        |
            |  `0b101`  |         32B        |
            |  `0b110`  |         64B        |

            All other values are reserved.

            It is recommended that SW does not advertise the TPM as supporting writes larger than `max_wr_size` to the Southbridge.
            '''
          resval: "6"
        } // f: max_wr_size
        { bits: "22:20"
          name: "max_rd_size"
          desc: '''The maximum read size in bytes the TPM submodule supports.
            The maximum read size is 2 to the power of the value in this field (between 4 and 64 byes).

            |   Value   | Maximum read size |
            |:---------:|:------------------|
            |  `0b010`  |        4B         |
            |  `0b011`  |        8B         |
            |  `0b100`  |        16B        |
            |  `0b101`  |        32B        |
            |  `0b110`  |        64B        |

            All other values are reserved.

            It is recommended that SW does not advertise the TPM as supporting reads larger than `max_rd_size` to the Southbridge.
            '''
          resval: "6"
        } // f: max_rd_size
      ]
    } // R: TPM_CAP
    { name: "TPM_CFG"
      desc: '''TPM Configuration register.
        '''
      swaccess: "rw"
      hwaccess: "hro"
      fields: [
        { bits: "0"
          name: "en"
          desc: "If set, the TPM submodule accepts the transactions over SPI."
          tags: [
          // Enabling TPM could cause an assertion error if CSb isn't disabled properly in chip-level
          "excl:CsrNonInitTests:CsrExclWrite"]
        } // f: en
        { bits: "1"
          name: "tpm_mode"
          desc: '''Configure the TPM mode. If set, the TPM is in CRB mode, otherwise it is FIFO mode.

            If this field is set by SW, the HW logic always pushes the
            command, address, and write data to buffers. The logic does not compare
            the incoming address to the list of managed-by-HW register
            addresses.

            The invalid locality check still runs based on the invalid_locality
            configuration.
            '''
        } // f: tpm_mode
        { bits: "2"
          name: "hw_reg_dis"
          desc: '''If unset, TPM submodule directly returns the return-by-HW registers for read requests.

            If set, TPM submodule uploads the TPM command regardless of the address, and the SW may return the value through the read FIFO.
            '''
        } // f: hw_reg_dis
        { bits: "3"
          name: "tpm_reg_chk_dis"
          desc: '''If set, the logic does not compare the upper 8 bits of the
            received address with the `TpmAddr` constant, `0xD4`.

            If unset, the HW uploads the command, address, and write
            payload to the buffers in case of address that is not `0xD4_XXXX`.
            '''
        } // f: tpm_reg_chk_dis
        { bits: "4"
          name: "invalid_locality"
          desc: '''If set, TPM submodule returns the invalid data (`0xFF`) for the
            out of the max Locality request.
            If the request is a write request, The HW will still upload the command and address. In that case, SW still needs to precess the incoming invalid command.

            If unset, TPM submodule uploads the TPM command and address. The SW may
            write `0xFF` to the read FIFO.

            Note: The TPM submodule uploads the TPM commands that do not fall
            into the FIFO registers (`0xD4_XXXX`) regardless of
            `invalid_locality` bit.
            '''
        } // f: invalid_locality
      ]
    } // R: TPM_CFG
    { name: "TPM_STATUS"
      desc: '''TPM submodule state register.

        The TPM_STATUS CSR provides the status of the read and write FIFOs, as well as the Command and Address buffer.
        '''
      swaccess: "ro"
      hwaccess: "hrw"
      hwext: true
      hwqe: true
      tags: [
        // SW is not able to read back the !!TPM_STATUS register right after write.
        // The read back value is the committed value, which needs at least some SPI cycles.
        // So excluded from CSR automation test.
        "excl:CsrNonInitTests:CsrExclWrite"
      ]
      fields: [
        { bits: "0"
          name: "cmdaddr_notempty"
          hwaccess: "hwo"
          desc: "If set, !!TPM_CMD_ADDR contains valid data. This status is reported via the interrupt also."
        } // f: cmdaddr_notempty
        { bits: "1"
          name: "wrfifo_pending"
          swaccess: "rw0c"
          desc: '''If set, the Write FIFO is reserved for software processing.

            This bit becomes set when a complete write command is received.
            While it remains set, subsequent write commands will block at the wait state until it is cleared.
            Write 0 to release the Write FIFO back to the TPM module.
            '''
        } // f: cmdaddr_notempty
        { bits: "2"
          name: "rdfifo_aborted"
          hwaccess: "hwo"
          desc: '''If set, the last Read FIFO command was aborted.

            This bit becomes set when a Read FIFO command became active, but the transaction did not complete.
            An aborted transaction occurs when the host de-asserts CSb without clocking all the requested data.
            This bit remains set until reset, or it will clear automatically after the next valid command is read from !!TPM_CMD_ADDR.
            '''
        } // f: cmdaddr_notempty
      ]
    } // R: TPM_STATUS
    { multireg: {
      cname: "TPM"
      name: "TPM_ACCESS"
      desc: '''TPM_ACCESS_x register.
        '''
      count: "NumLocality"
      compact: true
      swaccess: "rw"
      hwaccess: "hro"
      fields: [
        { bits: "7:0"
          name: "access"
          desc: "TPM_ACCESS"
        }
      ]
    }} // mr: TPM_ACCESS
    { name: "TPM_STS"
      desc: '''TPM_STS_x register.

        The register is mirrored to all Localities.
        The value is returned to the host system only when the activeLocality
        in the TPM_ACCESS_x is matched to the current received Locality.
        '''
      swaccess: "rw"
      hwaccess: "hro"
      fields: [
        { bits: "31:0"
          name: "sts"
          desc: "TPM_STS_x"
        }
      ]
    } // R: TPM_STS
    { name: "TPM_INTF_CAPABILITY"
      desc: "TPM_INTF_CAPABILITY register."
      swaccess: "rw"
      hwaccess: "hro"
      fields: [
        { bits: "31:0"
          name: "intf_capability"
          desc: "TPM_INTF_CAPABILITY"
        }
      ]
    } // R: TPM_INTF_CAPABILITY
    { name: "TPM_INT_ENABLE"
      desc: "TPM_INT_ENABLE register."
      swaccess: "rw"
      hwaccess: "hro"
      fields: [
        { bits: "31:0"
          name: "int_enable"
          desc: "TPM_INT_ENABLE"
        }
      ]
    } // R: TPM_INT_ENABLE
    { name: "TPM_INT_VECTOR"
      desc: "TPM_INT_VECTOR register."
      swaccess: "rw"
      hwaccess: "hro"
      fields: [
        { bits: "7:0"
          name: "int_vector"
          desc: "TPM_INT_VECTOR"
        }
      ]
    } // R: TPM_INT_VECTOR
    { name: "TPM_INT_STATUS"
      desc: "TPM_INT_STATUS register."
      swaccess: "rw"
      hwaccess: "hro"
      fields: [
        { bits: "31:0"
          name: "int_status"
          desc: "TPM_INT_STATUS"
        }
      ]
    } // R: TPM_INT_STATUS
    { name: "TPM_DID_VID"
      desc: "TPM_DID/ TPM_VID register."
      swaccess: "rw"
      hwaccess: "hro"
      fields: [
        { bits: "15:0"
          name: "vid"
          desc: "TPM_VID"
        } // f: vid
        { bits: "31:16"
          name: "did"
          desc: "TPM_DID"
        } // f: did
      ]
    } // R: TPM_DID_VID
    { name: "TPM_RID"
      desc: "TPM_RID register."
      swaccess: "rw"
      hwaccess: "hro"
      fields: [
        { bits: "7:0"
          name: "rid"
          desc: "TPM_RID"
        }
      ]
    } // R: TPM_RID
    { name: "TPM_CMD_ADDR"
      desc: '''TPM Command and Address buffer.

        The SW may get the received TPM command and address by reading this CSR.
        '''
      swaccess: "ro"
      hwaccess: "hrw"
      hwext: "true"
      hwre:  "true"
      hwqe:  "true"
      fields: [
        { bits: "23:0"
          name: "addr"
          desc: "Received address."
        } // f: addr
        { bits: "31:24"
          name: "cmd"
          desc: "Received command."
        } // f: cmd
      ]
    } // R: TPM_CMD_ADDR
    { name: "TPM_READ_FIFO"
      desc: '''TPM Read command return data FIFO.

        The write port of the read command FIFO.
        '''
      swaccess: "wo"
      hwaccess: "hro"
      hwqe: "true"
      hwext: "true"
      fields: [
        { bits: "TpmRdFifoWidth-1:0"
          name: "value"
          desc: "Write port of the read FIFO."
        }
      ]
      tags: [// Updating FIFO randomly can result in tpm_status value change
             "excl:CsrNonInitTests:CsrExclWrite"]
    } // R: TPM_READ_FIFO
    //---------------------------------------------------------------
    { skipto: "0x1000" }
    { window: {
        name: "egress_buffer",
        items: "SramEgressDepth",
        validbits: "32",
        byte-write: "false",
        unusual: "true"
        swaccess: "wo",
        desc: '''
          SPI internal egress buffer.
          | Offset (Words) | Length (Words) | Purpose                                    |
          |:--------------:|:--------------:|:-------------------------------------------|
          |        0       |       512      | Flash mode Read buffer for emulated flash. |
          |       512      |       256      | Flash mode Mailbox.                        |
          |       768      |        64      | Flash mode SFDP configuration buffer.      |
          |       832      |        16      | TPM Read FIFO.                             |
          '''
      },
    },
    { window: {
        name: "ingress_buffer",
        items: "SramIngressDepth",
        validbits: "32",
        byte-write: "false",
        unusual: "true"
        swaccess: "ro",
        desc: '''
          SPI internal ingress buffer.
          | Offset (Words) | Length (Words) | Purpose                           |
          |:--------------:|:--------------:|:----------------------------------|
          |        0       |        64      | Flash mode Payload FIFO.          |
          |        64      |        16      | Flash mode uploaded command FIFO. |
          |        80      |        16      | Flash mode uploaded address FIFO. |
          |        96      |        16      | TPM Write FIFO.                   |
          '''
      },
    },
  ]
}
