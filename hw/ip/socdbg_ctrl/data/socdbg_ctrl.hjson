// Copyright lowRISC contributors.
// Licensed under the Apache License, Version 2.0, see LICENSE for details.
// SPDX-License-Identifier: Apache-2.0

{
  name:               "socdbg_ctrl",
  human_name:         "Soc Debug Acess Control Module",
  one_line_desc:      "Control Module to enable or disable debug access",
  one_paragraph_desc: '''
  Module that Controls the Debug / DFT feature access for an SoC for which OpenTitan serves as an integrated HW RoT
  A debug policy bus driven from this module governs the unlock policy. Output from the debug policy bus is decoded by various debug / DFT logic blocks in an SoC
  to determine if feature debug / DFT access is allowed or not.
  The access policy is derived by the RoT with a challenge-response based debug authentication exchange session with a remote policy enforcer
  '''
  // Unique comportable IP identifier defined under KNOWN_CIP_IDS in the regtool.
  cip_id:             "40",
  design_spec:        "../doc",
  dv_doc:             "../doc/dv",
  hw_checklist:       "../doc/checklist",
  sw_checklist:       "/sw/ip/socdbg_ctrl/dif/dif_socdbg_ctrl",
  revisions: [
    {
      version:            "1.0.0",
      life_stage:         "L1",
      design_stage:       "D1",
      verification_stage: "V1",
      dif_stage:          "S1",
      notes:              ""
    }
  ]
  clocking: [{clock: "clk_i", reset: "rst_ni"}],
  bus_interfaces: [
    { protocol: "tlul", direction: "device", name: "core" }
    { protocol: "tlul", direction: "device", name: "jtag" }
  ],
  // INTERRUPT pins
  interrupt_list: [
    { name: "debug_attention"
      desc: "A placeholder interrupt from the debug control module. No defined function at this time."
    }
  ],
  alert_list: [
    { name: "fatal_fault",
      desc: '''
      This fatal alert is triggered when a fatal TL-UL bus integrity fault is detected.
      '''
    }
  ],
  param_list: [
    { name: "EnableHaltFunction",
      desc: "Parameter to disable CPU halt funtions",
      type: "bit",
      default: "1",
    }
  ],
  countermeasures: [
    { name: "BUS.INTEGRITY",
      desc: "End-to-end bus integrity scheme.",
    }
    { name: "LC_CTRL.INTERSIG.MUBI",
      desc: "Life cycle control signals are multibit encoded."
    }
  ]

  inter_signal_list: [
    { struct:  "logic"
      type:    "uni"
      name:    "halt_cpu_boot"
      act:     "rcv"
    }
    { struct:  "pwrmgr_data"
      type:    "uni"
      name:    "continue_cpu_boot"
      package: "rom_ctrl_pkg"
      act:     "req"
    }
    { struct:  "soc_dbg_state"
      type:    "uni"
      name:    "soc_dbg_state"
      package: "lc_ctrl_state_pkg"
      act:     "rcv"
    }
    { struct:  "soc_dbg_policy"
      type:    "uni"
      name:    "socdbg_policy_bus"
      package: "socdbg_ctrl_pkg"
      act:     "req"
    }
    // Broadcast from LC
    { struct:  "lc_tx"
      type:    "uni"
      name:    "lc_escalate_en"
      act:     "rcv"
      default: "lc_ctrl_pkg::Off"
      package: "lc_ctrl_pkg"
      desc:    '''
               Life cycle escalation enable coming from life cycle controller.
               This signal moves all FSMs within OTP into the error state.
               '''
    }
    { struct:  "lc_tx"
      type:    "uni"
      name:    "lc_hw_debug_en"
      act:     "rcv"
      default: "lc_ctrl_pkg::Off"
      package: "lc_ctrl_pkg"
      desc:    '''
               Multibit life cycle hardware debug enable signal coming from life cycle controller,
               asserted when the hardware debug mechanisms are enabled in the system.
               '''
    },
    { struct:  "lc_tx"
      type:    "uni"
      name:    "lc_creator_seed_sw_rw_en"
      act:     "rcv"
      default: "lc_ctrl_pkg::Off"
      package: "lc_ctrl_pkg"
      desc:    '''
               Provision enable qualifier coming from life cycle controller.
               This signal enables SW read / write access to the RMA_TOKEN and CREATOR_ROOT_KEY_SHARE0 and CREATOR_ROOT_KEY_SHARE1.
               '''
    }
    { struct:  "lc_tx"
      type:    "uni"
      name:    "lc_seed_hw_rd_en"
      act:     "rcv"
      default: "lc_ctrl_pkg::Off"
      package: "lc_ctrl_pkg"
      desc:    '''
               Seed read enable coming from life cycle controller.
               This signal enables HW read access to the CREATOR_ROOT_KEY_SHARE0 and CREATOR_ROOT_KEY_SHARE1.
               '''
    }
    { struct:  "lc_tx"
      type:    "uni"
      name:    "lc_dft_en"
      act:     "rcv"
      default: "lc_ctrl_pkg::Off"
      package: "lc_ctrl_pkg"
      desc:    '''
               Test enable qualifier coming from life cycle controller.
               This signals enables the TL-UL access port to the proprietary OTP IP.
               '''
    }
    { struct:  "lc_tx"
      type:    "uni"
      name:    "lc_check_byp_en"
      act:     "rcv"
      default: "lc_ctrl_pkg::Off"
      package: "lc_ctrl_pkg"
      desc:    '''
               Life cycle partition check bypass signal.
               This signal causes the life cycle partition to bypass consistency checks during life cycle state transitions in order to prevent spurious consistency check failures.
               '''
    }
  ]

  // REGISTER definition
  regwidth: "32"
  registers: {
    core: [
        // CTRL register
        { name: "DEBUG_POLICY_CTRL"
          desc: "Debug Policy Control"
          swaccess: "rw"
          hwaccess: "hro"
          fields: [
            { bits: "3:0"
              resval: "0"
              name: "debug_policy_level"
              desc: '''
                     Debug Policy Control Setting
                     Indicates the current debug authorization policy that is
                     distributed to the rest of the SoC to govern debug / DFT
                     feature unlock
                    '''
            }
          ]
        }
        { name: "DEBUG_POLICY_VALID"
          desc: "Debug Policy Valid"
          swaccess: "rw"
          hwaccess: "hro"
          fields: [
            { bits: "0"
              resval: "0"
              name: "debug_policy_valid"
              desc: '''
                     Debug Policy Control Setting
                     Indicates the current debug authorization policy that is
                     distributed to the rest of the SoC to govern debug / DFT
                     feature unlock
                    '''
            }
          ]
        }
        { name:     "STATUS_MBX"
          desc:     "Debug Status Register"
          swaccess: "rw"
          hwaccess: "hro"
          fields: [
            { bits: "0"
              name: "auth_debug_intent_set"
              desc: '''
                     Status bit indicating whether the debug intent hardware strap
                     was set. If set, SoC will be treated as under debug and
                     authorized debug can be enabled to unlock the SoC at desired
                     debug unlock level
                    '''
              resval: "0"
            }
            { bits: "4"
              name: "auth_window_open"
              desc: '''
                     Status bit that tells whether debug authorization exchange
                     can take place
                     This bit is set when auth_debug_intent_set is 1 and SoC reset
                     sequence is paused to enable debug authorization exchange
                    '''
              resval: "0"
            }
            { bits: "5"
              name: "auth_window_closed"
              desc: '''
                     Status bit that indicates that SoC reset sequence is
                     unpaused SoC shall continue to boot and the debug authorization
                     exchange cannot take place anymore until next reset. Note that
                     the rest of the SoC reset sequence is triggered by the OT RoT
                    '''
              resval: "0"
            }
            { bits: "6"
              name: "auth_unlock_success"
              desc: '''
                     Status bit indicating whether the unlock protocol
                     resulted in a successful unlock at requested level"
                    '''
              resval: "0"
            }
            { bits: "7"
              name: "auth_unlock_failed"
              desc: '''
                     Status bit indicating whether the unlock protocol was
                     ulted in unlock failure at requested level"
                    '''
              resval: "0"
            }
            { bits: "11:8"
              name: "current_policy"
              desc: '''
                     Status bit that tells whether debug authorization exchange
                     can take place or the authorization widow is closed"
                    '''
              resval: "0"
            }
            { bits: "15:12"
              name: "requested_policy"
              desc: '''
                     Status bit that tells whether debug authorization exchange
                     can take place or the authorization widow is closed"
                    '''
              resval: "0"
            }
          ]
      tags: [// Updated by the hw. Exclude from write-checks.
             "excl:CsrNonInitTests:CsrExclWriteCheck"]
        }
      ]
    jtag: [
        // JTAG STATUS register
        { name:     "JTAG_STATUS"
          desc:     "Debug Status Register"
          swaccess: "ro"
          hwaccess: "hwo"
          hwext:    "true"
          fields: [
            { bits: "0"
              name: "auth_debug_intent_set"
              desc: '''
                     Status bit indicating whether the debug intent hardware strap
                     was set. If set, SoC will be treated as under debug and
                     authorized debug can be enabled to unlock the SoC at desired
                     debug unlock level"
                    '''
              resval: "0"
            }
            { bits: "4"
              name: "auth_window_open"
              desc: '''
                     Status bit that tells whether debug authorization exchange
                     can take place
                     This bit is set when auth_debug_intent_set is 1 and SoC reset
                     sequence is paused to enable debug authorization exchange"
                    '''
              resval: "0"
            }
            { bits: "5"
              name: "auth_window_closed"
              desc: '''
                     Status bit that indicates that SoC reset sequence is
                     unpaused, SoC shall continue to boot and the debug authorization
                     exchange cannot take place anymore until next reset. Note that
                     the rest of the SoC reset sequence is triggered by the OT RoT"
                    '''
              resval: "0"
            }
            { bits: "6"
              name: "auth_unlock_success"
              desc: '''
                     Status bit indicating whether the unlock protocol
                     resulted in a successful unlock at requested level"
                    '''
              resval: "0"
            }
            { bits: "7"
              name: "auth_unlock_failed"
              desc: '''
                     Status bit indicating whether the unlock protocol was
                     ulted in unlock failure at requested level"
                    '''
              resval: "0"
            }
            { bits: "11:8"
              name: "current_policy"
              desc: '''
                     Status bit that tells whether debug authorization exchange
                     can take place or the authorization widow is closed
                    '''
              resval: "0"
            }
            { bits: "15:12"
              name: "requested_policy"
              desc: '''
                    Status bit that tells whether debug authorization exchange
                     can take place or the authorization widow is closed
                    '''
              resval: "0"
            }
          ]
      tags: [// Updated by the hw. Exclude from write-checks.
             "excl:CsrNonInitTests:CsrExclWriteCheck"]
        }
      ]
  }
}
