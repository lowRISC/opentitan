// Copyright lowRISC contributors (OpenTitan project).
// Licensed under the Apache License, Version 2.0, see LICENSE for details.
// SPDX-License-Identifier: Apache-2.0
//
// ------------------- W A R N I N G: A U T O - G E N E R A T E D   C O D E !! -------------------//
// PLEASE DO NOT HAND-EDIT THIS FILE. IT HAS BEEN AUTO-GENERATED WITH THE FOLLOWING COMMAND:
//
// util/topgen.py -t hw/top_englishbreakfast/data/top_englishbreakfast.hjson \
//                -o hw/top_englishbreakfast/ \
//                --rnd_cnst_seed 4881560218908238235
{
  name: englishbreakfast
  type: top
  rnd_cnst_seed: 4881560218908238235
  datawidth: "32"
  power:
  {
    domains:
    [
      Aon
      "0"
    ]
    default: "0"
  }
  clocks:
  {
    hier_paths:
    {
      top: clkmgr_aon_clocks.
      ext: ""
      lpg: clkmgr_aon_cg_en.
    }
    srcs:
    [
      {
        name: main
        aon: no
        freq: "100000000"
        ref: false
      }
      {
        name: io
        aon: no
        freq: "96000000"
        ref: false
      }
      {
        name: usb
        aon: no
        freq: "48000000"
        ref: false
      }
      {
        name: aon
        aon: yes
        freq: "200000"
        ref: false
      }
    ]
    derived_srcs:
    [
      {
        name: io_div2
        aon: no
        freq: "48000000"
        ref: false
        div: "2"
        src: io
      }
      {
        name: io_div4
        aon: no
        freq: "24000000"
        ref: false
        div: "4"
        src: io
      }
    ]
    groups:
    [
      {
        name: ast
        src: ext
        sw_cg: no
        unique: no
        clocks:
        {
          clk_main_i: main
          clk_io_i: io
          clk_usb_i: usb
          clk_aon_i: aon
        }
      }
      {
        name: powerup
        src: top
        sw_cg: no
        unique: no
        clocks:
        {
          clk_io_div4_powerup: io_div4
          clk_aon_powerup: aon
          clk_main_powerup: main
          clk_io_powerup: io
          clk_usb_powerup: usb
          clk_io_div2_powerup: io_div2
        }
      }
      {
        name: trans
        src: top
        sw_cg: hint
        unique: yes
        clocks:
        {
          clk_main_aes: main
        }
      }
      {
        name: infra
        src: top
        sw_cg: no
        unique: no
        clocks:
        {
          clk_main_infra: main
          clk_io_div4_infra: io_div4
          clk_io_infra: io
          clk_usb_infra: usb
        }
      }
      {
        name: secure
        src: top
        sw_cg: no
        unique: no
        clocks:
        {
          clk_io_div4_secure: io_div4
          clk_aon_secure: aon
          clk_main_secure: main
        }
      }
      {
        name: peri
        src: top
        sw_cg: yes
        unique: no
        clocks:
        {
          clk_io_div4_peri: io_div4
          clk_io_div2_peri: io_div2
          clk_io_peri: io
          clk_usb_peri: usb
          clk_aon_peri: aon
        }
      }
      {
        name: timers
        src: top
        sw_cg: no
        unique: no
        clocks:
        {
          clk_io_div4_timers: io_div4
          clk_aon_timers: aon
        }
      }
      {
        name: proc
        src: no
        sw_cg: no
        unique: no
        clocks: {}
      }
    ]
  }
  resets:
  {
    hier_paths:
    {
      top: rstmgr_aon_resets.
      ext: ""
      lpg: rstmgr_aon_rst_en.
    }
    nodes:
    [
      {
        name: por_aon
        gen: false
        type: top
        domains:
        [
          Aon
        ]
        shadowed: false
        sw: false
        path: rstmgr_aon_resets.rst_por_aon_n
        clock: aon
      }
      {
        name: lc_src
        gen: false
        type: int
        domains: []
        shadowed: false
        sw: false
        path: ""
        clock: io_div4
      }
      {
        name: sys_src
        gen: false
        type: int
        domains: []
        shadowed: false
        sw: false
        path: ""
        clock: io_div4
      }
      {
        name: por
        gen: true
        type: top
        domains:
        [
          Aon
        ]
        shadowed: false
        sw: false
        path: rstmgr_aon_resets.rst_por_n
        parent: por_aon
        clock: main
      }
      {
        name: por_io
        gen: true
        type: top
        domains:
        [
          Aon
        ]
        shadowed: false
        sw: false
        path: rstmgr_aon_resets.rst_por_io_n
        parent: por_aon
        clock: io
      }
      {
        name: por_io_div2
        gen: true
        type: top
        domains:
        [
          Aon
        ]
        shadowed: false
        sw: false
        path: rstmgr_aon_resets.rst_por_io_div2_n
        parent: por_aon
        clock: io_div2
      }
      {
        name: por_io_div4
        gen: true
        type: top
        domains:
        [
          Aon
        ]
        shadowed: true
        sw: false
        path: rstmgr_aon_resets.rst_por_io_div4_n
        parent: por_aon
        clock: io_div4
      }
      {
        name: por_usb
        gen: true
        type: top
        domains:
        [
          Aon
        ]
        shadowed: false
        sw: false
        path: rstmgr_aon_resets.rst_por_usb_n
        parent: por_aon
        clock: usb
      }
      {
        name: lc
        gen: true
        type: top
        domains:
        [
          "0"
        ]
        shadowed: true
        sw: false
        path: rstmgr_aon_resets.rst_lc_n
        parent: lc_src
        clock: main
      }
      {
        name: lc_io_div4
        gen: true
        type: top
        domains:
        [
          "0"
          Aon
        ]
        shadowed: false
        sw: false
        path: rstmgr_aon_resets.rst_lc_io_div4_n
        parent: lc_src
        clock: io_div4
      }
      {
        name: sys
        gen: true
        type: top
        domains:
        [
          "0"
        ]
        shadowed: true
        sw: false
        path: rstmgr_aon_resets.rst_sys_n
        parent: sys_src
        clock: main
      }
      {
        name: sys_io_div4
        gen: true
        type: top
        domains:
        [
          "0"
          Aon
        ]
        shadowed: false
        sw: false
        path: rstmgr_aon_resets.rst_sys_io_div4_n
        parent: sys_src
        clock: io_div4
      }
      {
        name: sys_aon
        gen: true
        type: top
        domains:
        [
          "0"
          Aon
        ]
        shadowed: false
        sw: false
        path: rstmgr_aon_resets.rst_sys_aon_n
        parent: sys_src
        clock: aon
      }
      {
        name: spi_device
        gen: true
        type: top
        domains:
        [
          "0"
        ]
        shadowed: false
        sw: true
        path: rstmgr_aon_resets.rst_spi_device_n
        parent: sys_src
        clock: io_div2
      }
      {
        name: spi_host0
        gen: true
        type: top
        domains:
        [
          "0"
        ]
        shadowed: false
        sw: true
        path: rstmgr_aon_resets.rst_spi_host0_n
        parent: sys_src
        clock: io
      }
      {
        name: usb
        gen: true
        type: top
        domains:
        [
          "0"
        ]
        shadowed: false
        sw: true
        path: rstmgr_aon_resets.rst_usb_n
        parent: sys_src
        clock: usb
      }
    ]
  }
  num_cores: "1"
  module:
  [
    {
      name: uart0
      type: uart
      clock_srcs:
      {
        clk_i: io_div4
      }
      clock_group: peri
      reset_connections:
      {
        rst_ni:
        {
          name: lc_io_div4
          domain: "0"
        }
      }
      clock_connections:
      {
        clk_i: clkmgr_aon_clocks.clk_io_div4_peri
      }
      domain:
      [
        "0"
      ]
      param_decl: {}
      param_list: []
      inter_signal_list:
      [
        {
          name: tl
          struct: tl
          package: tlul_pkg
          type: req_rsp
          act: rsp
          width: 1
          inst_name: uart0
          default: ""
          end_idx: -1
          top_signame: uart0_tl
          index: -1
        }
      ]
      base_addrs:
      {
        null: 0x40000000
      }
    }
    {
      name: uart1
      type: uart
      clock_srcs:
      {
        clk_i: io_div4
      }
      clock_group: peri
      reset_connections:
      {
        rst_ni:
        {
          name: lc_io_div4
          domain: "0"
        }
      }
      clock_connections:
      {
        clk_i: clkmgr_aon_clocks.clk_io_div4_peri
      }
      domain:
      [
        "0"
      ]
      param_decl: {}
      param_list: []
      inter_signal_list:
      [
        {
          name: tl
          struct: tl
          package: tlul_pkg
          type: req_rsp
          act: rsp
          width: 1
          inst_name: uart1
          default: ""
          end_idx: -1
          top_signame: uart1_tl
          index: -1
        }
      ]
      base_addrs:
      {
        null: 0x40010000
      }
    }
    {
      name: gpio
      type: gpio
      clock_srcs:
      {
        clk_i: io_div4
      }
      clock_group: peri
      reset_connections:
      {
        rst_ni:
        {
          name: sys_io_div4
          domain: "0"
        }
      }
      param_decl:
      {
        GpioAsyncOn: "1"
      }
      clock_connections:
      {
        clk_i: clkmgr_aon_clocks.clk_io_div4_peri
      }
      domain:
      [
        "0"
      ]
      memory: {}
      param_list:
      [
        {
          name: GpioAsyncOn
          desc: Instantiates 2-flop synchronizers on all GPIO inputs if set to 1.
          type: bit
          default: "1"
          expose: "true"
          name_top: GpioGpioAsyncOn
        }
      ]
      inter_signal_list:
      [
        {
          name: tl
          struct: tl
          package: tlul_pkg
          type: req_rsp
          act: rsp
          width: 1
          inst_name: gpio
          default: ""
          end_idx: -1
          top_signame: gpio_tl
          index: -1
        }
      ]
      base_addrs:
      {
        null: 0x40040000
      }
    }
    {
      name: spi_device
      type: spi_device
      clock_srcs:
      {
        clk_i: io_div4
        scan_clk_i: io_div2
      }
      clock_group: peri
      reset_connections:
      {
        rst_ni:
        {
          name: spi_device
          domain: "0"
        }
      }
      clock_connections:
      {
        clk_i: clkmgr_aon_clocks.clk_io_div4_peri
        scan_clk_i: clkmgr_aon_clocks.clk_io_div2_peri
      }
      domain:
      [
        "0"
      ]
      param_decl: {}
      memory: {}
      param_list:
      [
        {
          name: SramType
          desc: Sram Entries. Word size is 32bit width.
          type: spi_device_pkg::sram_type_e
          default: spi_device_pkg::DefaultSramType
          expose: "true"
          name_top: SpiDeviceSramType
        }
      ]
      inter_signal_list:
      [
        {
          name: ram_cfg
          struct: ram_2p_cfg
          package: prim_ram_2p_pkg
          type: uni
          act: rcv
          width: 1
          inst_name: spi_device
          index: -1
        }
        {
          name: passthrough
          struct: passthrough
          package: spi_device_pkg
          type: req_rsp
          act: req
          width: 1
          inst_name: spi_device
          default: ""
          end_idx: -1
          top_signame: spi_device_passthrough
          index: -1
        }
        {
          name: mbist_en
          struct: logic
          type: uni
          act: rcv
          width: 1
          inst_name: spi_device
          index: -1
        }
        {
          name: sck_monitor
          struct: logic
          type: uni
          act: req
          width: 1
          inst_name: spi_device
          default: ""
          package: ""
          external: true
          top_signame: sck_monitor
          conn_type: false
          index: -1
        }
        {
          name: tl
          struct: tl
          package: tlul_pkg
          type: req_rsp
          act: rsp
          width: 1
          inst_name: spi_device
          default: ""
          end_idx: -1
          top_signame: spi_device_tl
          index: -1
        }
      ]
      base_addrs:
      {
        null: 0x40050000
      }
    }
    {
      name: spi_host0
      type: spi_host
      clock_srcs:
      {
        clk_i: io
      }
      clock_group: peri
      reset_connections:
      {
        rst_ni:
        {
          name: spi_host0
          domain: "0"
        }
      }
      clock_connections:
      {
        clk_i: clkmgr_aon_clocks.clk_io_peri
      }
      domain:
      [
        "0"
      ]
      param_decl: {}
      param_list: []
      inter_signal_list:
      [
        {
          name: passthrough
          struct: passthrough
          package: spi_device_pkg
          type: req_rsp
          act: rsp
          width: 1
          inst_name: spi_host0
          default: ""
          top_signame: spi_device_passthrough
          index: -1
        }
        {
          name: tl
          struct: tl
          package: tlul_pkg
          type: req_rsp
          act: rsp
          width: 1
          inst_name: spi_host0
          default: ""
          end_idx: -1
          top_signame: spi_host0_tl
          index: -1
        }
      ]
      base_addrs:
      {
        null: 0x40060000
      }
    }
    {
      name: rv_timer
      type: rv_timer
      clock_srcs:
      {
        clk_i: io_div4
      }
      clock_group: timers
      reset_connections:
      {
        rst_ni:
        {
          name: sys_io_div4
          domain: "0"
        }
      }
      clock_connections:
      {
        clk_i: clkmgr_aon_clocks.clk_io_div4_timers
      }
      domain:
      [
        "0"
      ]
      param_decl: {}
      param_list: []
      inter_signal_list:
      [
        {
          name: tl
          struct: tl
          package: tlul_pkg
          type: req_rsp
          act: rsp
          width: 1
          inst_name: rv_timer
          default: ""
          end_idx: -1
          top_signame: rv_timer_tl
          index: -1
        }
      ]
      base_addrs:
      {
        null: 0x40100000
      }
    }
    {
      name: usbdev
      type: usbdev
      clock_srcs:
      {
        clk_i: usb
        clk_aon_i: aon
      }
      clock_group: peri
      reset_connections:
      {
        rst_ni:
        {
          name: usb
          domain: "0"
        }
        rst_aon_ni:
        {
          name: sys_aon
          domain: "0"
        }
      }
      clock_connections:
      {
        clk_i: clkmgr_aon_clocks.clk_usb_peri
        clk_aon_i: clkmgr_aon_clocks.clk_aon_peri
      }
      domain:
      [
        "0"
      ]
      param_decl: {}
      memory: {}
      param_list:
      [
        {
          name: Stub
          desc: Stub out the core of entropy_src logic
          type: bit
          default: "0"
          expose: "true"
          name_top: UsbdevStub
        }
        {
          name: RcvrWakeTimeUs
          desc: Maximum number of microseconds for the differential receiver to become operational
          type: int
          default: "1"
          expose: "true"
          name_top: UsbdevRcvrWakeTimeUs
        }
      ]
      inter_signal_list:
      [
        {
          name: usb_rx_d
          desc: USB RX data from an external differential receiver, if available
          struct: logic
          type: uni
          act: rcv
          width: 1
          inst_name: usbdev
          default: ""
          package: ""
          external: true
          top_signame: usbdev_usb_rx_d
          conn_type: false
          index: -1
        }
        {
          name: usb_tx_d
          desc: USB transmit data value (not used if usb_tx_se0 is set)
          struct: logic
          type: uni
          act: req
          width: 1
          inst_name: usbdev
          default: ""
          package: ""
          external: true
          top_signame: usbdev_usb_tx_d
          conn_type: false
          index: -1
        }
        {
          name: usb_tx_se0
          desc: Force transmission of a USB single-ended zero (i.e. both D+ and D- are low) regardless of usb_tx_d
          struct: logic
          type: uni
          act: req
          width: 1
          inst_name: usbdev
          default: ""
          package: ""
          external: true
          top_signame: usbdev_usb_tx_se0
          conn_type: false
          index: -1
        }
        {
          name: usb_tx_use_d_se0
          desc: Use the usb_tx_d and usb_tx_se0 TX interface, instead of usb_dp_o and usb_dn_o
          struct: logic
          type: uni
          act: req
          width: 1
          inst_name: usbdev
          default: ""
          package: ""
          external: true
          top_signame: usbdev_usb_tx_use_d_se0
          conn_type: false
          index: -1
        }
        {
          name: usb_dp_pullup
          desc: USB D+ pullup control
          struct: logic
          type: uni
          act: req
          width: 1
          inst_name: usbdev
          default: ""
          package: ""
          end_idx: -1
          top_type: broadcast
          top_signame: usbdev_usb_dp_pullup
          index: -1
        }
        {
          name: usb_dn_pullup
          desc: USB D- pullup control
          struct: logic
          type: uni
          act: req
          width: 1
          inst_name: usbdev
          default: ""
          package: ""
          end_idx: -1
          top_type: broadcast
          top_signame: usbdev_usb_dn_pullup
          index: -1
        }
        {
          name: usb_rx_enable
          desc: USB differential receiver enable
          struct: logic
          type: uni
          act: req
          width: 1
          inst_name: usbdev
          default: ""
          package: ""
          external: true
          top_signame: usbdev_usb_rx_enable
          conn_type: false
          index: -1
        }
        {
          name: usb_ref_val
          desc: This indicates that USB timing reference signal 'usb_ref_pulse' is valid
          struct: logic
          type: uni
          act: req
          width: 1
          inst_name: usbdev
          default: ""
          package: ""
          external: true
          top_signame: usbdev_usb_ref_val
          conn_type: false
          index: -1
        }
        {
          name: usb_ref_pulse
          desc: USB timing reference signal. This signal pulses for a single 48MHz clock every 1ms USB frame
          struct: logic
          type: uni
          act: req
          width: 1
          inst_name: usbdev
          default: ""
          package: ""
          external: true
          top_signame: usbdev_usb_ref_pulse
          conn_type: false
          index: -1
        }
        {
          name: usb_aon_suspend_req
          desc: Request to activate the AON/Wake module and take control of the USB pullups
          struct: logic
          type: uni
          act: req
          width: 1
          inst_name: usbdev
          default: ""
          package: ""
          end_idx: -1
          top_type: broadcast
          top_signame: usbdev_usb_aon_suspend_req
          index: -1
        }
        {
          name: usb_aon_wake_ack
          desc: Acknowledge a wake signal from the AON/Wake and relinquish control of the USB pullups
          struct: logic
          type: uni
          act: req
          width: 1
          inst_name: usbdev
          default: ""
          package: ""
          end_idx: -1
          top_type: broadcast
          top_signame: usbdev_usb_aon_wake_ack
          index: -1
        }
        {
          name: usb_aon_bus_reset
          desc: Indicates that the reason for waking was that a USB Bus Reset occurred
          struct: logic
          type: uni
          act: rcv
          width: 1
          inst_name: usbdev
          default: ""
          package: ""
          end_idx: -1
          top_type: broadcast
          top_signame: usbdev_usb_aon_bus_reset
          index: -1
        }
        {
          name: usb_aon_sense_lost
          desc: Indicates that the reason for waking was that the VBUS/SENSE signal became deasserted
          struct: logic
          type: uni
          act: rcv
          width: 1
          inst_name: usbdev
          default: ""
          package: ""
          end_idx: -1
          top_type: broadcast
          top_signame: usbdev_usb_aon_sense_lost
          index: -1
        }
        {
          name: usb_aon_bus_not_idle
          desc: Indicates that the reason for waking was that the USB is in a non-idle state
          struct: logic
          type: uni
          act: rcv
          width: 1
          inst_name: usbdev
          index: -1
        }
        {
          name: usb_aon_wake_detect_active
          desc: Indicates that the external AON/Wake module is active and controlling the USB pullups
          struct: logic
          type: uni
          act: rcv
          width: 1
          inst_name: usbdev
          default: ""
          package: ""
          top_signame: pinmux_aon_usbdev_wake_detect_active
          index: -1
        }
        {
          name: ram_cfg
          struct: ram_1p_cfg
          package: prim_ram_1p_pkg
          type: uni
          act: rcv
          width: 1
          inst_name: usbdev
          index: -1
        }
        {
          name: tl
          struct: tl
          package: tlul_pkg
          type: req_rsp
          act: rsp
          width: 1
          inst_name: usbdev
          default: ""
          end_idx: -1
          top_signame: usbdev_tl
          index: -1
        }
      ]
      base_addrs:
      {
        null: 0x40320000
      }
    }
    {
      name: pwrmgr_aon
      type: pwrmgr
      clock_srcs:
      {
        clk_i: io_div4
        clk_slow_i: aon
        clk_lc_i: io_div4
        clk_esc_i: io_div4
      }
      clock_group: powerup
      reset_connections:
      {
        rst_ni:
        {
          name: por_io_div4
          domain: Aon
        }
        rst_lc_ni:
        {
          name: lc_io_div4
          domain: Aon
        }
        rst_esc_ni:
        {
          name: lc_io_div4
          domain: Aon
        }
        rst_main_ni:
        {
          name: por_aon
          domain: Aon
        }
        rst_slow_ni:
        {
          name: por_aon
          domain: Aon
        }
      }
      domain:
      [
        Aon
      ]
      attr: ipgen
      clock_connections:
      {
        clk_i: clkmgr_aon_clocks.clk_io_div4_powerup
        clk_slow_i: clkmgr_aon_clocks.clk_aon_powerup
        clk_lc_i: clkmgr_aon_clocks.clk_io_div4_powerup
        clk_esc_i: clkmgr_aon_clocks.clk_io_div4_powerup
      }
      param_decl: {}
      param_list: []
      inter_signal_list:
      [
        {
          name: pwr_ast
          struct: pwr_ast
          package: pwrmgr_pkg
          type: req_rsp
          act: req
          width: 1
          inst_name: pwrmgr_aon
          default: ""
          external: true
          top_signame: pwrmgr_ast
          conn_type: false
          index: -1
        }
        {
          name: pwr_rst
          struct: pwr_rst
          package: pwrmgr_pkg
          type: req_rsp
          act: req
          width: 1
          inst_name: pwrmgr_aon
          default: ""
          end_idx: -1
          top_signame: pwrmgr_aon_pwr_rst
          index: -1
        }
        {
          name: pwr_clk
          struct: pwr_clk
          package: pwrmgr_pkg
          type: req_rsp
          act: req
          width: 1
          inst_name: pwrmgr_aon
          default: ""
          end_idx: -1
          top_signame: pwrmgr_aon_pwr_clk
          index: -1
        }
        {
          name: pwr_otp
          struct: pwr_otp
          package: pwrmgr_pkg
          type: req_rsp
          act: req
          width: 1
          inst_name: pwrmgr_aon
          index: -1
        }
        {
          name: pwr_lc
          struct: pwr_lc
          package: pwrmgr_pkg
          type: req_rsp
          act: req
          width: 1
          inst_name: pwrmgr_aon
          index: -1
        }
        {
          name: pwr_flash
          struct: pwr_flash
          package: pwrmgr_pkg
          type: uni
          act: rcv
          width: 1
          inst_name: pwrmgr_aon
          default: ""
          end_idx: -1
          top_type: broadcast
          top_signame: pwrmgr_aon_pwr_flash
          index: -1
        }
        {
          name: esc_rst_tx
          struct: esc_tx
          package: prim_esc_pkg
          type: uni
          act: rcv
          width: 1
          inst_name: pwrmgr_aon
          index: -1
        }
        {
          name: esc_rst_rx
          struct: esc_rx
          package: prim_esc_pkg
          type: uni
          act: req
          width: 1
          inst_name: pwrmgr_aon
          index: -1
        }
        {
          name: pwr_cpu
          struct: pwr_cpu
          package: pwrmgr_pkg
          type: uni
          act: rcv
          width: 1
          inst_name: pwrmgr_aon
          default: ""
          top_signame: rv_core_ibex_pwrmgr
          index: -1
        }
        {
          name: wakeups
          struct: logic
          type: uni
          act: rcv
          width: 3
          inst_name: pwrmgr_aon
          default: ""
          package: ""
          end_idx: -1
          top_type: one-to-N
          top_signame: pwrmgr_aon_wakeups
          index: -1
        }
        {
          name: rstreqs
          struct: logic
          type: uni
          act: rcv
          width: 1
          inst_name: pwrmgr_aon
          default: ""
          package: ""
          end_idx: -1
          top_type: broadcast
          top_signame: pwrmgr_aon_rstreqs
          index: -1
        }
        {
          name: ndmreset_req
          struct: logic
          type: uni
          act: rcv
          width: 1
          inst_name: pwrmgr_aon
          index: -1
        }
        {
          name: strap
          struct: logic
          type: uni
          act: req
          width: 1
          inst_name: pwrmgr_aon
          default: ""
          package: ""
          end_idx: -1
          top_type: broadcast
          top_signame: pwrmgr_aon_strap
          index: -1
        }
        {
          name: low_power
          struct: logic
          type: uni
          act: req
          width: 1
          inst_name: pwrmgr_aon
          default: ""
          package: ""
          end_idx: -1
          top_type: broadcast
          top_signame: pwrmgr_aon_low_power
          index: -1
        }
        {
          name: rom_ctrl
          struct: pwrmgr_data
          package: rom_ctrl_pkg
          type: uni
          act: rcv
          width: 1
          inst_name: pwrmgr_aon
          index: -1
        }
        {
          name: fetch_en
          struct: lc_tx
          package: lc_ctrl_pkg
          type: uni
          act: req
          width: 1
          inst_name: pwrmgr_aon
          default: ""
          end_idx: -1
          top_type: broadcast
          top_signame: pwrmgr_aon_fetch_en
          index: -1
        }
        {
          name: lc_dft_en
          struct: lc_tx
          package: lc_ctrl_pkg
          type: uni
          act: rcv
          width: 1
          inst_name: pwrmgr_aon
          index: -1
        }
        {
          name: lc_hw_debug_en
          struct: lc_tx
          package: lc_ctrl_pkg
          type: uni
          act: rcv
          width: 1
          inst_name: pwrmgr_aon
          index: -1
        }
        {
          name: sw_rst_req
          struct: mubi4
          package: prim_mubi_pkg
          type: uni
          act: rcv
          width: 1
          inst_name: pwrmgr_aon
          default: ""
          top_signame: rstmgr_aon_sw_rst_req
          index: -1
        }
        {
          name: tl
          struct: tl
          package: tlul_pkg
          type: req_rsp
          act: rsp
          width: 1
          inst_name: pwrmgr_aon
          default: ""
          end_idx: -1
          top_signame: pwrmgr_aon_tl
          index: -1
        }
      ]
      base_addrs:
      {
        null: 0x40400000
      }
    }
    {
      name: rstmgr_aon
      type: rstmgr
      clock_srcs:
      {
        clk_i: io_div4
        clk_por_i: io_div4
        clk_aon_i: aon
        clk_main_i: main
        clk_io_i: io
        clk_usb_i: usb
        clk_io_div2_i: io_div2
        clk_io_div4_i: io_div4
      }
      clock_group: powerup
      reset_connections:
      {
        rst_ni:
        {
          name: lc_io_div4
          domain: Aon
        }
        rst_por_ni:
        {
          name: por_io_div4
          domain: Aon
        }
      }
      domain:
      [
        Aon
      ]
      param_decl:
      {
        SecCheck: "0"
      }
      attr: ipgen
      clock_connections:
      {
        clk_i: clkmgr_aon_clocks.clk_io_div4_powerup
        clk_por_i: clkmgr_aon_clocks.clk_io_div4_powerup
        clk_aon_i: clkmgr_aon_clocks.clk_aon_powerup
        clk_main_i: clkmgr_aon_clocks.clk_main_powerup
        clk_io_i: clkmgr_aon_clocks.clk_io_powerup
        clk_usb_i: clkmgr_aon_clocks.clk_usb_powerup
        clk_io_div2_i: clkmgr_aon_clocks.clk_io_div2_powerup
        clk_io_div4_i: clkmgr_aon_clocks.clk_io_div4_powerup
      }
      memory: {}
      param_list:
      [
        {
          name: SecCheck
          desc:
            '''
            When 1, enable rstmgr reset consistency checks.
            When 0, there are no consistency checks.
            '''
          type: bit
          default: "0"
          expose: "true"
          name_top: SecRstmgrAonCheck
        }
        {
          name: SecMaxSyncDelay
          desc: The maximum synchronization delay for parent / child reset checks.
          type: int
          default: "2"
          expose: "true"
          name_top: SecRstmgrAonMaxSyncDelay
        }
      ]
      inter_signal_list:
      [
        {
          name: por_n
          desc:
            '''
            Root power on reset signals from ast.
            There is one root reset signal for each core power domain.
            '''
          struct: logic
          type: uni
          act: rcv
          width: 2
          inst_name: rstmgr_aon
          default: ""
          package: ""
          external: true
          top_signame: por_n
          conn_type: false
          index: -1
        }
        {
          name: pwr
          desc:
            '''
            Reset request signals from power manager.
            Power manager can request for specific domains of the lc/sys reset tree to assert.
            '''
          struct: pwr_rst
          type: req_rsp
          act: rsp
          width: 1
          inst_name: rstmgr_aon
          default: ""
          package: pwrmgr_pkg
          top_signame: pwrmgr_aon_pwr_rst
          index: -1
        }
        {
          name: resets
          desc: Leaf resets fed to the system.
          struct: rstmgr_out
          package: rstmgr_pkg
          type: uni
          act: req
          width: 1
          inst_name: rstmgr_aon
          default: ""
          top_signame: rstmgr_aon_resets
          index: -1
        }
        {
          name: rst_en
          desc: Low-power-group outputs used by alert handler.
          struct: rstmgr_rst_en
          package: rstmgr_pkg
          type: uni
          act: req
          width: 1
          inst_name: rstmgr_aon
          default: ""
          top_signame: rstmgr_aon_rst_en
          index: -1
        }
        {
          name: alert_dump
          desc: Alert handler crash dump information.
          struct: alert_crashdump
          package: alert_pkg
          type: uni
          act: rcv
          width: 1
          inst_name: rstmgr_aon
          index: -1
        }
        {
          name: cpu_dump
          desc: Main processing element crash dump information.
          struct: cpu_crash_dump
          package: rv_core_ibex_pkg
          type: uni
          act: rcv
          width: 1
          inst_name: rstmgr_aon
          default: ""
          top_signame: rv_core_ibex_crash_dump
          index: -1
        }
        {
          name: sw_rst_req
          desc: Software requested system reset to pwrmgr.
          struct: mubi4
          package: prim_mubi_pkg
          type: uni
          act: req
          width: 1
          inst_name: rstmgr_aon
          default: ""
          end_idx: -1
          top_type: broadcast
          top_signame: rstmgr_aon_sw_rst_req
          index: -1
        }
        {
          name: tl
          struct: tl
          package: tlul_pkg
          type: req_rsp
          act: rsp
          width: 1
          inst_name: rstmgr_aon
          default: ""
          end_idx: -1
          top_signame: rstmgr_aon_tl
          index: -1
        }
      ]
      base_addrs:
      {
        null: 0x40410000
      }
    }
    {
      name: clkmgr_aon
      type: clkmgr
      clock_srcs:
      {
        clk_i: io_div4
        clk_main_i:
        {
          group: ast
          clock: main
        }
        clk_io_i:
        {
          group: ast
          clock: io
        }
        clk_usb_i:
        {
          group: ast
          clock: usb
        }
        clk_aon_i:
        {
          group: ast
          clock: aon
        }
      }
      clock_group: powerup
      reset_connections:
      {
        rst_ni:
        {
          name: por_io_div4
          domain: Aon
        }
        rst_aon_ni:
        {
          name: por_aon
          domain: Aon
        }
        rst_io_ni:
        {
          name: por_io
          domain: Aon
        }
        rst_io_div2_ni:
        {
          name: por_io_div2
          domain: Aon
        }
        rst_io_div4_ni:
        {
          name: por_io_div4
          domain: Aon
        }
        rst_main_ni:
        {
          name: por
          domain: Aon
        }
        rst_usb_ni:
        {
          name: por_usb
          domain: Aon
        }
        rst_root_ni:
        {
          name: por_io_div4
          domain: Aon
        }
        rst_root_io_ni:
        {
          name: por_io
          domain: Aon
        }
        rst_root_io_div2_ni:
        {
          name: por_io_div2
          domain: Aon
        }
        rst_root_io_div4_ni:
        {
          name: por_io_div4
          domain: Aon
        }
        rst_root_main_ni:
        {
          name: por
          domain: Aon
        }
        rst_root_usb_ni:
        {
          name: por_usb
          domain: Aon
        }
      }
      domain:
      [
        Aon
      ]
      attr: ipgen
      clock_connections:
      {
        clk_i: clkmgr_aon_clocks.clk_io_div4_powerup
        clk_main_i: clk_main_i
        clk_io_i: clk_io_i
        clk_usb_i: clk_usb_i
        clk_aon_i: clk_aon_i
      }
      param_decl: {}
      param_list: []
      inter_signal_list:
      [
        {
          name: clocks
          struct: clkmgr_out
          package: clkmgr_pkg
          type: uni
          act: req
          width: 1
          inst_name: clkmgr_aon
          default: ""
          top_signame: clkmgr_aon_clocks
          index: -1
        }
        {
          name: cg_en
          struct: clkmgr_cg_en
          package: clkmgr_pkg
          type: uni
          act: req
          width: 1
          inst_name: clkmgr_aon
          default: ""
          top_signame: clkmgr_aon_cg_en
          index: -1
        }
        {
          name: lc_hw_debug_en
          struct: lc_tx
          package: lc_ctrl_pkg
          type: uni
          act: rcv
          width: 1
          inst_name: clkmgr_aon
          index: -1
        }
        {
          name: io_clk_byp_req
          struct: mubi4
          package: prim_mubi_pkg
          type: uni
          act: req
          width: 1
          inst_name: clkmgr_aon
          default: ""
          external: true
          top_signame: io_clk_byp_req
          conn_type: false
          index: -1
        }
        {
          name: io_clk_byp_ack
          struct: mubi4
          package: prim_mubi_pkg
          type: uni
          act: rcv
          width: 1
          inst_name: clkmgr_aon
          default: ""
          external: true
          top_signame: io_clk_byp_ack
          conn_type: false
          index: -1
        }
        {
          name: all_clk_byp_req
          struct: mubi4
          package: prim_mubi_pkg
          type: uni
          act: req
          width: 1
          inst_name: clkmgr_aon
          default: ""
          external: true
          top_signame: all_clk_byp_req
          conn_type: false
          index: -1
        }
        {
          name: all_clk_byp_ack
          struct: mubi4
          package: prim_mubi_pkg
          type: uni
          act: rcv
          width: 1
          inst_name: clkmgr_aon
          default: ""
          external: true
          top_signame: all_clk_byp_ack
          conn_type: false
          index: -1
        }
        {
          name: hi_speed_sel
          struct: mubi4
          package: prim_mubi_pkg
          type: uni
          act: req
          width: 1
          inst_name: clkmgr_aon
          default: ""
          external: true
          top_signame: hi_speed_sel
          conn_type: false
          index: -1
        }
        {
          name: div_step_down_req
          struct: mubi4
          package: prim_mubi_pkg
          type: uni
          act: rcv
          width: 1
          inst_name: clkmgr_aon
          default: ""
          external: true
          top_signame: div_step_down_req
          conn_type: false
          index: -1
        }
        {
          name: lc_clk_byp_req
          struct: lc_tx
          package: lc_ctrl_pkg
          type: uni
          act: rcv
          width: 1
          inst_name: clkmgr_aon
          index: -1
        }
        {
          name: lc_clk_byp_ack
          struct: lc_tx
          package: lc_ctrl_pkg
          type: uni
          act: req
          width: 1
          inst_name: clkmgr_aon
          index: -1
        }
        {
          name: jitter_en
          struct: mubi4
          package: prim_mubi_pkg
          type: uni
          act: req
          width: 1
          inst_name: clkmgr_aon
          default: ""
          external: true
          top_signame: clk_main_jitter_en
          conn_type: false
          index: -1
        }
        {
          name: pwr
          struct: pwr_clk
          type: req_rsp
          act: rsp
          width: 1
          inst_name: clkmgr_aon
          default: ""
          package: pwrmgr_pkg
          top_signame: pwrmgr_aon_pwr_clk
          index: -1
        }
        {
          name: idle
          struct: mubi4
          package: prim_mubi_pkg
          type: uni
          act: rcv
          width: 1
          inst_name: clkmgr_aon
          default: ""
          end_idx: -1
          top_type: broadcast
          top_signame: clkmgr_aon_idle
          index: -1
        }
        {
          name: calib_rdy
          desc: Indicates clocks are calibrated and frequencies accurate
          struct: mubi4
          package: prim_mubi_pkg
          type: uni
          act: rcv
          width: 1
          default: prim_mubi_pkg::MuBi4True
          inst_name: clkmgr_aon
          index: -1
        }
        {
          name: tl
          struct: tl
          package: tlul_pkg
          type: req_rsp
          act: rsp
          width: 1
          inst_name: clkmgr_aon
          default: ""
          end_idx: -1
          top_signame: clkmgr_aon_tl
          index: -1
        }
      ]
      base_addrs:
      {
        null: 0x40420000
      }
    }
    {
      name: pinmux_aon
      type: pinmux
      clock_srcs:
      {
        clk_i: io_div4
        clk_aon_i: aon
      }
      clock_group: powerup
      reset_connections:
      {
        rst_ni:
        {
          name: lc_io_div4
          domain: Aon
        }
        rst_aon_ni:
        {
          name: sys_aon
          domain: Aon
        }
        rst_sys_ni:
        {
          name: sys_io_div4
          domain: Aon
        }
      }
      domain:
      [
        Aon
      ]
      attr: templated
      clock_connections:
      {
        clk_i: clkmgr_aon_clocks.clk_io_div4_powerup
        clk_aon_i: clkmgr_aon_clocks.clk_aon_powerup
      }
      param_decl: {}
      memory: {}
      param_list:
      [
        {
          name: SecVolatileRawUnlockEn
          desc:
            '''
            Disable (0) or enable (1) volatile RAW UNLOCK capability.
            If enabled, the strap_en_override_i input can be used to re-sample the straps at runtime.

            IMPORTANT NOTE: This should only be used in test chips. The parameter must be set
            to 0 in production tapeouts since this weakens the security posture of the RAW
            UNLOCK mechanism.
            '''
          type: bit
          default: 1'b0
          expose: "true"
          name_top: SecPinmuxAonVolatileRawUnlockEn
        }
        {
          name: TargetCfg
          desc: Target specific pinmux configuration.
          type: pinmux_pkg::target_cfg_t
          default: pinmux_pkg::DefaultTargetCfg
          expose: "true"
          name_top: PinmuxAonTargetCfg
        }
      ]
      inter_signal_list:
      [
        {
          name: lc_hw_debug_en
          desc: Debug enable qualifier coming from life cycle controller, used for HW strap qualification.
          struct: lc_tx
          package: lc_ctrl_pkg
          type: uni
          act: rcv
          width: 1
          default: lc_ctrl_pkg::Off
          inst_name: pinmux_aon
          index: -1
        }
        {
          name: lc_dft_en
          desc: Test enable qualifier coming from life cycle controller, used for HW strap qualification.
          struct: lc_tx
          package: lc_ctrl_pkg
          type: uni
          act: rcv
          width: 1
          default: lc_ctrl_pkg::Off
          inst_name: pinmux_aon
          index: -1
        }
        {
          name: lc_escalate_en
          desc:
            '''
            Escalation enable signal coming from life cycle controller, used for invalidating
            the latched lc_hw_debug_en state inside the strap sampling logic.
            '''
          struct: lc_tx
          package: lc_ctrl_pkg
          type: uni
          act: rcv
          width: 1
          default: lc_ctrl_pkg::Off
          inst_name: pinmux_aon
          index: -1
        }
        {
          name: lc_check_byp_en
          desc:
            '''
            Check bypass enable signal coming from life cycle controller, used for invalidating
            the latched lc_hw_debug_en state inside the strap sampling logic. This signal is asserted
            whenever the life cycle controller performs a life cycle transition. Its main use is
            to skip any background checks inside the life cycle partition of the OTP controller while
            a life cycle transition is in progress.
            '''
          struct: lc_tx
          package: lc_ctrl_pkg
          type: uni
          act: rcv
          width: 1
          default: lc_ctrl_pkg::Off
          inst_name: pinmux_aon
          index: -1
        }
        {
          name: pinmux_hw_debug_en
          desc:
            '''
            This is the latched version of lc_hw_debug_en_i. We use it exclusively to gate the JTAG
            signals and TAP side of the RV_DM so that RV_DM can remain live during an NDM reset cycle.
            '''
          struct: lc_tx
          package: lc_ctrl_pkg
          type: uni
          act: req
          width: 1
          default: lc_ctrl_pkg::Off
          inst_name: pinmux_aon
          index: -1
        }
        {
          name: lc_jtag
          desc: Qualified JTAG signals for life cycle controller TAP.
          struct: jtag
          package: jtag_pkg
          type: req_rsp
          act: req
          width: 1
          inst_name: pinmux_aon
          index: -1
        }
        {
          name: rv_jtag
          desc: Qualified JTAG signals for RISC-V processor TAP.
          struct: jtag
          package: jtag_pkg
          type: req_rsp
          act: req
          width: 1
          inst_name: pinmux_aon
          index: -1
        }
        {
          name: dft_jtag
          desc: Qualified JTAG signals for DFT TAP.
          struct: jtag
          package: jtag_pkg
          type: req_rsp
          act: req
          width: 1
          inst_name: pinmux_aon
          default: ""
          top_signame: pinmux_aon_dft_jtag
          index: -1
        }
        {
          name: dft_strap_test
          desc: Sampled DFT strap values, going to the DFT TAP.
          struct: dft_strap_test_req
          package: pinmux_pkg
          type: uni
          act: req
          width: 1
          default: "'0"
          inst_name: pinmux_aon
          external: true
          top_signame: dft_strap_test
          conn_type: false
          index: -1
        }
        {
          name: dft_hold_tap_sel
          desc: TAP selection hold indication, asserted by the DFT TAP during boundary scan.
          struct: logic
          type: uni
          act: rcv
          width: 1
          default: "'0"
          inst_name: pinmux_aon
          package: ""
          external: true
          top_signame: dft_hold_tap_sel
          conn_type: false
          index: -1
        }
        {
          name: sleep_en
          desc: Level signal that is asserted when the power manager enters sleep.
          struct: logic
          type: uni
          act: rcv
          width: 1
          default: 1'b0
          inst_name: pinmux_aon
          package: ""
          top_signame: pwrmgr_aon_low_power
          index: -1
        }
        {
          name: strap_en
          desc: This signal is pulsed high by the power manager after reset in order to sample the HW straps.
          struct: logic
          type: uni
          act: rcv
          width: 1
          default: 1'b0
          inst_name: pinmux_aon
          package: ""
          top_signame: pwrmgr_aon_strap
          index: -1
        }
        {
          name: strap_en_override
          desc:
            '''
            This signal transitions from 0 -> 1 by the lc_ctrl manager after volatile RAW_UNLOCK in order to re-sample the HW straps.
            The signal must stay at 1 until reset.
            Note that this is only used in test chips when SecVolatileRawUnlockEn = 1.
            Otherwise this signal is unused.
            '''
          struct: logic
          type: uni
          act: rcv
          width: 1
          default: 1'b0
          inst_name: pinmux_aon
          index: -1
        }
        {
          name: pin_wkup_req
          desc: Wakeup request from wakeup detectors, to the power manager, running on the AON clock.
          struct: logic
          type: uni
          act: req
          width: 1
          default: 1'b0
          inst_name: pinmux_aon
          package: ""
          top_signame: pwrmgr_aon_wakeups
          index: 0
        }
        {
          name: usbdev_dppullup_en
          desc: Pullup enable signal coming from the USB IP.
          struct: logic
          type: uni
          act: rcv
          width: 1
          inst_name: pinmux_aon
          default: ""
          package: ""
          top_signame: usbdev_usb_dp_pullup
          index: -1
        }
        {
          name: usbdev_dnpullup_en
          desc: Pullup enable signal coming from the USB IP.
          struct: logic
          type: uni
          act: rcv
          width: 1
          inst_name: pinmux_aon
          default: ""
          package: ""
          top_signame: usbdev_usb_dn_pullup
          index: -1
        }
        {
          name: usb_dppullup_en
          desc: " Pullup enable signal going to USB PHY, needs to be maintained in low-power mode."
          struct: logic
          type: uni
          act: req
          width: 1
          default: 1'b0
          inst_name: pinmux_aon
          package: ""
          external: true
          top_signame: usb_dp_pullup_en
          conn_type: false
          index: -1
        }
        {
          name: usb_dnpullup_en
          desc: Pullup enable signal going to USB PHY, needs to be maintained in low-power mode.
          struct: logic
          type: uni
          act: req
          width: 1
          default: 1'b0
          inst_name: pinmux_aon
          package: ""
          external: true
          top_signame: usb_dn_pullup_en
          conn_type: false
          index: -1
        }
        {
          name: usb_wkup_req
          desc: Wakeup request from USB wakeup detector, going to the power manager, running on the AON clock.
          struct: logic
          type: uni
          act: req
          width: 1
          default: 1'b0
          inst_name: pinmux_aon
          package: ""
          top_signame: pwrmgr_aon_wakeups
          index: 1
        }
        {
          name: usbdev_suspend_req
          desc: Indicates whether USB is in suspended state, coming from the USB device.
          struct: logic
          type: uni
          act: rcv
          width: 1
          inst_name: pinmux_aon
          default: ""
          package: ""
          top_signame: usbdev_usb_aon_suspend_req
          index: -1
        }
        {
          name: usbdev_wake_ack
          desc: Acknowledges the USB wakeup request, coming from the USB device.
          struct: logic
          type: uni
          act: rcv
          width: 1
          inst_name: pinmux_aon
          default: ""
          package: ""
          top_signame: usbdev_usb_aon_wake_ack
          index: -1
        }
        {
          name: usbdev_bus_not_idle
          desc: Event signal that indicates that the USB was not idle while monitoring.
          struct: logic
          type: uni
          act: req
          width: 1
          default: 1'b0
          inst_name: pinmux_aon
          index: -1
        }
        {
          name: usbdev_bus_reset
          desc: Event signal that indicates that the USB issued a Bus Reset while monitoring.
          struct: logic
          type: uni
          act: req
          width: 1
          default: 1'b0
          inst_name: pinmux_aon
          package: ""
          top_signame: usbdev_usb_aon_bus_reset
          index: -1
        }
        {
          name: usbdev_sense_lost
          desc: Event signal that indicates that USB SENSE signal was lost while monitoring.
          struct: logic
          type: uni
          act: req
          width: 1
          default: 1'b0
          inst_name: pinmux_aon
          package: ""
          top_signame: usbdev_usb_aon_sense_lost
          index: -1
        }
        {
          name: usbdev_wake_detect_active
          desc: State debug information.
          struct: logic
          type: uni
          act: req
          width: 1
          default: 1'b0
          inst_name: pinmux_aon
          package: ""
          end_idx: -1
          top_type: broadcast
          top_signame: pinmux_aon_usbdev_wake_detect_active
          index: -1
        }
        {
          name: tl
          struct: tl
          package: tlul_pkg
          type: req_rsp
          act: rsp
          width: 1
          inst_name: pinmux_aon
          default: ""
          end_idx: -1
          top_signame: pinmux_aon_tl
          index: -1
        }
      ]
      base_addrs:
      {
        null: 0x40460000
      }
    }
    {
      name: aon_timer_aon
      type: aon_timer
      clock_srcs:
      {
        clk_i: io_div4
        clk_aon_i: aon
      }
      clock_group: timers
      reset_connections:
      {
        rst_ni:
        {
          name: sys_io_div4
          domain: Aon
        }
        rst_aon_ni:
        {
          name: sys_aon
          domain: Aon
        }
      }
      domain:
      [
        Aon
      ]
      clock_connections:
      {
        clk_i: clkmgr_aon_clocks.clk_io_div4_timers
        clk_aon_i: clkmgr_aon_clocks.clk_aon_timers
      }
      param_decl: {}
      param_list: []
      inter_signal_list:
      [
        {
          name: nmi_wdog_timer_bark
          struct: logic
          type: uni
          act: req
          width: 1
          default: 1'b0
          inst_name: aon_timer_aon
          index: -1
        }
        {
          name: wkup_req
          struct: logic
          type: uni
          act: req
          width: 1
          default: 1'b0
          inst_name: aon_timer_aon
          package: ""
          top_signame: pwrmgr_aon_wakeups
          index: 2
        }
        {
          name: aon_timer_rst_req
          struct: logic
          type: uni
          act: req
          width: 1
          default: 1'b0
          inst_name: aon_timer_aon
          package: ""
          top_signame: pwrmgr_aon_rstreqs
          index: -1
        }
        {
          name: lc_escalate_en
          struct: lc_tx
          package: lc_ctrl_pkg
          type: uni
          act: rcv
          width: 1
          default: lc_ctrl_pkg::Off
          inst_name: aon_timer_aon
          index: -1
        }
        {
          name: sleep_mode
          struct: logic
          type: uni
          act: rcv
          width: 1
          inst_name: aon_timer_aon
          default: ""
          package: ""
          top_signame: pwrmgr_aon_low_power
          index: -1
        }
        {
          name: tl
          struct: tl
          package: tlul_pkg
          type: req_rsp
          act: rsp
          width: 1
          inst_name: aon_timer_aon
          index: -1
        }
      ]
      base_addrs:
      {
        null: 0x40470000
      }
    }
    {
      name: ast
      type: ast
      clock_srcs:
      {
        clk_ast_tlul_i: io_div4
        clk_ast_adc_i: aon
        clk_ast_alert_i: io_div4
        clk_ast_es_i: main
        clk_ast_rng_i: main
        clk_ast_usb_i:
        {
          clock: usb
          group: peri
        }
      }
      clock_group: secure
      reset_connections:
      {
        rst_ast_tlul_ni:
        {
          name: lc_io_div4
          domain: "0"
        }
        rst_ast_adc_ni:
        {
          name: sys_aon
          domain: "0"
        }
        rst_ast_alert_ni:
        {
          name: lc_io_div4
          domain: "0"
        }
        rst_ast_es_ni:
        {
          name: sys
          domain: "0"
        }
        rst_ast_rng_ni:
        {
          name: sys
          domain: "0"
        }
        rst_ast_usb_ni:
        {
          name: usb
          domain: "0"
        }
      }
      attr: reggen_only
      clock_connections:
      {
        clk_ast_tlul_i: clkmgr_aon_clocks.clk_io_div4_secure
        clk_ast_adc_i: clkmgr_aon_clocks.clk_aon_secure
        clk_ast_alert_i: clkmgr_aon_clocks.clk_io_div4_secure
        clk_ast_es_i: clkmgr_aon_clocks.clk_main_secure
        clk_ast_rng_i: clkmgr_aon_clocks.clk_main_secure
        clk_ast_usb_i: clkmgr_aon_clocks.clk_usb_peri
      }
      domain:
      [
        "0"
      ]
      param_decl: {}
      param_list: []
      inter_signal_list:
      [
        {
          name: tl
          struct: tl
          package: tlul_pkg
          type: req_rsp
          act: rsp
          width: 1
          inst_name: ast
          index: -1
        }
      ]
      base_addrs:
      {
        null: 0x40480000
      }
    }
    {
      name: flash_ctrl
      type: flash_ctrl
      clock_srcs:
      {
        clk_i: main
        clk_otp_i: io_div4
      }
      clock_group: infra
      reset_connections:
      {
        rst_ni:
        {
          name: lc
          domain: "0"
        }
        rst_otp_ni:
        {
          name: lc_io_div4
          domain: "0"
        }
      }
      base_addrs:
      {
        core: 0x41000000
        prim: 0x41008000
        mem: 0x20000000
      }
      param_decl:
      {
        SecScrambleEn: "0"
      }
      memory:
      {
        mem:
        {
          label: eflash
          swaccess: ro
          exec: True
          byte_write: False
          config:
          {
            banks: 2
            pages_per_bank: 16
            program_resolution: 8
            pgm_resolution_bytes: 64
            bytes_per_page: 2048
            bytes_per_bank: 32768
            size: 0x10000
          }
          size: 0x10000
        }
      }
      attr: ipgen
      clock_connections:
      {
        clk_i: clkmgr_aon_clocks.clk_main_infra
        clk_otp_i: clkmgr_aon_clocks.clk_io_div4_infra
      }
      domain:
      [
        "0"
      ]
      param_list:
      [
        {
          name: RndCnstAddrKey
          desc: Compile-time random bits for default address key
          type: flash_ctrl_pkg::flash_key_t
          randcount: 128
          randtype: data
          name_top: RndCnstFlashCtrlAddrKey
          default: 0x9e90f8e65f8cdc028e681edcb14cb2e8
          randwidth: 128
        }
        {
          name: RndCnstDataKey
          desc: Compile-time random bits for default data key
          type: flash_ctrl_pkg::flash_key_t
          randcount: 128
          randtype: data
          name_top: RndCnstFlashCtrlDataKey
          default: 0x1c9634b9fa84fec1ccc9e2525b4acfbe
          randwidth: 128
        }
        {
          name: RndCnstAllSeeds
          desc: Compile-time random bits for default seeds
          type: flash_ctrl_pkg::all_seeds_t
          randcount: 512
          randtype: data
          name_top: RndCnstFlashCtrlAllSeeds
          default: 0xf1354b0969540f0f285312fd274e1f6136763b10aef74fea8020040b2a0b515ed5e666d771ef5001237710feb20a90edffd46b00ce07c1b5411e793482c8143e
          randwidth: 512
        }
        {
          name: RndCnstLfsrSeed
          desc: Compile-time random bits for initial LFSR seed
          type: flash_ctrl_pkg::lfsr_seed_t
          randcount: 32
          randtype: data
          name_top: RndCnstFlashCtrlLfsrSeed
          default: 0x6ae2b721
          randwidth: 32
        }
        {
          name: RndCnstLfsrPerm
          desc: Compile-time random permutation for LFSR output
          type: flash_ctrl_pkg::lfsr_perm_t
          randcount: 32
          randtype: perm
          name_top: RndCnstFlashCtrlLfsrPerm
          default: 0x757edcd0d2e4d0b4eae27d831600b8e906756e1e
          randwidth: 160
        }
        {
          name: SecScrambleEn
          desc: Compile-time option to enable flash scrambling
          type: bit
          default: "0"
          expose: "true"
          name_top: SecFlashCtrlScrambleEn
        }
        {
          name: ProgFifoDepth
          desc: Depth of program fifo
          type: int
          default: "16"
          expose: "true"
          name_top: FlashCtrlProgFifoDepth
        }
        {
          name: RdFifoDepth
          desc: Depth of read fifo
          type: int
          default: "16"
          expose: "true"
          name_top: FlashCtrlRdFifoDepth
        }
      ]
      inter_signal_list:
      [
        {
          name: otp
          struct: flash_otp_key
          package: otp_ctrl_pkg
          type: req_rsp
          act: req
          width: 1
          inst_name: flash_ctrl
          index: -1
        }
        {
          name: lc_nvm_debug_en
          struct: lc_tx
          package: lc_ctrl_pkg
          type: uni
          act: rcv
          width: 1
          inst_name: flash_ctrl
          index: -1
        }
        {
          name: flash_bist_enable
          struct: mubi4
          package: prim_mubi_pkg
          type: uni
          act: rcv
          width: 1
          inst_name: flash_ctrl
          default: ""
          external: true
          top_signame: flash_bist_enable
          conn_type: false
          index: -1
        }
        {
          name: flash_power_down_h
          struct: logic
          type: uni
          act: rcv
          width: 1
          inst_name: flash_ctrl
          default: ""
          package: ""
          external: true
          top_signame: flash_power_down_h
          conn_type: false
          index: -1
        }
        {
          name: flash_power_ready_h
          struct: logic
          type: uni
          act: rcv
          width: 1
          inst_name: flash_ctrl
          default: ""
          package: ""
          external: true
          top_signame: flash_power_ready_h
          conn_type: false
          index: -1
        }
        {
          name: flash_test_mode_a
          struct: ""
          type: io
          act: none
          width: 2
          inst_name: flash_ctrl
          index: -1
        }
        {
          name: flash_test_voltage_h
          struct: ""
          type: io
          act: none
          width: 1
          inst_name: flash_ctrl
          index: -1
        }
        {
          name: lc_creator_seed_sw_rw_en
          struct: lc_tx
          package: lc_ctrl_pkg
          type: uni
          act: rcv
          width: 1
          inst_name: flash_ctrl
          index: -1
        }
        {
          name: lc_owner_seed_sw_rw_en
          struct: lc_tx
          package: lc_ctrl_pkg
          type: uni
          act: rcv
          width: 1
          inst_name: flash_ctrl
          index: -1
        }
        {
          name: lc_iso_part_sw_rd_en
          struct: lc_tx
          package: lc_ctrl_pkg
          type: uni
          act: rcv
          width: 1
          inst_name: flash_ctrl
          index: -1
        }
        {
          name: lc_iso_part_sw_wr_en
          struct: lc_tx
          package: lc_ctrl_pkg
          type: uni
          act: rcv
          width: 1
          inst_name: flash_ctrl
          index: -1
        }
        {
          name: lc_seed_hw_rd_en
          struct: lc_tx
          package: lc_ctrl_pkg
          type: uni
          act: rcv
          width: 1
          inst_name: flash_ctrl
          index: -1
        }
        {
          name: lc_escalate_en
          struct: lc_tx
          package: lc_ctrl_pkg
          type: uni
          act: rcv
          width: 1
          inst_name: flash_ctrl
          index: -1
        }
        {
          name: rma_req
          struct: lc_tx
          package: lc_ctrl_pkg
          type: uni
          act: rcv
          width: 1
          inst_name: flash_ctrl
          index: -1
        }
        {
          name: rma_ack
          struct: lc_tx
          package: lc_ctrl_pkg
          type: uni
          act: req
          width: 1
          inst_name: flash_ctrl
          index: -1
        }
        {
          name: rma_seed
          struct: lc_flash_rma_seed
          package: lc_ctrl_pkg
          type: uni
          act: rcv
          width: 1
          inst_name: flash_ctrl
          index: -1
        }
        {
          name: pwrmgr
          struct: pwr_flash
          package: pwrmgr_pkg
          type: uni
          act: req
          width: 1
          inst_name: flash_ctrl
          default: ""
          top_signame: pwrmgr_aon_pwr_flash
          index: -1
        }
        {
          name: keymgr
          struct: keymgr_flash
          package: flash_ctrl_pkg
          type: uni
          act: req
          width: 1
          inst_name: flash_ctrl
          index: -1
        }
        {
          name: obs_ctrl
          struct: ast_obs_ctrl
          package: ast_pkg
          type: uni
          act: rcv
          width: 1
          inst_name: flash_ctrl
          default: ""
          external: true
          top_signame: obs_ctrl
          conn_type: false
          index: -1
        }
        {
          name: fla_obs
          struct: logic
          type: uni
          act: req
          width: 8
          inst_name: flash_ctrl
          default: ""
          package: ""
          external: true
          top_signame: flash_obs
          conn_type: false
          index: -1
        }
        {
          name: core_tl
          struct: tl
          package: tlul_pkg
          type: req_rsp
          act: rsp
          width: 1
          inst_name: flash_ctrl
          default: ""
          end_idx: -1
          top_signame: flash_ctrl_core_tl
          index: -1
        }
        {
          name: prim_tl
          struct: tl
          package: tlul_pkg
          type: req_rsp
          act: rsp
          width: 1
          inst_name: flash_ctrl
          default: ""
          end_idx: -1
          top_signame: flash_ctrl_prim_tl
          index: -1
        }
        {
          name: mem_tl
          struct: tl
          package: tlul_pkg
          type: req_rsp
          act: rsp
          width: 1
          inst_name: flash_ctrl
          default: ""
          end_idx: -1
          top_signame: flash_ctrl_mem_tl
          index: -1
        }
      ]
    }
    {
      name: rv_plic
      type: rv_plic
      clock_srcs:
      {
        clk_i: main
      }
      clock_group: secure
      reset_connections:
      {
        rst_ni:
        {
          name: sys
          domain: "0"
        }
      }
      attr: ipgen
      clock_connections:
      {
        clk_i: clkmgr_aon_clocks.clk_main_secure
      }
      domain:
      [
        "0"
      ]
      param_decl: {}
      param_list: []
      inter_signal_list:
      [
        {
          name: irq
          struct: logic
          type: uni
          act: req
          width: 1
          inst_name: rv_plic
          default: ""
          package: ""
          end_idx: -1
          top_type: broadcast
          top_signame: rv_plic_irq
          index: -1
        }
        {
          name: irq_id
          struct: logic
          type: uni
          act: req
          width: 1
          inst_name: rv_plic
          index: -1
        }
        {
          name: msip
          struct: logic
          type: uni
          act: req
          width: 1
          inst_name: rv_plic
          default: ""
          package: ""
          end_idx: -1
          top_type: broadcast
          top_signame: rv_plic_msip
          index: -1
        }
        {
          name: tl
          struct: tl
          package: tlul_pkg
          type: req_rsp
          act: rsp
          width: 1
          inst_name: rv_plic
          default: ""
          end_idx: -1
          top_signame: rv_plic_tl
          index: -1
        }
      ]
      base_addrs:
      {
        null: 0x48000000
      }
    }
    {
      name: aes
      type: aes
      clock_srcs:
      {
        clk_i: main
        clk_edn_i: main
      }
      clock_group: trans
      reset_connections:
      {
        rst_ni:
        {
          name: sys
          domain: "0"
        }
        rst_edn_ni:
        {
          name: sys
          domain: "0"
        }
      }
      param_decl:
      {
        SecMasking: "1"
        SecSBoxImpl: aes_pkg::SBoxImplDom
      }
      clock_connections:
      {
        clk_i: clkmgr_aon_clocks.clk_main_aes
        clk_edn_i: clkmgr_aon_clocks.clk_main_aes
      }
      domain:
      [
        "0"
      ]
      memory: {}
      param_list:
      [
        {
          name: AES192Enable
          desc: Disable (0) or enable (1) support for 192-bit key lengths (AES-192).
          type: bit
          default: 1'b1
          expose: "false"
          name_top: AesAES192Enable
        }
        {
          name: SecMasking
          desc:
            '''
            Disable (0) or enable (1) first-order masking of the AES cipher core.
            Masking requires the use of a masked S-Box, see SecSBoxImpl parameter.
            '''
          type: bit
          default: "1"
          expose: "true"
          name_top: SecAesMasking
        }
        {
          name: SecSBoxImpl
          desc: Selection of the S-Box implementation. See aes_pkg.sv.
          type: aes_pkg::sbox_impl_e
          default: aes_pkg::SBoxImplDom
          expose: "true"
          name_top: SecAesSBoxImpl
        }
        {
          name: SecStartTriggerDelay
          desc:
            '''
            Manual start trigger delay, useful for SCA measurements.
            A value of e.g. 40 allows the processor to go into sleep before AES starts operation.
            '''
          type: int unsigned
          default: "0"
          expose: "true"
          name_top: SecAesStartTriggerDelay
        }
        {
          name: SecAllowForcingMasks
          desc:
            '''
            Forbid (0) or allow (1) forcing the masking PRNG output to a constant value via FORCE_MASKS bit in the Auxiliary Control Register.
            Useful for SCA measurements.
            Meaningful only if masking is enabled.
            '''
          type: bit
          default: 1'b0
          expose: "true"
          name_top: SecAesAllowForcingMasks
        }
        {
          name: SecSkipPRNGReseeding
          desc:
            '''
            Perform (0) or skip (1) PRNG reseeding requests, useful for SCA measurements only.
            The current SCA setup doesn't provide sufficient resources to implement the infrastructure required for PRNG reseeding (CSRNG, EDN).
            To enable SCA resistance evaluations, we need to skip reseeding requests on the SCA platform.
            '''
          type: bit
          default: 1'b0
          expose: "true"
          name_top: SecAesSkipPRNGReseeding
        }
        {
          name: RndCnstClearingLfsrSeed
          desc: Default seed of the PRNG used for register clearing.
          type: aes_pkg::clearing_lfsr_seed_t
          randcount: 64
          randtype: data
          name_top: RndCnstAesClearingLfsrSeed
          default: 0xc5a44f9dc00a807e
          randwidth: 64
        }
        {
          name: RndCnstClearingLfsrPerm
          desc: Permutation applied to the LFSR of the PRNG used for clearing.
          type: aes_pkg::clearing_lfsr_perm_t
          randcount: 64
          randtype: perm
          name_top: RndCnstAesClearingLfsrPerm
          default: 0x80e79cf48b437e73292eb407c40d04ff2c3b476cf9368e136d55d650f912f1a882f89d5d877baf1bab18a819a58d9285
          randwidth: 384
        }
        {
          name: RndCnstClearingSharePerm
          desc: Permutation applied to the clearing PRNG output for clearing the second share of registers.
          type: aes_pkg::clearing_lfsr_perm_t
          randcount: 64
          randtype: perm
          name_top: RndCnstAesClearingSharePerm
          default: 0x80d40cbf860e22779193a5f54b4d997d60d3f2b9a3c4af4754497f09bca214ba3bc1d6aa073e5c86ef8f254dedb29180
          randwidth: 384
        }
        {
          name: RndCnstMaskingLfsrSeed
          desc: Default seed of the PRNG used for masking.
          type: aes_pkg::masking_lfsr_seed_t
          randcount: 288
          randtype: data
          name_top: RndCnstAesMaskingLfsrSeed
          default: 0xff657fc29427d0f48aad106e3859890c0902355895a38418fa02e1245e46fac24fa1fc04
          randwidth: 288
        }
        {
          name: RndCnstMaskingLfsrPerm
          desc: Permutation applied to the output of the PRNG used for masking.
          type: aes_pkg::masking_lfsr_perm_t
          randcount: 160
          randtype: perm
          name_top: RndCnstAesMaskingLfsrPerm
          default: 0x9d12152e8b3c0f99008d951071673b882f61057f1e7b16685439498c5f34735a4f59705b7437751a369c0c64291b4b2c879a657a9b254a2076401d246d06698f5277010357433197483242189019932b7c9f274d08603a358545621f2a81500e923d51786c2d46021c6e445e589e72803f66418e6b6f6a170d565d8a82237d79949809330b4c530a9186846389133830048326963e4e1147555c07221421287e
          randwidth: 1280
        }
      ]
      inter_signal_list:
      [
        {
          name: idle
          struct: mubi4
          package: prim_mubi_pkg
          type: uni
          act: req
          width: 1
          inst_name: aes
          default: ""
          top_signame: clkmgr_aon_idle
          index: -1
        }
        {
          name: lc_escalate_en
          struct: lc_tx
          package: lc_ctrl_pkg
          type: uni
          act: rcv
          width: 1
          default: lc_ctrl_pkg::Off
          inst_name: aes
          index: -1
        }
        {
          name: edn
          struct: edn
          package: edn_pkg
          type: req_rsp
          act: req
          width: 1
          inst_name: aes
          index: -1
        }
        {
          name: keymgr_key
          struct: hw_key_req
          package: keymgr_pkg
          type: uni
          act: rcv
          width: 1
          inst_name: aes
          index: -1
        }
        {
          name: tl
          struct: tl
          package: tlul_pkg
          type: req_rsp
          act: rsp
          width: 1
          inst_name: aes
          default: ""
          end_idx: -1
          top_signame: aes_tl
          index: -1
        }
      ]
      base_addrs:
      {
        null: 0x41100000
      }
    }
    {
      name: sram_ctrl_main
      type: sram_ctrl
      clock_srcs:
      {
        clk_i: main
        clk_otp_i: io_div4
      }
      clock_group: secure
      reset_connections:
      {
        rst_ni:
        {
          name: sys
          domain: "0"
        }
        rst_otp_ni:
        {
          name: lc_io_div4
          domain: "0"
        }
      }
      param_decl:
      {
        InstrExec: "1"
      }
      base_addrs:
      {
        regs: 0x411C0000
        ram: 0x10000000
      }
      memory:
      {
        ram:
        {
          label: ram_main
          swaccess: rw
          exec: True
          byte_write: True
          size: 0x20000
        }
      }
      clock_connections:
      {
        clk_i: clkmgr_aon_clocks.clk_main_secure
        clk_otp_i: clkmgr_aon_clocks.clk_io_div4_secure
      }
      domain:
      [
        "0"
      ]
      param_list:
      [
        {
          name: RndCnstSramKey
          desc: Compile-time random reset value for SRAM scrambling key.
          type: otp_ctrl_pkg::sram_key_t
          randcount: 128
          randtype: data
          name_top: RndCnstSramCtrlMainSramKey
          default: 0xa84afd110e65e2c09d4012491ac45c2d
          randwidth: 128
        }
        {
          name: RndCnstSramNonce
          desc: Compile-time random reset value for SRAM scrambling nonce.
          type: otp_ctrl_pkg::sram_nonce_t
          randcount: 128
          randtype: data
          name_top: RndCnstSramCtrlMainSramNonce
          default: 0x7799e699c02a50aee3b25af703b953b
          randwidth: 128
        }
        {
          name: RndCnstLfsrSeed
          desc: Compile-time random bits for initial LFSR seed
          type: sram_ctrl_pkg::lfsr_seed_t
          randcount: 32
          randtype: data
          name_top: RndCnstSramCtrlMainLfsrSeed
          default: 0x72c25acd
          randwidth: 32
        }
        {
          name: RndCnstLfsrPerm
          desc: Compile-time random permutation for LFSR output
          type: sram_ctrl_pkg::lfsr_perm_t
          randcount: 32
          randtype: perm
          name_top: RndCnstSramCtrlMainLfsrPerm
          default: 0x70f1c20229aef41baec26351432b3283cb33fbbf
          randwidth: 160
        }
        {
          name: MemSizeRam
          desc: Memory size of the RAM (in bytes).
          type: int
          name_top: MemSizeSramCtrlMainRam
          default: 131072
        }
        {
          name: InstrExec
          desc: Support execution from SRAM
          type: bit
          default: "1"
          expose: "true"
          name_top: SramCtrlMainInstrExec
        }
        {
          name: NumPrinceRoundsHalf
          desc: Number of PRINCE half rounds for the SRAM scrambling feature
          type: int
          default: "3"
          expose: "true"
          name_top: SramCtrlMainNumPrinceRoundsHalf
        }
      ]
      inter_signal_list:
      [
        {
          name: sram_otp_key
          struct: sram_otp_key
          package: otp_ctrl_pkg
          type: req_rsp
          act: req
          width: 1
          inst_name: sram_ctrl_main
          index: -1
        }
        {
          name: cfg
          struct: ram_1p_cfg
          package: prim_ram_1p_pkg
          type: uni
          act: rcv
          width: 1
          default: "'0"
          inst_name: sram_ctrl_main
          index: -1
        }
        {
          name: lc_escalate_en
          struct: lc_tx
          package: lc_ctrl_pkg
          type: uni
          act: rcv
          width: 1
          default: lc_ctrl_pkg::Off
          inst_name: sram_ctrl_main
          index: -1
        }
        {
          name: lc_hw_debug_en
          struct: lc_tx
          package: lc_ctrl_pkg
          type: uni
          act: rcv
          width: 1
          default: lc_ctrl_pkg::Off
          inst_name: sram_ctrl_main
          index: -1
        }
        {
          name: otp_en_sram_ifetch
          struct: mubi8
          package: prim_mubi_pkg
          type: uni
          act: rcv
          width: 1
          default: prim_mubi_pkg::MuBi8False
          inst_name: sram_ctrl_main
          top_signame: sram_ctrl_main_otp_en_sram_ifetch
          index: -1
        }
        {
          name: regs_tl
          struct: tl
          package: tlul_pkg
          type: req_rsp
          act: rsp
          width: 1
          inst_name: sram_ctrl_main
          default: ""
          end_idx: -1
          top_signame: sram_ctrl_main_regs_tl
          index: -1
        }
        {
          name: ram_tl
          struct: tl
          package: tlul_pkg
          type: req_rsp
          act: rsp
          width: 1
          inst_name: sram_ctrl_main
          default: ""
          end_idx: -1
          top_signame: sram_ctrl_main_ram_tl
          index: -1
        }
      ]
    }
    {
      name: rom_ctrl
      type: rom_ctrl
      clock_srcs:
      {
        clk_i: main
      }
      clock_group: infra
      reset_connections:
      {
        rst_ni:
        {
          name: sys
          domain: "0"
        }
      }
      base_addrs:
      {
        rom: 0x00008000
        regs: 0x411e0000
      }
      memory:
      {
        rom:
        {
          label: rom
          swaccess: ro
          exec: True
          byte_write: False
          size: 0x8000
        }
      }
      param_decl:
      {
        SecDisableScrambling: 1'b1
      }
      clock_connections:
      {
        clk_i: clkmgr_aon_clocks.clk_main_infra
      }
      domain:
      [
        "0"
      ]
      param_list:
      [
        {
          name: BootRomInitFile
          desc: Contents of ROM
          type: ""
          default: '''""'''
          expose: "true"
          name_top: RomCtrlBootRomInitFile
        }
        {
          name: RndCnstScrNonce
          desc: Fixed nonce used for address / data scrambling
          type: bit [63:0]
          randcount: 64
          randtype: data
          name_top: RndCnstRomCtrlScrNonce
          default: 0xa055cd153e14afcf
          randwidth: 64
        }
        {
          name: RndCnstScrKey
          desc: Randomised constant used as a scrambling key for ROM data
          type: bit [127:0]
          randcount: 128
          randtype: data
          name_top: RndCnstRomCtrlScrKey
          default: 0xaf2b8b9ba0eeeeeab949b4462a2e7e3b
          randwidth: 128
        }
        {
          name: SecDisableScrambling
          desc:
            '''
            Disable scrambling and checking in rom_ctrl, turning the block into a
            simple ROM wrapper. This isn't intended for real chips, but is useful
            for small FPGA targets where there's not space for the PRINCE
            primitives.
            '''
          type: bit
          default: 1'b1
          expose: "true"
          name_top: SecRomCtrlDisableScrambling
        }
        {
          name: MemSizeRom
          desc: Memory size of the ROM (in bytes).
          type: int
          name_top: MemSizeRomCtrlRom
          default: 32768
        }
      ]
      inter_signal_list:
      [
        {
          name: rom_cfg
          struct: rom_cfg
          package: prim_rom_pkg
          type: uni
          act: rcv
          width: 1
          inst_name: rom_ctrl
          index: -1
        }
        {
          name: pwrmgr_data
          struct: pwrmgr_data
          package: rom_ctrl_pkg
          type: uni
          act: req
          width: 1
          inst_name: rom_ctrl
          index: -1
        }
        {
          name: keymgr_data
          struct: keymgr_data
          package: rom_ctrl_pkg
          type: uni
          act: req
          width: 1
          inst_name: rom_ctrl
          index: -1
        }
        {
          name: kmac_data
          struct: app
          package: kmac_pkg
          type: req_rsp
          act: req
          width: 1
          inst_name: rom_ctrl
          index: -1
        }
        {
          name: regs_tl
          struct: tl
          package: tlul_pkg
          type: req_rsp
          act: rsp
          width: 1
          inst_name: rom_ctrl
          default: ""
          end_idx: -1
          top_signame: rom_ctrl_regs_tl
          index: -1
        }
        {
          name: rom_tl
          struct: tl
          package: tlul_pkg
          type: req_rsp
          act: rsp
          width: 1
          inst_name: rom_ctrl
          default: ""
          end_idx: -1
          top_signame: rom_ctrl_rom_tl
          index: -1
        }
      ]
    }
    {
      name: rv_core_ibex
      type: rv_core_ibex
      param_decl:
      {
        PMPEnable: "0"
        PMPGranularity: "0"
        PMPNumRegions: "16"
        MHPMCounterNum: "0"
        MHPMCounterWidth: "32"
        RV32E: "0"
        RV32M: ibex_pkg::RV32MSingleCycle
        RV32B: ibex_pkg::RV32BNone
        RegFile: ibex_pkg::RegFileFF
        BranchTargetALU: "1"
        WritebackStage: "1"
        ICache: "0"
        ICacheECC: "0"
        BranchPredictor: "0"
        DbgTriggerEn: "1"
        SecureIbex: "0"
        DmHaltAddr: "0"
        DmExceptionAddr: "0"
        PipeLine: "0"
      }
      clock_srcs:
      {
        clk_i: main
        clk_edn_i: main
        clk_esc_i: io_div4
        clk_otp_i: io_div4
      }
      clock_group: infra
      reset_connections:
      {
        rst_ni:
        {
          name: sys
          domain: "0"
        }
        rst_edn_ni:
        {
          name: sys
          domain: "0"
        }
        rst_esc_ni:
        {
          name: lc_io_div4
          domain: "0"
        }
        rst_otp_ni:
        {
          name: lc_io_div4
          domain: "0"
        }
      }
      clock_connections:
      {
        clk_i: clkmgr_aon_clocks.clk_main_infra
        clk_edn_i: clkmgr_aon_clocks.clk_main_infra
        clk_esc_i: clkmgr_aon_clocks.clk_io_div4_infra
        clk_otp_i: clkmgr_aon_clocks.clk_io_div4_infra
      }
      domain:
      [
        "0"
      ]
      memory: {}
      param_list:
      [
        {
          name: RndCnstLfsrSeed
          desc: Default seed of the PRNG used for random instructions.
          type: ibex_pkg::lfsr_seed_t
          randcount: 32
          randtype: data
          name_top: RndCnstRvCoreIbexLfsrSeed
          default: 0x88f2805b
          randwidth: 32
        }
        {
          name: RndCnstLfsrPerm
          desc: Permutation applied to the LFSR of the PRNG used for random instructions.
          type: ibex_pkg::lfsr_perm_t
          randcount: 32
          randtype: perm
          name_top: RndCnstRvCoreIbexLfsrPerm
          default: 0xc19b5091071af9efd36fc952e8a99300af097756
          randwidth: 160
        }
        {
          name: RndCnstIbexKeyDefault
          desc: Default icache scrambling key
          type: logic [ibex_pkg::SCRAMBLE_KEY_W-1:0]
          randcount: 128
          randtype: data
          name_top: RndCnstRvCoreIbexIbexKeyDefault
          default: 0x6aeabf2275afc88a1d1273b99c6d2d23
          randwidth: 128
        }
        {
          name: RndCnstIbexNonceDefault
          desc: Default icache scrambling nonce
          type: logic [ibex_pkg::SCRAMBLE_NONCE_W-1:0]
          randcount: 64
          randtype: data
          name_top: RndCnstRvCoreIbexIbexNonceDefault
          default: 0x9f28888f3ef00fc7
          randwidth: 64
        }
        {
          name: PMPEnable
          desc: Enable PMP
          type: bit
          default: "0"
          expose: "true"
          name_top: RvCoreIbexPMPEnable
        }
        {
          name: PMPGranularity
          desc: PMP Granularity
          type: int unsigned
          default: "0"
          expose: "true"
          name_top: RvCoreIbexPMPGranularity
        }
        {
          name: PMPNumRegions
          desc: PMP number of regions
          type: int unsigned
          default: "16"
          expose: "true"
          name_top: RvCoreIbexPMPNumRegions
        }
        {
          name: MHPMCounterNum
          desc: "Number of the MHPM counter "
          type: int unsigned
          default: "0"
          expose: "true"
          name_top: RvCoreIbexMHPMCounterNum
        }
        {
          name: MHPMCounterWidth
          desc: "Width of the MHPM Counter "
          type: int unsigned
          default: "32"
          expose: "true"
          name_top: RvCoreIbexMHPMCounterWidth
        }
        {
          name: RV32E
          desc: RV32E
          type: bit
          default: "0"
          expose: "true"
          name_top: RvCoreIbexRV32E
        }
        {
          name: RV32M
          desc: RV32M
          type: ibex_pkg::rv32m_e
          default: ibex_pkg::RV32MSingleCycle
          expose: "true"
          name_top: RvCoreIbexRV32M
        }
        {
          name: RV32B
          desc: RV32B
          type: ibex_pkg::rv32b_e
          default: ibex_pkg::RV32BNone
          expose: "true"
          name_top: RvCoreIbexRV32B
        }
        {
          name: RegFile
          desc: Reg file
          type: ibex_pkg::regfile_e
          default: ibex_pkg::RegFileFF
          expose: "true"
          name_top: RvCoreIbexRegFile
        }
        {
          name: BranchTargetALU
          desc: Branch target ALU
          type: bit
          default: "1"
          expose: "true"
          name_top: RvCoreIbexBranchTargetALU
        }
        {
          name: WritebackStage
          desc: Write back stage
          type: bit
          default: "1"
          expose: "true"
          name_top: RvCoreIbexWritebackStage
        }
        {
          name: ICache
          desc: Instruction cache
          type: bit
          default: "0"
          expose: "true"
          name_top: RvCoreIbexICache
        }
        {
          name: ICacheECC
          desc: Instruction cache ECC
          type: bit
          default: "0"
          expose: "true"
          name_top: RvCoreIbexICacheECC
        }
        {
          name: ICacheScramble
          desc: Scramble instruction cach
          type: bit
          default: "0"
          expose: "true"
          name_top: RvCoreIbexICacheScramble
        }
        {
          name: BranchPredictor
          desc: Branch predictor
          type: bit
          default: "0"
          expose: "true"
          name_top: RvCoreIbexBranchPredictor
        }
        {
          name: DbgTriggerEn
          desc: Enable degug trigger
          type: bit
          default: "1"
          expose: "true"
          name_top: RvCoreIbexDbgTriggerEn
        }
        {
          name: DbgHwBreakNum
          desc: Number of debug hardware break
          type: int
          default: "1"
          expose: "true"
          name_top: RvCoreIbexDbgHwBreakNum
        }
        {
          name: SecureIbex
          desc: "Width of the MHPM Counter "
          type: bit
          default: "0"
          expose: "true"
          name_top: RvCoreIbexSecureIbex
        }
        {
          name: DmHaltAddr
          desc: Halt address
          type: int unsigned
          default: "0"
          expose: "true"
          name_top: RvCoreIbexDmHaltAddr
        }
        {
          name: DmExceptionAddr
          desc: Exception address
          type: int unsigned
          default: "0"
          expose: "true"
          name_top: RvCoreIbexDmExceptionAddr
        }
        {
          name: PipeLine
          desc: Pipe line
          type: bit
          default: "0"
          expose: "true"
          name_top: RvCoreIbexPipeLine
        }
      ]
      inter_signal_list:
      [
        {
          name: rst_cpu_n
          struct: logic
          type: uni
          act: req
          width: 1
          inst_name: rv_core_ibex
          index: -1
        }
        {
          name: ram_cfg
          struct: ram_1p_cfg
          package: prim_ram_1p_pkg
          type: uni
          act: rcv
          width: 1
          inst_name: rv_core_ibex
          index: -1
        }
        {
          name: hart_id
          struct: logic
          type: uni
          act: rcv
          width: 32
          inst_name: rv_core_ibex
          default: ""
          package: ""
          top_signame: rv_core_ibex_hart_id
          index: -1
        }
        {
          name: boot_addr
          struct: logic
          type: uni
          act: rcv
          width: 32
          inst_name: rv_core_ibex
          default: ""
          package: ""
          top_signame: rv_core_ibex_boot_addr
          index: -1
        }
        {
          name: irq_software
          struct: logic
          type: uni
          act: rcv
          width: 1
          inst_name: rv_core_ibex
          default: ""
          package: ""
          top_signame: rv_plic_msip
          index: -1
        }
        {
          name: irq_timer
          struct: logic
          type: uni
          act: rcv
          width: 1
          inst_name: rv_core_ibex
          default: ""
          package: ""
          top_signame: rv_core_ibex_irq_timer
          index: -1
        }
        {
          name: irq_external
          struct: logic
          type: uni
          act: rcv
          width: 1
          inst_name: rv_core_ibex
          default: ""
          package: ""
          top_signame: rv_plic_irq
          index: -1
        }
        {
          name: esc_tx
          struct: esc_tx
          package: prim_esc_pkg
          type: uni
          act: rcv
          width: 1
          inst_name: rv_core_ibex
          index: -1
        }
        {
          name: esc_rx
          struct: esc_rx
          package: prim_esc_pkg
          type: uni
          act: req
          width: 1
          inst_name: rv_core_ibex
          index: -1
        }
        {
          name: debug_req
          struct: logic
          type: uni
          act: rcv
          width: 1
          inst_name: rv_core_ibex
          index: -1
        }
        {
          name: crash_dump
          struct: cpu_crash_dump
          package: rv_core_ibex_pkg
          type: uni
          act: req
          width: 1
          inst_name: rv_core_ibex
          default: ""
          end_idx: -1
          top_type: broadcast
          top_signame: rv_core_ibex_crash_dump
          index: -1
        }
        {
          name: lc_cpu_en
          struct: lc_tx
          package: lc_ctrl_pkg
          type: uni
          act: rcv
          width: 1
          inst_name: rv_core_ibex
          default: ""
          top_signame: rv_core_ibex_lc_cpu_en
          index: -1
        }
        {
          name: pwrmgr_cpu_en
          struct: lc_tx
          package: lc_ctrl_pkg
          type: uni
          act: rcv
          width: 1
          inst_name: rv_core_ibex
          default: ""
          top_signame: pwrmgr_aon_fetch_en
          index: -1
        }
        {
          name: pwrmgr
          struct: pwr_cpu
          package: pwrmgr_pkg
          type: uni
          act: req
          width: 1
          inst_name: rv_core_ibex
          default: ""
          end_idx: -1
          top_type: broadcast
          top_signame: rv_core_ibex_pwrmgr
          index: -1
        }
        {
          name: nmi_wdog
          struct: logic
          type: uni
          act: rcv
          width: 1
          inst_name: rv_core_ibex
          index: -1
        }
        {
          name: edn
          struct: edn
          package: edn_pkg
          type: req_rsp
          act: req
          width: 1
          inst_name: rv_core_ibex
          index: -1
        }
        {
          name: icache_otp_key
          struct: sram_otp_key
          package: otp_ctrl_pkg
          type: req_rsp
          act: req
          width: 1
          inst_name: rv_core_ibex
          index: -1
        }
        {
          name: fpga_info
          struct: logic
          type: uni
          act: rcv
          width: 32
          inst_name: rv_core_ibex
          default: ""
          package: ""
          external: true
          top_signame: fpga_info
          conn_type: false
          index: -1
        }
        {
          name: corei_tl_h
          struct: tl
          package: tlul_pkg
          type: req_rsp
          act: req
          width: 1
          inst_name: rv_core_ibex
          default: ""
          top_signame: main_tl_rv_core_ibex__corei
          index: -1
        }
        {
          name: cored_tl_h
          struct: tl
          package: tlul_pkg
          type: req_rsp
          act: req
          width: 1
          inst_name: rv_core_ibex
          default: ""
          top_signame: main_tl_rv_core_ibex__cored
          index: -1
        }
        {
          name: cfg_tl_d
          struct: tl
          package: tlul_pkg
          type: req_rsp
          act: rsp
          width: 1
          inst_name: rv_core_ibex
          default: ""
          end_idx: -1
          top_signame: rv_core_ibex_cfg_tl_d
          index: -1
        }
      ]
      base_addrs:
      {
        cfg: 0x411F0000
      }
    }
  ]
  memory: []
  port:
  [
    {
      name: ast
      inter_signal_list:
      [
        {
          struct: edn
          type: req_rsp
          name: edn
          act: rsp
          package: edn_pkg
          inst_name: ast
          width: 1
          default: ""
          external: true
          top_signame: ast_edn
          conn_type: false
          index: -1
        }
        {
          struct: lc_tx
          type: uni
          name: lc_dft_en
          act: req
          package: lc_ctrl_pkg
          inst_name: ast
          width: 1
          default: ""
          external: true
          top_signame: ast_lc_dft_en
          conn_type: false
          index: -1
        }
        {
          struct: ram_1p_cfg
          package: prim_ram_1p_pkg
          type: uni
          name: ram_1p_cfg
          act: rcv
          inst_name: ast
          width: 1
          default: ""
          external: true
          top_signame: ram_1p_cfg
          conn_type: false
          index: -1
        }
        {
          struct: ram_2p_cfg
          package: prim_ram_2p_pkg
          type: uni
          name: spi_ram_2p_cfg
          act: rcv
          inst_name: ast
          width: 1
          default: ""
          external: true
          top_signame: spi_ram_2p_cfg
          conn_type: false
          index: -1
        }
        {
          struct: ram_1p_cfg
          package: prim_ram_1p_pkg
          type: uni
          name: usb_ram_1p_cfg
          act: rcv
          inst_name: ast
          width: 1
          default: ""
          external: true
          top_signame: usb_ram_1p_cfg
          conn_type: false
          index: -1
        }
        {
          struct: rom_cfg
          package: prim_rom_pkg
          type: uni
          name: rom_cfg
          act: rcv
          inst_name: ast
          width: 1
          default: ""
          external: true
          top_signame: rom_cfg
          conn_type: false
          index: -1
        }
      ]
    }
  ]
  inter_module:
  {
    connect:
    {
      pwrmgr_aon.pwr_flash:
      [
        flash_ctrl.pwrmgr
      ]
      pwrmgr_aon.pwr_rst:
      [
        rstmgr_aon.pwr
      ]
      pwrmgr_aon.pwr_clk:
      [
        clkmgr_aon.pwr
      ]
      pwrmgr_aon.strap:
      [
        pinmux_aon.strap_en
      ]
      pwrmgr_aon.low_power:
      [
        pinmux_aon.sleep_en
        aon_timer_aon.sleep_mode
      ]
      pwrmgr_aon.fetch_en:
      [
        rv_core_ibex.pwrmgr_cpu_en
      ]
      usbdev.usb_dp_pullup:
      [
        pinmux_aon.usbdev_dppullup_en
      ]
      usbdev.usb_dn_pullup:
      [
        pinmux_aon.usbdev_dnpullup_en
      ]
      usbdev.usb_aon_suspend_req:
      [
        pinmux_aon.usbdev_suspend_req
      ]
      usbdev.usb_aon_wake_ack:
      [
        pinmux_aon.usbdev_wake_ack
      ]
      usbdev.usb_aon_bus_reset:
      [
        pinmux_aon.usbdev_bus_reset
      ]
      usbdev.usb_aon_sense_lost:
      [
        pinmux_aon.usbdev_sense_lost
      ]
      pinmux_aon.usbdev_wake_detect_active:
      [
        usbdev.usb_aon_wake_detect_active
      ]
      clkmgr_aon.idle:
      [
        aes.idle
      ]
      rv_plic.msip:
      [
        rv_core_ibex.irq_software
      ]
      rv_plic.irq:
      [
        rv_core_ibex.irq_external
      ]
      rv_core_ibex.crash_dump:
      [
        rstmgr_aon.cpu_dump
      ]
      rv_core_ibex.pwrmgr:
      [
        pwrmgr_aon.pwr_cpu
      ]
      spi_device.passthrough:
      [
        spi_host0.passthrough
      ]
      rstmgr_aon.sw_rst_req:
      [
        pwrmgr_aon.sw_rst_req
      ]
      pwrmgr_aon.wakeups:
      [
        pinmux_aon.pin_wkup_req
        pinmux_aon.usb_wkup_req
        aon_timer_aon.wkup_req
      ]
      pwrmgr_aon.rstreqs:
      [
        aon_timer_aon.aon_timer_rst_req
      ]
      main.tl_rv_core_ibex__corei:
      [
        rv_core_ibex.corei_tl_h
      ]
      main.tl_rv_core_ibex__cored:
      [
        rv_core_ibex.cored_tl_h
      ]
      rom_ctrl.rom_tl:
      [
        main.tl_rom_ctrl__rom
      ]
      rom_ctrl.regs_tl:
      [
        main.tl_rom_ctrl__regs
      ]
      main.tl_peri:
      [
        peri.tl_main
      ]
      flash_ctrl.core_tl:
      [
        main.tl_flash_ctrl__core
      ]
      flash_ctrl.prim_tl:
      [
        main.tl_flash_ctrl__prim
      ]
      flash_ctrl.mem_tl:
      [
        main.tl_flash_ctrl__mem
      ]
      aes.tl:
      [
        main.tl_aes
      ]
      rv_plic.tl:
      [
        main.tl_rv_plic
      ]
      rv_core_ibex.cfg_tl_d:
      [
        main.tl_rv_core_ibex__cfg
      ]
      sram_ctrl_main.regs_tl:
      [
        main.tl_sram_ctrl_main__regs
      ]
      sram_ctrl_main.ram_tl:
      [
        main.tl_sram_ctrl_main__ram
      ]
      uart0.tl:
      [
        peri.tl_uart0
      ]
      uart1.tl:
      [
        peri.tl_uart1
      ]
      gpio.tl:
      [
        peri.tl_gpio
      ]
      spi_device.tl:
      [
        peri.tl_spi_device
      ]
      spi_host0.tl:
      [
        peri.tl_spi_host0
      ]
      rv_timer.tl:
      [
        peri.tl_rv_timer
      ]
      usbdev.tl:
      [
        peri.tl_usbdev
      ]
      pwrmgr_aon.tl:
      [
        peri.tl_pwrmgr_aon
      ]
      rstmgr_aon.tl:
      [
        peri.tl_rstmgr_aon
      ]
      clkmgr_aon.tl:
      [
        peri.tl_clkmgr_aon
      ]
      pinmux_aon.tl:
      [
        peri.tl_pinmux_aon
      ]
    }
    top:
    [
      clkmgr_aon.clocks
      clkmgr_aon.cg_en
      rstmgr_aon.resets
      rstmgr_aon.rst_en
      rv_core_ibex.irq_timer
      rv_core_ibex.hart_id
      rv_core_ibex.boot_addr
      rv_core_ibex.lc_cpu_en
      pinmux_aon.dft_jtag
      sram_ctrl_main.otp_en_sram_ifetch
    ]
    external:
    {
      ast.edn: ""
      ast.lc_dft_en: ""
      ast.ram_1p_cfg: ram_1p_cfg
      ast.spi_ram_2p_cfg: spi_ram_2p_cfg
      ast.usb_ram_1p_cfg: usb_ram_1p_cfg
      ast.rom_cfg: rom_cfg
      clkmgr_aon.jitter_en: clk_main_jitter_en
      clkmgr_aon.hi_speed_sel: hi_speed_sel
      clkmgr_aon.div_step_down_req: div_step_down_req
      clkmgr_aon.all_clk_byp_req: all_clk_byp_req
      clkmgr_aon.all_clk_byp_ack: all_clk_byp_ack
      clkmgr_aon.io_clk_byp_req: io_clk_byp_req
      clkmgr_aon.io_clk_byp_ack: io_clk_byp_ack
      flash_ctrl.flash_bist_enable: flash_bist_enable
      flash_ctrl.flash_power_down_h: flash_power_down_h
      flash_ctrl.flash_power_ready_h: flash_power_ready_h
      flash_ctrl.obs_ctrl: obs_ctrl
      flash_ctrl.fla_obs: flash_obs
      peri.tl_ast: ast_tl
      pinmux_aon.dft_strap_test: dft_strap_test
      pinmux_aon.dft_hold_tap_sel: dft_hold_tap_sel
      pinmux_aon.usb_dppullup_en: usb_dp_pullup_en
      pinmux_aon.usb_dnpullup_en: usb_dn_pullup_en
      pwrmgr_aon.pwr_ast: pwrmgr_ast
      rstmgr_aon.por_n: por_n
      rv_core_ibex.fpga_info: fpga_info
      usbdev.usb_rx_d: ""
      usbdev.usb_tx_d: ""
      usbdev.usb_tx_se0: ""
      usbdev.usb_tx_use_d_se0: ""
      usbdev.usb_rx_enable: ""
      usbdev.usb_ref_val: ""
      usbdev.usb_ref_pulse: ""
      spi_device.sck_monitor: sck_monitor
    }
  }
  xbar:
  [
    {
      name: main
      clock_srcs:
      {
        clk_main_i: main
        clk_fixed_i: io_div4
      }
      clock_group: infra
      reset: rst_main_ni
      reset_connections:
      {
        rst_main_ni:
        {
          name: sys
          domain: "0"
        }
        rst_fixed_ni:
        {
          name: sys_io_div4
          domain: "0"
        }
      }
      clock_connections:
      {
        clk_main_i: clkmgr_aon_clocks.clk_main_infra
        clk_fixed_i: clkmgr_aon_clocks.clk_io_div4_infra
      }
      domain:
      [
        "0"
      ]
      connections:
      {
        rv_core_ibex.corei:
        [
          rom_ctrl.rom
          sram_ctrl_main.ram
          flash_ctrl.mem
        ]
        rv_core_ibex.cored:
        [
          rom_ctrl.rom
          rom_ctrl.regs
          sram_ctrl_main.ram
          flash_ctrl.mem
          peri
          flash_ctrl.core
          flash_ctrl.prim
          aes
          rv_plic
          sram_ctrl_main.ram
          sram_ctrl_main.regs
          rv_core_ibex.cfg
        ]
      }
      nodes:
      [
        {
          name: rv_core_ibex.corei
          type: host
          clock: clk_main_i
          reset: rst_main_ni
          pipeline: false
          xbar: false
          stub: false
          inst_type: ""
          req_fifo_pass: true
          rsp_fifo_pass: true
        }
        {
          name: rv_core_ibex.cored
          type: host
          clock: clk_main_i
          reset: rst_main_ni
          pipeline: false
          xbar: false
          stub: false
          inst_type: ""
          req_fifo_pass: true
          rsp_fifo_pass: true
        }
        {
          name: rom_ctrl.rom
          type: device
          clock: clk_main_i
          reset: rst_main_ni
          pipeline: false
          inst_type: rom_ctrl
          addr_range:
          [
            {
              base_addr: 0x8000
              size_byte: 0x8000
            }
          ]
          xbar: false
          stub: false
          req_fifo_pass: true
        }
        {
          name: rom_ctrl.regs
          type: device
          clock: clk_main_i
          reset: rst_main_ni
          pipeline: false
          inst_type: rom_ctrl
          addr_range:
          [
            {
              base_addr: 0x411e0000
              size_byte: 0x80
            }
          ]
          xbar: false
          stub: false
          req_fifo_pass: true
        }
        {
          name: peri
          type: device
          clock: clk_fixed_i
          reset: rst_fixed_ni
          pipeline: false
          xbar: true
          stub: false
          req_fifo_pass: true
          addr_range:
          [
            {
              base_addr: 0x40000000
              size_byte: 0x800000
            }
          ]
        }
        {
          name: flash_ctrl.core
          type: device
          clock: clk_main_i
          reset: rst_main_ni
          req_fifo_pass: true
          rsp_fifo_pass: false
          inst_type: flash_ctrl
          addr_range:
          [
            {
              base_addr: 0x41000000
              size_byte: 0x200
            }
          ]
          xbar: false
          stub: false
          pipeline: true
        }
        {
          name: flash_ctrl.prim
          type: device
          clock: clk_main_i
          reset: rst_main_ni
          req_fifo_pass: true
          rsp_fifo_pass: false
          inst_type: flash_ctrl
          addr_range:
          [
            {
              base_addr: 0x41008000
              size_byte: 0x80
            }
          ]
          xbar: false
          stub: false
          pipeline: true
        }
        {
          name: flash_ctrl.mem
          type: device
          clock: clk_main_i
          reset: rst_main_ni
          req_fifo_pass: true
          rsp_fifo_pass: false
          inst_type: flash_ctrl
          addr_range:
          [
            {
              base_addr: 0x20000000
              size_byte: 0x10000
            }
          ]
          xbar: false
          stub: false
          pipeline: true
        }
        {
          name: aes
          type: device
          clock: clk_main_i
          reset: rst_main_ni
          pipeline: false
          inst_type: aes
          addr_range:
          [
            {
              base_addr: 0x41100000
              size_byte: 0x100
            }
          ]
          xbar: false
          stub: false
          req_fifo_pass: true
        }
        {
          name: rv_plic
          type: device
          clock: clk_main_i
          reset: rst_main_ni
          inst_type: rv_plic
          pipeline: false
          addr_range:
          [
            {
              base_addr: 0x48000000
              size_byte: 0x8000000
            }
          ]
          xbar: false
          stub: false
          req_fifo_pass: true
        }
        {
          name: rv_core_ibex.cfg
          type: device
          clock: clk_main_i
          reset: rst_main_ni
          pipeline: false
          inst_type: rv_core_ibex
          addr_range:
          [
            {
              base_addr: 0x411f0000
              size_byte: 0x100
            }
          ]
          xbar: false
          stub: false
          req_fifo_pass: true
        }
        {
          name: sram_ctrl_main.regs
          type: device
          clock: clk_main_i
          reset: rst_main_ni
          pipeline: false
          inst_type: sram_ctrl
          addr_range:
          [
            {
              base_addr: 0x411c0000
              size_byte: 0x40
            }
          ]
          xbar: false
          stub: false
          req_fifo_pass: true
        }
        {
          name: sram_ctrl_main.ram
          type: device
          clock: clk_main_i
          reset: rst_main_ni
          pipeline: false
          inst_type: sram_ctrl
          addr_range:
          [
            {
              base_addr: 0x10000000
              size_byte: 0x20000
            }
          ]
          xbar: false
          stub: false
          req_fifo_pass: true
        }
      ]
      clock: clk_main_i
      type: xbar
      inter_signal_list:
      [
        {
          name: tl_rv_core_ibex__corei
          struct: tl
          package: tlul_pkg
          type: req_rsp
          act: rsp
          width: 1
          inst_name: main
          default: ""
          end_idx: -1
          top_signame: main_tl_rv_core_ibex__corei
          index: -1
        }
        {
          name: tl_rv_core_ibex__cored
          struct: tl
          package: tlul_pkg
          type: req_rsp
          act: rsp
          width: 1
          inst_name: main
          default: ""
          end_idx: -1
          top_signame: main_tl_rv_core_ibex__cored
          index: -1
        }
        {
          name: tl_rom_ctrl__rom
          struct: tl
          package: tlul_pkg
          type: req_rsp
          act: req
          width: 1
          inst_name: main
          default: ""
          top_signame: rom_ctrl_rom_tl
          index: -1
        }
        {
          name: tl_rom_ctrl__regs
          struct: tl
          package: tlul_pkg
          type: req_rsp
          act: req
          width: 1
          inst_name: main
          default: ""
          top_signame: rom_ctrl_regs_tl
          index: -1
        }
        {
          name: tl_peri
          struct: tl
          package: tlul_pkg
          type: req_rsp
          act: req
          width: 1
          inst_name: main
          default: ""
          end_idx: -1
          top_signame: main_tl_peri
          index: -1
        }
        {
          name: tl_flash_ctrl__core
          struct: tl
          package: tlul_pkg
          type: req_rsp
          act: req
          width: 1
          inst_name: main
          default: ""
          top_signame: flash_ctrl_core_tl
          index: -1
        }
        {
          name: tl_flash_ctrl__prim
          struct: tl
          package: tlul_pkg
          type: req_rsp
          act: req
          width: 1
          inst_name: main
          default: ""
          top_signame: flash_ctrl_prim_tl
          index: -1
        }
        {
          name: tl_flash_ctrl__mem
          struct: tl
          package: tlul_pkg
          type: req_rsp
          act: req
          width: 1
          inst_name: main
          default: ""
          top_signame: flash_ctrl_mem_tl
          index: -1
        }
        {
          name: tl_aes
          struct: tl
          package: tlul_pkg
          type: req_rsp
          act: req
          width: 1
          inst_name: main
          default: ""
          top_signame: aes_tl
          index: -1
        }
        {
          name: tl_rv_plic
          struct: tl
          package: tlul_pkg
          type: req_rsp
          act: req
          width: 1
          inst_name: main
          default: ""
          top_signame: rv_plic_tl
          index: -1
        }
        {
          name: tl_rv_core_ibex__cfg
          struct: tl
          package: tlul_pkg
          type: req_rsp
          act: req
          width: 1
          inst_name: main
          default: ""
          top_signame: rv_core_ibex_cfg_tl_d
          index: -1
        }
        {
          name: tl_sram_ctrl_main__regs
          struct: tl
          package: tlul_pkg
          type: req_rsp
          act: req
          width: 1
          inst_name: main
          default: ""
          top_signame: sram_ctrl_main_regs_tl
          index: -1
        }
        {
          name: tl_sram_ctrl_main__ram
          struct: tl
          package: tlul_pkg
          type: req_rsp
          act: req
          width: 1
          inst_name: main
          default: ""
          top_signame: sram_ctrl_main_ram_tl
          index: -1
        }
      ]
    }
    {
      name: peri
      clock_srcs:
      {
        clk_peri_i: io_div4
        clk_spi_host0_i: io
        clk_usb_i: usb
      }
      clock_group: infra
      reset: rst_peri_ni
      reset_connections:
      {
        rst_peri_ni:
        {
          name: sys_io_div4
          domain: "0"
        }
        rst_spi_host0_ni:
        {
          name: spi_host0
          domain: "0"
        }
        rst_usb_ni:
        {
          name: usb
          domain: "0"
        }
      }
      clock_connections:
      {
        clk_peri_i: clkmgr_aon_clocks.clk_io_div4_infra
        clk_spi_host0_i: clkmgr_aon_clocks.clk_io_infra
        clk_usb_i: clkmgr_aon_clocks.clk_usb_infra
      }
      domain:
      [
        "0"
      ]
      connections:
      {
        main:
        [
          uart0
          uart1
          gpio
          spi_device
          spi_host0
          rv_timer
          usbdev
          pwrmgr_aon
          rstmgr_aon
          clkmgr_aon
          pinmux_aon
          ast
        ]
      }
      nodes:
      [
        {
          name: main
          type: host
          clock: clk_peri_i
          reset: rst_peri_ni
          xbar: true
          pipeline: false
          stub: false
          inst_type: ""
          req_fifo_pass: true
          rsp_fifo_pass: true
        }
        {
          name: uart0
          type: device
          clock: clk_peri_i
          reset: rst_peri_ni
          pipeline: false
          inst_type: uart
          addr_range:
          [
            {
              base_addr: 0x40000000
              size_byte: 0x40
            }
          ]
          xbar: false
          stub: false
          req_fifo_pass: true
        }
        {
          name: uart1
          type: device
          clock: clk_peri_i
          reset: rst_peri_ni
          pipeline: false
          inst_type: uart
          addr_range:
          [
            {
              base_addr: 0x40010000
              size_byte: 0x40
            }
          ]
          xbar: false
          stub: false
          req_fifo_pass: true
        }
        {
          name: gpio
          type: device
          clock: clk_peri_i
          reset: rst_peri_ni
          pipeline: false
          inst_type: gpio
          addr_range:
          [
            {
              base_addr: 0x40040000
              size_byte: 0x40
            }
          ]
          xbar: false
          stub: false
          req_fifo_pass: true
        }
        {
          name: spi_device
          type: device
          clock: clk_peri_i
          reset: rst_peri_ni
          pipeline: false
          inst_type: spi_device
          addr_range:
          [
            {
              base_addr: 0x40050000
              size_byte: 0x2000
            }
          ]
          xbar: false
          stub: false
          req_fifo_pass: true
        }
        {
          name: spi_host0
          type: device
          clock: clk_spi_host0_i
          reset: rst_spi_host0_ni
          pipeline: false
          inst_type: spi_host
          addr_range:
          [
            {
              base_addr: 0x40060000
              size_byte: 0x40
            }
          ]
          xbar: false
          stub: false
          req_fifo_pass: true
        }
        {
          name: rv_timer
          type: device
          clock: clk_peri_i
          reset: rst_peri_ni
          pipeline: false
          inst_type: rv_timer
          addr_range:
          [
            {
              base_addr: 0x40100000
              size_byte: 0x200
            }
          ]
          xbar: false
          stub: false
          req_fifo_pass: true
        }
        {
          name: usbdev
          type: device
          clock: clk_usb_i
          reset: rst_usb_ni
          pipeline: false
          inst_type: usbdev
          addr_range:
          [
            {
              base_addr: 0x40320000
              size_byte: 0x1000
            }
          ]
          xbar: false
          stub: false
          req_fifo_pass: true
        }
        {
          name: pwrmgr_aon
          type: device
          clock: clk_peri_i
          reset: rst_peri_ni
          pipeline: false
          inst_type: pwrmgr
          addr_range:
          [
            {
              base_addr: 0x40400000
              size_byte: 0x80
            }
          ]
          xbar: false
          stub: false
          req_fifo_pass: true
        }
        {
          name: rstmgr_aon
          type: device
          clock: clk_peri_i
          reset: rst_peri_ni
          pipeline: false
          inst_type: rstmgr
          addr_range:
          [
            {
              base_addr: 0x40410000
              size_byte: 0x80
            }
          ]
          xbar: false
          stub: false
          req_fifo_pass: true
        }
        {
          name: clkmgr_aon
          type: device
          clock: clk_peri_i
          reset: rst_peri_ni
          pipeline: false
          inst_type: clkmgr
          addr_range:
          [
            {
              base_addr: 0x40420000
              size_byte: 0x80
            }
          ]
          xbar: false
          stub: false
          req_fifo_pass: true
        }
        {
          name: pinmux_aon
          type: device
          clock: clk_peri_i
          reset: rst_peri_ni
          pipeline: false
          inst_type: pinmux
          addr_range:
          [
            {
              base_addr: 0x40460000
              size_byte: 0x1000
            }
          ]
          xbar: false
          stub: false
          req_fifo_pass: true
        }
        {
          name: ast
          type: device
          clock: clk_peri_i
          reset: rst_peri_ni
          pipeline: false
          inst_type: ast
          addr_range:
          [
            {
              base_addr: 0x40480000
              size_byte: 0x400
            }
          ]
          xbar: false
          stub: true
          req_fifo_pass: true
        }
      ]
      clock: clk_peri_i
      type: xbar
      inter_signal_list:
      [
        {
          name: tl_main
          struct: tl
          package: tlul_pkg
          type: req_rsp
          act: rsp
          width: 1
          inst_name: peri
          default: ""
          top_signame: main_tl_peri
          index: -1
        }
        {
          name: tl_uart0
          struct: tl
          package: tlul_pkg
          type: req_rsp
          act: req
          width: 1
          inst_name: peri
          default: ""
          top_signame: uart0_tl
          index: -1
        }
        {
          name: tl_uart1
          struct: tl
          package: tlul_pkg
          type: req_rsp
          act: req
          width: 1
          inst_name: peri
          default: ""
          top_signame: uart1_tl
          index: -1
        }
        {
          name: tl_gpio
          struct: tl
          package: tlul_pkg
          type: req_rsp
          act: req
          width: 1
          inst_name: peri
          default: ""
          top_signame: gpio_tl
          index: -1
        }
        {
          name: tl_spi_device
          struct: tl
          package: tlul_pkg
          type: req_rsp
          act: req
          width: 1
          inst_name: peri
          default: ""
          top_signame: spi_device_tl
          index: -1
        }
        {
          name: tl_spi_host0
          struct: tl
          package: tlul_pkg
          type: req_rsp
          act: req
          width: 1
          inst_name: peri
          default: ""
          top_signame: spi_host0_tl
          index: -1
        }
        {
          name: tl_rv_timer
          struct: tl
          package: tlul_pkg
          type: req_rsp
          act: req
          width: 1
          inst_name: peri
          default: ""
          top_signame: rv_timer_tl
          index: -1
        }
        {
          name: tl_usbdev
          struct: tl
          package: tlul_pkg
          type: req_rsp
          act: req
          width: 1
          inst_name: peri
          default: ""
          top_signame: usbdev_tl
          index: -1
        }
        {
          name: tl_pwrmgr_aon
          struct: tl
          package: tlul_pkg
          type: req_rsp
          act: req
          width: 1
          inst_name: peri
          default: ""
          top_signame: pwrmgr_aon_tl
          index: -1
        }
        {
          name: tl_rstmgr_aon
          struct: tl
          package: tlul_pkg
          type: req_rsp
          act: req
          width: 1
          inst_name: peri
          default: ""
          top_signame: rstmgr_aon_tl
          index: -1
        }
        {
          name: tl_clkmgr_aon
          struct: tl
          package: tlul_pkg
          type: req_rsp
          act: req
          width: 1
          inst_name: peri
          default: ""
          top_signame: clkmgr_aon_tl
          index: -1
        }
        {
          name: tl_pinmux_aon
          struct: tl
          package: tlul_pkg
          type: req_rsp
          act: req
          width: 1
          inst_name: peri
          default: ""
          top_signame: pinmux_aon_tl
          index: -1
        }
        {
          name: tl_ast
          struct: tl
          package: tlul_pkg
          type: req_rsp
          act: req
          width: 1
          inst_name: peri
          default: ""
          external: true
          top_signame: ast_tl
          conn_type: false
          index: -1
        }
      ]
    }
  ]
  interrupt_module:
  [
    uart0
    uart1
    gpio
    spi_device
    spi_host0
    usbdev
    pwrmgr_aon
    aon_timer_aon
    flash_ctrl
  ]
  pinout:
  {
    banks:
    [
      VCC
      AVCC
      VIOA
      VIOB
    ]
    pads:
    [
      {
        name: POR_N
        type: InputStd
        bank: VCC
        connection: manual
        desc: System reset
        port_type: inout
        idx: 0
      }
      {
        name: USB_P
        type: BidirTol
        bank: VCC
        connection: manual
        desc: USB P signal
        port_type: inout
        idx: 1
      }
      {
        name: USB_N
        type: BidirTol
        bank: VCC
        connection: manual
        desc: USB N signal
        port_type: inout
        idx: 2
      }
      {
        name: CC1
        type: InputStd
        bank: AVCC
        connection: manual
        desc: ADC input 1
        port_type: inout
        idx: 3
      }
      {
        name: CC2
        type: InputStd
        bank: AVCC
        connection: manual
        desc: ADC input 2
        port_type: inout
        idx: 4
      }
      {
        name: FLASH_TEST_VOLT
        type: AnalogIn0
        bank: VCC
        connection: manual
        desc: Flash test voltage input
        port_type: inout
        idx: 5
      }
      {
        name: FLASH_TEST_MODE0
        type: InputStd
        bank: VCC
        connection: manual
        desc: Flash test mode signal
        port_type: inout
        idx: 6
      }
      {
        name: FLASH_TEST_MODE1
        type: InputStd
        bank: VCC
        connection: manual
        desc: Flash test mode signal
        port_type: inout
        idx: 7
      }
      {
        name: SPI_HOST_D0
        type: BidirStd
        bank: VIOA
        connection: direct
        desc: SPI host data
        port_type: inout
        idx: 8
      }
      {
        name: SPI_HOST_D1
        type: BidirStd
        bank: VIOA
        connection: direct
        desc: SPI host data
        port_type: inout
        idx: 9
      }
      {
        name: SPI_HOST_D2
        type: BidirStd
        bank: VIOA
        connection: direct
        desc: SPI host data
        port_type: inout
        idx: 10
      }
      {
        name: SPI_HOST_D3
        type: BidirStd
        bank: VIOA
        connection: direct
        desc: SPI host data
        port_type: inout
        idx: 11
      }
      {
        name: SPI_HOST_CLK
        type: BidirStd
        bank: VIOA
        connection: direct
        desc: SPI host clock
        port_type: inout
        idx: 12
      }
      {
        name: SPI_HOST_CS_L
        type: BidirStd
        bank: VIOA
        connection: direct
        desc: SPI host chip select
        port_type: inout
        idx: 13
      }
      {
        name: SPI_DEV_D0
        type: BidirStd
        bank: VIOA
        connection: direct
        desc: SPI device data
        port_type: inout
        idx: 14
      }
      {
        name: SPI_DEV_D1
        type: BidirStd
        bank: VIOA
        connection: direct
        desc: SPI device data
        port_type: inout
        idx: 15
      }
      {
        name: SPI_DEV_D2
        type: BidirStd
        bank: VIOA
        connection: direct
        desc: SPI device data
        port_type: inout
        idx: 16
      }
      {
        name: SPI_DEV_D3
        type: BidirStd
        bank: VIOA
        connection: direct
        desc: SPI device data
        port_type: inout
        idx: 17
      }
      {
        name: SPI_DEV_CLK
        type: InputStd
        bank: VIOA
        connection: direct
        desc: SPI device clock
        port_type: inout
        idx: 18
      }
      {
        name: SPI_DEV_CS_L
        type: InputStd
        bank: VIOA
        connection: direct
        desc: SPI device chip select
        port_type: inout
        idx: 19
      }
      {
        name: IOA0
        type: BidirStd
        bank: VIOA
        connection: muxed
        desc: Muxed IO pad
        port_type: inout
        idx: 0
      }
      {
        name: IOA1
        type: BidirStd
        bank: VIOA
        connection: muxed
        desc: Muxed IO pad
        port_type: inout
        idx: 1
      }
      {
        name: IOA2
        type: BidirStd
        bank: VIOA
        connection: muxed
        desc: Muxed IO pad
        port_type: inout
        idx: 2
      }
      {
        name: IOA3
        type: BidirStd
        bank: VIOA
        connection: muxed
        desc: Muxed IO pad
        port_type: inout
        idx: 3
      }
      {
        name: IOA4
        type: BidirStd
        bank: VIOA
        connection: muxed
        desc: Muxed IO pad
        port_type: inout
        idx: 4
      }
      {
        name: IOA5
        type: BidirStd
        bank: VIOA
        connection: muxed
        desc: Muxed IO pad
        port_type: inout
        idx: 5
      }
      {
        name: IOA6
        type: BidirOd
        bank: VIOA
        connection: muxed
        desc: Muxed IO pad
        port_type: inout
        idx: 6
      }
      {
        name: IOA7
        type: BidirOd
        bank: VIOA
        connection: muxed
        desc: Muxed IO pad
        port_type: inout
        idx: 7
      }
      {
        name: IOA8
        type: BidirOd
        bank: VIOA
        connection: muxed
        desc: Muxed IO pad
        port_type: inout
        idx: 8
      }
      {
        name: IOB0
        type: BidirStd
        bank: VIOB
        connection: muxed
        desc: Muxed IO pad
        port_type: inout
        idx: 9
      }
      {
        name: IOB1
        type: BidirStd
        bank: VIOB
        connection: muxed
        desc: Muxed IO pad
        port_type: inout
        idx: 10
      }
      {
        name: IOB2
        type: BidirStd
        bank: VIOB
        connection: muxed
        desc: Muxed IO pad
        port_type: inout
        idx: 11
      }
      {
        name: IOB3
        type: BidirStd
        bank: VIOB
        connection: muxed
        desc: Muxed IO pad
        port_type: inout
        idx: 12
      }
      {
        name: IOB4
        type: BidirStd
        bank: VIOB
        connection: muxed
        desc: Muxed IO pad
        port_type: inout
        idx: 13
      }
      {
        name: IOB5
        type: BidirStd
        bank: VIOB
        connection: muxed
        desc: Muxed IO pad
        port_type: inout
        idx: 14
      }
      {
        name: IOB6
        type: BidirStd
        bank: VIOB
        connection: muxed
        desc: Muxed IO pad
        port_type: inout
        idx: 15
      }
      {
        name: IOB7
        type: BidirStd
        bank: VIOB
        connection: muxed
        desc: Muxed IO pad
        port_type: inout
        idx: 16
      }
      {
        name: IOB8
        type: BidirStd
        bank: VIOB
        connection: muxed
        desc: Muxed IO pad
        port_type: inout
        idx: 17
      }
      {
        name: IOB9
        type: BidirOd
        bank: VIOB
        connection: muxed
        desc: Muxed IO pad
        port_type: inout
        idx: 18
      }
      {
        name: IOB10
        type: BidirOd
        bank: VIOB
        connection: muxed
        desc: Muxed IO pad
        port_type: inout
        idx: 19
      }
      {
        name: IOB11
        type: BidirOd
        bank: VIOB
        connection: muxed
        desc: Muxed IO pad
        port_type: inout
        idx: 20
      }
      {
        name: IOB12
        type: BidirOd
        bank: VIOB
        connection: muxed
        desc: Muxed IO pad
        port_type: inout
        idx: 21
      }
      {
        name: IOC0
        type: BidirStd
        bank: VCC
        connection: muxed
        desc: Muxed IO pad
        port_type: inout
        idx: 22
      }
      {
        name: IOC1
        type: BidirStd
        bank: VCC
        connection: muxed
        desc: Muxed IO pad
        port_type: inout
        idx: 23
      }
      {
        name: IOC2
        type: BidirStd
        bank: VCC
        connection: muxed
        desc: Muxed IO pad
        port_type: inout
        idx: 24
      }
      {
        name: IOC3
        type: BidirStd
        bank: VCC
        connection: muxed
        desc: Muxed IO pad
        port_type: inout
        idx: 25
      }
      {
        name: IOC4
        type: BidirStd
        bank: VCC
        connection: muxed
        desc: Muxed IO pad
        port_type: inout
        idx: 26
      }
      {
        name: IOC5
        type: BidirStd
        bank: VCC
        connection: muxed
        desc: Muxed IO pad
        port_type: inout
        idx: 27
      }
      {
        name: IOC6
        type: BidirStd
        bank: VCC
        connection: muxed
        desc: Muxed IO pad
        port_type: inout
        idx: 28
      }
      {
        name: IOC7
        type: BidirStd
        bank: VCC
        connection: muxed
        desc: Muxed IO pad
        port_type: inout
        idx: 29
      }
      {
        name: IOC8
        type: BidirStd
        bank: VCC
        connection: muxed
        desc: Muxed IO pad
        port_type: inout
        idx: 30
      }
      {
        name: IOC9
        type: BidirStd
        bank: VCC
        connection: muxed
        desc: Muxed IO pad
        port_type: inout
        idx: 31
      }
      {
        name: IOC10
        type: BidirOd
        bank: VCC
        connection: muxed
        desc: Muxed IO pad
        port_type: inout
        idx: 32
      }
      {
        name: IOC11
        type: BidirOd
        bank: VCC
        connection: muxed
        desc: Muxed IO pad
        port_type: inout
        idx: 33
      }
      {
        name: IOC12
        type: BidirOd
        bank: VCC
        connection: muxed
        desc: Muxed IO pad
        port_type: inout
        idx: 34
      }
      {
        name: IOR0
        type: BidirStd
        bank: VCC
        connection: muxed
        desc: Muxed IO pad
        port_type: inout
        idx: 35
      }
      {
        name: IOR1
        type: BidirStd
        bank: VCC
        connection: muxed
        desc: Muxed IO pad
        port_type: inout
        idx: 36
      }
      {
        name: IOR2
        type: BidirStd
        bank: VCC
        connection: muxed
        desc: Muxed IO pad
        port_type: inout
        idx: 37
      }
      {
        name: IOR3
        type: BidirStd
        bank: VCC
        connection: muxed
        desc: Muxed IO pad
        port_type: inout
        idx: 38
      }
      {
        name: IOR4
        type: BidirStd
        bank: VCC
        connection: muxed
        desc: Muxed IO pad
        port_type: inout
        idx: 39
      }
      {
        name: IOR5
        type: BidirStd
        bank: VCC
        connection: muxed
        desc: Muxed IO pad
        port_type: inout
        idx: 40
      }
      {
        name: IOR6
        type: BidirStd
        bank: VCC
        connection: muxed
        desc: Muxed IO pad
        port_type: inout
        idx: 41
      }
      {
        name: IOR7
        type: BidirStd
        bank: VCC
        connection: muxed
        desc: Muxed IO pad
        port_type: inout
        idx: 42
      }
      {
        name: IOR10
        type: BidirOd
        bank: VCC
        connection: muxed
        desc: Muxed IO pad
        port_type: inout
        idx: 43
      }
      {
        name: IOR11
        type: BidirOd
        bank: VCC
        connection: muxed
        desc: Muxed IO pad
        port_type: inout
        idx: 44
      }
      {
        name: IOR12
        type: BidirOd
        bank: VCC
        connection: muxed
        desc: Muxed IO pad
        port_type: inout
        idx: 45
      }
      {
        name: IOR13
        type: BidirOd
        bank: VCC
        connection: muxed
        desc: Muxed IO pad
        port_type: inout
        idx: 46
      }
    ]
  }
  pinmux:
  {
    signals:
    [
      {
        instance: spi_host0
        port: sck
        connection: direct
        pad: SPI_HOST_CLK
        desc: ""
        attr: BidirStd
      }
      {
        instance: spi_host0
        port: csb
        connection: direct
        pad: SPI_HOST_CS_L
        desc: ""
        attr: BidirStd
      }
      {
        instance: spi_host0
        port: sd[0]
        connection: direct
        pad: SPI_HOST_D0
        desc: ""
        attr: BidirStd
      }
      {
        instance: spi_host0
        port: sd[1]
        connection: direct
        pad: SPI_HOST_D1
        desc: ""
        attr: BidirStd
      }
      {
        instance: spi_host0
        port: sd[2]
        connection: direct
        pad: SPI_HOST_D2
        desc: ""
        attr: BidirStd
      }
      {
        instance: spi_host0
        port: sd[3]
        connection: direct
        pad: SPI_HOST_D3
        desc: ""
        attr: BidirStd
      }
      {
        instance: spi_device
        port: sck
        connection: direct
        pad: SPI_DEV_CLK
        desc: ""
        attr: InputStd
      }
      {
        instance: spi_device
        port: csb
        connection: direct
        pad: SPI_DEV_CS_L
        desc: ""
        attr: InputStd
      }
      {
        instance: spi_device
        port: sd[0]
        connection: direct
        pad: SPI_DEV_D0
        desc: ""
        attr: BidirStd
      }
      {
        instance: spi_device
        port: sd[1]
        connection: direct
        pad: SPI_DEV_D1
        desc: ""
        attr: BidirStd
      }
      {
        instance: spi_device
        port: sd[2]
        connection: direct
        pad: SPI_DEV_D2
        desc: ""
        attr: BidirStd
      }
      {
        instance: spi_device
        port: sd[3]
        connection: direct
        pad: SPI_DEV_D3
        desc: ""
        attr: BidirStd
      }
      {
        instance: usbdev
        port: usb_dp
        connection: manual
        pad: ""
        desc: ""
        attr: BidirStd
      }
      {
        instance: usbdev
        port: usb_dn
        connection: manual
        pad: ""
        desc: ""
        attr: BidirStd
      }
      {
        instance: gpio
        port: ""
        connection: muxed
        pad: ""
        desc: ""
        attr: ""
      }
      {
        instance: uart0
        port: ""
        connection: muxed
        pad: ""
        desc: ""
        attr: ""
      }
      {
        instance: uart1
        port: ""
        connection: muxed
        pad: ""
        desc: ""
        attr: ""
      }
      {
        instance: flash_ctrl
        port: ""
        connection: muxed
        pad: ""
        desc: ""
        attr: ""
      }
      {
        instance: usbdev
        port: sense
        connection: muxed
        pad: ""
        desc: ""
        attr: ""
      }
    ]
    num_wkup_detect: 8
    wkup_cnt_width: 8
    ios:
    [
      {
        name: spi_host0_sd
        width: 4
        type: inout
        idx: 0
        pad: SPI_HOST_D0
        attr: BidirStd
        connection: direct
        desc: ""
        glob_idx: 0
      }
      {
        name: spi_host0_sd
        width: 4
        type: inout
        idx: 1
        pad: SPI_HOST_D1
        attr: BidirStd
        connection: direct
        desc: ""
        glob_idx: 1
      }
      {
        name: spi_host0_sd
        width: 4
        type: inout
        idx: 2
        pad: SPI_HOST_D2
        attr: BidirStd
        connection: direct
        desc: ""
        glob_idx: 2
      }
      {
        name: spi_host0_sd
        width: 4
        type: inout
        idx: 3
        pad: SPI_HOST_D3
        attr: BidirStd
        connection: direct
        desc: ""
        glob_idx: 3
      }
      {
        name: spi_device_sd
        width: 4
        type: inout
        idx: 0
        pad: SPI_DEV_D0
        attr: BidirStd
        connection: direct
        desc: ""
        glob_idx: 4
      }
      {
        name: spi_device_sd
        width: 4
        type: inout
        idx: 1
        pad: SPI_DEV_D1
        attr: BidirStd
        connection: direct
        desc: ""
        glob_idx: 5
      }
      {
        name: spi_device_sd
        width: 4
        type: inout
        idx: 2
        pad: SPI_DEV_D2
        attr: BidirStd
        connection: direct
        desc: ""
        glob_idx: 6
      }
      {
        name: spi_device_sd
        width: 4
        type: inout
        idx: 3
        pad: SPI_DEV_D3
        attr: BidirStd
        connection: direct
        desc: ""
        glob_idx: 7
      }
      {
        name: usbdev_usb_dp
        width: 1
        type: inout
        idx: -1
        pad: ""
        attr: BidirStd
        connection: manual
        desc: ""
        glob_idx: 8
      }
      {
        name: usbdev_usb_dn
        width: 1
        type: inout
        idx: -1
        pad: ""
        attr: BidirStd
        connection: manual
        desc: ""
        glob_idx: 9
      }
      {
        name: gpio_gpio
        width: 32
        type: inout
        idx: 0
        pad: ""
        attr: ""
        connection: muxed
        desc: ""
        glob_idx: 0
      }
      {
        name: gpio_gpio
        width: 32
        type: inout
        idx: 1
        pad: ""
        attr: ""
        connection: muxed
        desc: ""
        glob_idx: 1
      }
      {
        name: gpio_gpio
        width: 32
        type: inout
        idx: 2
        pad: ""
        attr: ""
        connection: muxed
        desc: ""
        glob_idx: 2
      }
      {
        name: gpio_gpio
        width: 32
        type: inout
        idx: 3
        pad: ""
        attr: ""
        connection: muxed
        desc: ""
        glob_idx: 3
      }
      {
        name: gpio_gpio
        width: 32
        type: inout
        idx: 4
        pad: ""
        attr: ""
        connection: muxed
        desc: ""
        glob_idx: 4
      }
      {
        name: gpio_gpio
        width: 32
        type: inout
        idx: 5
        pad: ""
        attr: ""
        connection: muxed
        desc: ""
        glob_idx: 5
      }
      {
        name: gpio_gpio
        width: 32
        type: inout
        idx: 6
        pad: ""
        attr: ""
        connection: muxed
        desc: ""
        glob_idx: 6
      }
      {
        name: gpio_gpio
        width: 32
        type: inout
        idx: 7
        pad: ""
        attr: ""
        connection: muxed
        desc: ""
        glob_idx: 7
      }
      {
        name: gpio_gpio
        width: 32
        type: inout
        idx: 8
        pad: ""
        attr: ""
        connection: muxed
        desc: ""
        glob_idx: 8
      }
      {
        name: gpio_gpio
        width: 32
        type: inout
        idx: 9
        pad: ""
        attr: ""
        connection: muxed
        desc: ""
        glob_idx: 9
      }
      {
        name: gpio_gpio
        width: 32
        type: inout
        idx: 10
        pad: ""
        attr: ""
        connection: muxed
        desc: ""
        glob_idx: 10
      }
      {
        name: gpio_gpio
        width: 32
        type: inout
        idx: 11
        pad: ""
        attr: ""
        connection: muxed
        desc: ""
        glob_idx: 11
      }
      {
        name: gpio_gpio
        width: 32
        type: inout
        idx: 12
        pad: ""
        attr: ""
        connection: muxed
        desc: ""
        glob_idx: 12
      }
      {
        name: gpio_gpio
        width: 32
        type: inout
        idx: 13
        pad: ""
        attr: ""
        connection: muxed
        desc: ""
        glob_idx: 13
      }
      {
        name: gpio_gpio
        width: 32
        type: inout
        idx: 14
        pad: ""
        attr: ""
        connection: muxed
        desc: ""
        glob_idx: 14
      }
      {
        name: gpio_gpio
        width: 32
        type: inout
        idx: 15
        pad: ""
        attr: ""
        connection: muxed
        desc: ""
        glob_idx: 15
      }
      {
        name: gpio_gpio
        width: 32
        type: inout
        idx: 16
        pad: ""
        attr: ""
        connection: muxed
        desc: ""
        glob_idx: 16
      }
      {
        name: gpio_gpio
        width: 32
        type: inout
        idx: 17
        pad: ""
        attr: ""
        connection: muxed
        desc: ""
        glob_idx: 17
      }
      {
        name: gpio_gpio
        width: 32
        type: inout
        idx: 18
        pad: ""
        attr: ""
        connection: muxed
        desc: ""
        glob_idx: 18
      }
      {
        name: gpio_gpio
        width: 32
        type: inout
        idx: 19
        pad: ""
        attr: ""
        connection: muxed
        desc: ""
        glob_idx: 19
      }
      {
        name: gpio_gpio
        width: 32
        type: inout
        idx: 20
        pad: ""
        attr: ""
        connection: muxed
        desc: ""
        glob_idx: 20
      }
      {
        name: gpio_gpio
        width: 32
        type: inout
        idx: 21
        pad: ""
        attr: ""
        connection: muxed
        desc: ""
        glob_idx: 21
      }
      {
        name: gpio_gpio
        width: 32
        type: inout
        idx: 22
        pad: ""
        attr: ""
        connection: muxed
        desc: ""
        glob_idx: 22
      }
      {
        name: gpio_gpio
        width: 32
        type: inout
        idx: 23
        pad: ""
        attr: ""
        connection: muxed
        desc: ""
        glob_idx: 23
      }
      {
        name: gpio_gpio
        width: 32
        type: inout
        idx: 24
        pad: ""
        attr: ""
        connection: muxed
        desc: ""
        glob_idx: 24
      }
      {
        name: gpio_gpio
        width: 32
        type: inout
        idx: 25
        pad: ""
        attr: ""
        connection: muxed
        desc: ""
        glob_idx: 25
      }
      {
        name: gpio_gpio
        width: 32
        type: inout
        idx: 26
        pad: ""
        attr: ""
        connection: muxed
        desc: ""
        glob_idx: 26
      }
      {
        name: gpio_gpio
        width: 32
        type: inout
        idx: 27
        pad: ""
        attr: ""
        connection: muxed
        desc: ""
        glob_idx: 27
      }
      {
        name: gpio_gpio
        width: 32
        type: inout
        idx: 28
        pad: ""
        attr: ""
        connection: muxed
        desc: ""
        glob_idx: 28
      }
      {
        name: gpio_gpio
        width: 32
        type: inout
        idx: 29
        pad: ""
        attr: ""
        connection: muxed
        desc: ""
        glob_idx: 29
      }
      {
        name: gpio_gpio
        width: 32
        type: inout
        idx: 30
        pad: ""
        attr: ""
        connection: muxed
        desc: ""
        glob_idx: 30
      }
      {
        name: gpio_gpio
        width: 32
        type: inout
        idx: 31
        pad: ""
        attr: ""
        connection: muxed
        desc: ""
        glob_idx: 31
      }
      {
        name: spi_device_sck
        width: 1
        type: input
        idx: -1
        pad: SPI_DEV_CLK
        attr: InputStd
        connection: direct
        desc: ""
        glob_idx: 10
      }
      {
        name: spi_device_csb
        width: 1
        type: input
        idx: -1
        pad: SPI_DEV_CS_L
        attr: InputStd
        connection: direct
        desc: ""
        glob_idx: 11
      }
      {
        name: uart0_rx
        width: 1
        type: input
        idx: -1
        pad: ""
        attr: ""
        connection: muxed
        desc: ""
        glob_idx: 32
      }
      {
        name: uart1_rx
        width: 1
        type: input
        idx: -1
        pad: ""
        attr: ""
        connection: muxed
        desc: ""
        glob_idx: 33
      }
      {
        name: flash_ctrl_tck
        width: 1
        type: input
        idx: -1
        pad: ""
        attr: ""
        connection: muxed
        desc: ""
        glob_idx: 34
      }
      {
        name: flash_ctrl_tms
        width: 1
        type: input
        idx: -1
        pad: ""
        attr: ""
        connection: muxed
        desc: ""
        glob_idx: 35
      }
      {
        name: flash_ctrl_tdi
        width: 1
        type: input
        idx: -1
        pad: ""
        attr: ""
        connection: muxed
        desc: ""
        glob_idx: 36
      }
      {
        name: usbdev_sense
        width: 1
        type: input
        idx: -1
        pad: ""
        attr: ""
        connection: muxed
        desc: ""
        glob_idx: 37
      }
      {
        name: spi_host0_sck
        width: 1
        type: output
        idx: -1
        pad: SPI_HOST_CLK
        attr: BidirStd
        connection: direct
        desc: ""
        glob_idx: 12
      }
      {
        name: spi_host0_csb
        width: 1
        type: output
        idx: -1
        pad: SPI_HOST_CS_L
        attr: BidirStd
        connection: direct
        desc: ""
        glob_idx: 13
      }
      {
        name: uart0_tx
        width: 1
        type: output
        idx: -1
        pad: ""
        attr: ""
        connection: muxed
        desc: ""
        glob_idx: 32
      }
      {
        name: uart1_tx
        width: 1
        type: output
        idx: -1
        pad: ""
        attr: ""
        connection: muxed
        desc: ""
        glob_idx: 33
      }
      {
        name: flash_ctrl_tdo
        width: 1
        type: output
        idx: -1
        pad: ""
        attr: ""
        connection: muxed
        desc: ""
        glob_idx: 34
      }
    ]
    io_counts:
    {
      dedicated:
      {
        inouts: 10
        inputs: 2
        outputs: 2
        pads: 20
      }
      muxed:
      {
        inouts: 32
        inputs: 6
        outputs: 3
        pads: 47
      }
    }
  }
  targets:
  [
    {
      name: cw305
      pinout:
      {
        remove_ports: []
        remove_pads:
        [
          CC1
          CC2
          SPI_DEV_D2
          SPI_DEV_D3
          SPI_HOST_CLK
          SPI_HOST_CS_L
          SPI_HOST_D0
          SPI_HOST_D1
          SPI_HOST_D2
          SPI_HOST_D3
          FLASH_TEST_VOLT
          FLASH_TEST_MODE0
          FLASH_TEST_MODE1
          IOB7
          IOB8
          IOB9
          IOB10
          IOB11
          IOB12
          IOC6
          IOC7
          IOC9
          IOC10
          IOC11
          IOC12
          IOR0
          IOR1
          IOR2
          IOR3
          IOR5
          IOR6
          IOR7
          IOR10
          IOR11
          IOR12
          IOR13
        ]
        add_pads:
        [
          {
            name: IO_CLK
            type: InputStd
            bank: VCC
            connection: manual
            desc: Extra clock input for FPGA target
            port_type: inout
          }
          {
            name: POR_BUTTON_N
            type: InputStd
            bank: VCC
            connection: manual
            desc: POR from the push-button
            port_type: inout
          }
          {
            name: IO_USB_SENSE0
            type: BidirStd
            bank: VCC
            connection: manual
            desc: Manual USB signal for FPGA target
            port_type: inout
          }
          {
            name: IO_USB_DNPULLUP0
            type: BidirStd
            bank: VCC
            connection: manual
            desc: Manual USB signal for FPGA target
            port_type: inout
          }
          {
            name: IO_USB_DPPULLUP0
            type: BidirStd
            bank: VCC
            connection: manual
            desc: Manual USB signal for FPGA target
            port_type: inout
          }
          {
            name: IO_CLKOUT
            type: BidirStd
            bank: VCC
            connection: manual
            desc: Manual clock output for SCA setup
            port_type: inout
          }
          {
            name: IO_TRIGGER
            type: BidirStd
            bank: VCC
            connection: manual
            desc: Manual trigger output for SCA setup
            port_type: inout
          }
        ]
      }
      pinmux:
      {
        special_signals:
        [
          {
            name: tap0
            pad: IOC8
            desc: TAP strap signal.
            idx: 30
          }
          {
            name: tap1
            pad: IOC5
            desc: TAP strap signal.
            idx: 27
          }
          {
            name: dft0
            pad: IOR5
            desc: DFT strap signal.
            idx: 40
          }
          {
            name: dft1
            pad: IOR7
            desc: DFT strap signal.
            idx: 42
          }
          {
            name: tck
            pad: SPI_DEV_CLK
            desc: JTAG tck signal, overlaid on SPI_DEV.
            idx: 57
          }
          {
            name: tms
            pad: SPI_DEV_CS_L
            desc: JTAG tms signal, overlaid on SPI_DEV.
            idx: 58
          }
          {
            name: trst_n
            pad: IOR4
            desc: JTAG trst_n signal.
            idx: 39
          }
          {
            name: tdi
            pad: SPI_DEV_D0
            desc: JTAG tdi signal, overlaid on SPI_DEV.
            idx: 51
          }
          {
            name: tdo
            pad: SPI_DEV_D1
            desc: JTAG tdo signal, overlaid on SPI_DEV.
            idx: 52
          }
        ]
      }
    }
  ]
  exported_clks: {}
  wakeups:
  [
    {
      name: pin_wkup_req
      width: "1"
      module: pinmux_aon
    }
    {
      name: usb_wkup_req
      width: "1"
      module: pinmux_aon
    }
    {
      name: wkup_req
      width: "1"
      module: aon_timer_aon
    }
  ]
  reset_requests:
  {
    peripheral:
    [
      {
        name: aon_timer_rst_req
        width: "1"
        module: aon_timer_aon
        desc: watchdog reset requestt
      }
    ]
    int:
    [
      {
        name: MainPwr
        desc: main power glitch reset request
        module: pwrmgr_aon
      }
      {
        name: Esc
        desc: escalation reset request
        module: alert_handler
      }
    ]
    debug:
    [
      {
        name: Ndm
        desc: non-debug-module reset request
        module: rv_dm
      }
    ]
  }
  interrupt:
  [
    {
      name: uart0_tx_watermark
      width: 1
      type: interrupt
      module_name: uart0
      intr_type: IntrType.Status
      default_val: true
    }
    {
      name: uart0_rx_watermark
      width: 1
      type: interrupt
      module_name: uart0
      intr_type: IntrType.Status
      default_val: false
    }
    {
      name: uart0_tx_done
      width: 1
      type: interrupt
      module_name: uart0
      intr_type: IntrType.Event
      default_val: false
    }
    {
      name: uart0_rx_overflow
      width: 1
      type: interrupt
      module_name: uart0
      intr_type: IntrType.Event
      default_val: false
    }
    {
      name: uart0_rx_frame_err
      width: 1
      type: interrupt
      module_name: uart0
      intr_type: IntrType.Event
      default_val: false
    }
    {
      name: uart0_rx_break_err
      width: 1
      type: interrupt
      module_name: uart0
      intr_type: IntrType.Event
      default_val: false
    }
    {
      name: uart0_rx_timeout
      width: 1
      type: interrupt
      module_name: uart0
      intr_type: IntrType.Event
      default_val: false
    }
    {
      name: uart0_rx_parity_err
      width: 1
      type: interrupt
      module_name: uart0
      intr_type: IntrType.Event
      default_val: false
    }
    {
      name: uart0_tx_empty
      width: 1
      type: interrupt
      module_name: uart0
      intr_type: IntrType.Status
      default_val: true
    }
    {
      name: uart1_tx_watermark
      width: 1
      type: interrupt
      module_name: uart1
      intr_type: IntrType.Status
      default_val: true
    }
    {
      name: uart1_rx_watermark
      width: 1
      type: interrupt
      module_name: uart1
      intr_type: IntrType.Status
      default_val: false
    }
    {
      name: uart1_tx_done
      width: 1
      type: interrupt
      module_name: uart1
      intr_type: IntrType.Event
      default_val: false
    }
    {
      name: uart1_rx_overflow
      width: 1
      type: interrupt
      module_name: uart1
      intr_type: IntrType.Event
      default_val: false
    }
    {
      name: uart1_rx_frame_err
      width: 1
      type: interrupt
      module_name: uart1
      intr_type: IntrType.Event
      default_val: false
    }
    {
      name: uart1_rx_break_err
      width: 1
      type: interrupt
      module_name: uart1
      intr_type: IntrType.Event
      default_val: false
    }
    {
      name: uart1_rx_timeout
      width: 1
      type: interrupt
      module_name: uart1
      intr_type: IntrType.Event
      default_val: false
    }
    {
      name: uart1_rx_parity_err
      width: 1
      type: interrupt
      module_name: uart1
      intr_type: IntrType.Event
      default_val: false
    }
    {
      name: uart1_tx_empty
      width: 1
      type: interrupt
      module_name: uart1
      intr_type: IntrType.Status
      default_val: true
    }
    {
      name: gpio_gpio
      width: 32
      type: interrupt
      module_name: gpio
      intr_type: IntrType.Event
      default_val: false
    }
    {
      name: spi_device_upload_cmdfifo_not_empty
      width: 1
      type: interrupt
      module_name: spi_device
      intr_type: IntrType.Event
      default_val: false
    }
    {
      name: spi_device_upload_payload_not_empty
      width: 1
      type: interrupt
      module_name: spi_device
      intr_type: IntrType.Event
      default_val: false
    }
    {
      name: spi_device_upload_payload_overflow
      width: 1
      type: interrupt
      module_name: spi_device
      intr_type: IntrType.Event
      default_val: false
    }
    {
      name: spi_device_readbuf_watermark
      width: 1
      type: interrupt
      module_name: spi_device
      intr_type: IntrType.Event
      default_val: false
    }
    {
      name: spi_device_readbuf_flip
      width: 1
      type: interrupt
      module_name: spi_device
      intr_type: IntrType.Event
      default_val: false
    }
    {
      name: spi_device_tpm_header_not_empty
      width: 1
      type: interrupt
      module_name: spi_device
      intr_type: IntrType.Status
      default_val: false
    }
    {
      name: spi_device_tpm_rdfifo_cmd_end
      width: 1
      type: interrupt
      module_name: spi_device
      intr_type: IntrType.Event
      default_val: false
    }
    {
      name: spi_device_tpm_rdfifo_drop
      width: 1
      type: interrupt
      module_name: spi_device
      intr_type: IntrType.Event
      default_val: false
    }
    {
      name: spi_host0_error
      width: 1
      type: interrupt
      module_name: spi_host0
      intr_type: IntrType.Event
      default_val: false
    }
    {
      name: spi_host0_spi_event
      width: 1
      type: interrupt
      module_name: spi_host0
      intr_type: IntrType.Status
      default_val: false
    }
    {
      name: usbdev_pkt_received
      width: 1
      type: interrupt
      module_name: usbdev
      intr_type: IntrType.Status
      default_val: false
    }
    {
      name: usbdev_pkt_sent
      width: 1
      type: interrupt
      module_name: usbdev
      intr_type: IntrType.Status
      default_val: false
    }
    {
      name: usbdev_disconnected
      width: 1
      type: interrupt
      module_name: usbdev
      intr_type: IntrType.Event
      default_val: false
    }
    {
      name: usbdev_host_lost
      width: 1
      type: interrupt
      module_name: usbdev
      intr_type: IntrType.Event
      default_val: false
    }
    {
      name: usbdev_link_reset
      width: 1
      type: interrupt
      module_name: usbdev
      intr_type: IntrType.Event
      default_val: false
    }
    {
      name: usbdev_link_suspend
      width: 1
      type: interrupt
      module_name: usbdev
      intr_type: IntrType.Event
      default_val: false
    }
    {
      name: usbdev_link_resume
      width: 1
      type: interrupt
      module_name: usbdev
      intr_type: IntrType.Event
      default_val: false
    }
    {
      name: usbdev_av_out_empty
      width: 1
      type: interrupt
      module_name: usbdev
      intr_type: IntrType.Status
      default_val: false
    }
    {
      name: usbdev_rx_full
      width: 1
      type: interrupt
      module_name: usbdev
      intr_type: IntrType.Status
      default_val: false
    }
    {
      name: usbdev_av_overflow
      width: 1
      type: interrupt
      module_name: usbdev
      intr_type: IntrType.Event
      default_val: false
    }
    {
      name: usbdev_link_in_err
      width: 1
      type: interrupt
      module_name: usbdev
      intr_type: IntrType.Event
      default_val: false
    }
    {
      name: usbdev_rx_crc_err
      width: 1
      type: interrupt
      module_name: usbdev
      intr_type: IntrType.Event
      default_val: false
    }
    {
      name: usbdev_rx_pid_err
      width: 1
      type: interrupt
      module_name: usbdev
      intr_type: IntrType.Event
      default_val: false
    }
    {
      name: usbdev_rx_bitstuff_err
      width: 1
      type: interrupt
      module_name: usbdev
      intr_type: IntrType.Event
      default_val: false
    }
    {
      name: usbdev_frame
      width: 1
      type: interrupt
      module_name: usbdev
      intr_type: IntrType.Event
      default_val: false
    }
    {
      name: usbdev_powered
      width: 1
      type: interrupt
      module_name: usbdev
      intr_type: IntrType.Event
      default_val: false
    }
    {
      name: usbdev_link_out_err
      width: 1
      type: interrupt
      module_name: usbdev
      intr_type: IntrType.Event
      default_val: false
    }
    {
      name: usbdev_av_setup_empty
      width: 1
      type: interrupt
      module_name: usbdev
      intr_type: IntrType.Status
      default_val: false
    }
    {
      name: pwrmgr_aon_wakeup
      width: 1
      type: interrupt
      module_name: pwrmgr_aon
      intr_type: IntrType.Event
      default_val: false
    }
    {
      name: aon_timer_aon_wkup_timer_expired
      width: 1
      type: interrupt
      module_name: aon_timer_aon
      intr_type: IntrType.Event
      default_val: false
    }
    {
      name: aon_timer_aon_wdog_timer_bark
      width: 1
      type: interrupt
      module_name: aon_timer_aon
      intr_type: IntrType.Event
      default_val: false
    }
    {
      name: flash_ctrl_prog_empty
      width: 1
      type: interrupt
      module_name: flash_ctrl
      intr_type: IntrType.Status
      default_val: true
    }
    {
      name: flash_ctrl_prog_lvl
      width: 1
      type: interrupt
      module_name: flash_ctrl
      intr_type: IntrType.Status
      default_val: true
    }
    {
      name: flash_ctrl_rd_full
      width: 1
      type: interrupt
      module_name: flash_ctrl
      intr_type: IntrType.Status
      default_val: false
    }
    {
      name: flash_ctrl_rd_lvl
      width: 1
      type: interrupt
      module_name: flash_ctrl
      intr_type: IntrType.Status
      default_val: false
    }
    {
      name: flash_ctrl_op_done
      width: 1
      type: interrupt
      module_name: flash_ctrl
      intr_type: IntrType.Event
      default_val: false
    }
    {
      name: flash_ctrl_corr_err
      width: 1
      type: interrupt
      module_name: flash_ctrl
      intr_type: IntrType.Event
      default_val: false
    }
  ]
  alert_module:
  [
    uart0
    uart1
    gpio
    spi_device
    spi_host0
    rv_timer
    usbdev
    pwrmgr_aon
    rstmgr_aon
    clkmgr_aon
    pinmux_aon
    aon_timer_aon
    flash_ctrl
    rv_plic
    aes
    sram_ctrl_main
    rom_ctrl
    rv_core_ibex
  ]
  alert:
  [
    {
      name: uart0_fatal_fault
      width: 1
      type: alert
      async: "1"
      module_name: uart0
      lpg_name: peri_lc_io_div4_0
      lpg_idx: 0
    }
    {
      name: uart1_fatal_fault
      width: 1
      type: alert
      async: "1"
      module_name: uart1
      lpg_name: peri_lc_io_div4_0
      lpg_idx: 0
    }
    {
      name: gpio_fatal_fault
      width: 1
      type: alert
      async: "1"
      module_name: gpio
      lpg_name: peri_sys_io_div4_0
      lpg_idx: 1
    }
    {
      name: spi_device_fatal_fault
      width: 1
      type: alert
      async: "1"
      module_name: spi_device
      lpg_name: peri_spi_device_0
      lpg_idx: 2
    }
    {
      name: spi_host0_fatal_fault
      width: 1
      type: alert
      async: "1"
      module_name: spi_host0
      lpg_name: peri_spi_host0_0
      lpg_idx: 3
    }
    {
      name: rv_timer_fatal_fault
      width: 1
      type: alert
      async: "1"
      module_name: rv_timer
      lpg_name: timers_sys_io_div4_0
      lpg_idx: 4
    }
    {
      name: usbdev_fatal_fault
      width: 1
      type: alert
      async: "1"
      module_name: usbdev
      lpg_name: peri_usb_0
      lpg_idx: 5
    }
    {
      name: pwrmgr_aon_fatal_fault
      width: 1
      type: alert
      async: "1"
      module_name: pwrmgr_aon
      lpg_name: powerup_por_io_div4_Aon
      lpg_idx: 6
    }
    {
      name: rstmgr_aon_fatal_fault
      width: 1
      type: alert
      async: "1"
      module_name: rstmgr_aon
      lpg_name: powerup_lc_io_div4_Aon
      lpg_idx: 7
    }
    {
      name: rstmgr_aon_fatal_cnsty_fault
      width: 1
      type: alert
      async: "1"
      module_name: rstmgr_aon
      lpg_name: powerup_lc_io_div4_Aon
      lpg_idx: 7
    }
    {
      name: clkmgr_aon_recov_fault
      width: 1
      type: alert
      async: "1"
      module_name: clkmgr_aon
      lpg_name: powerup_por_io_div4_Aon
      lpg_idx: 6
    }
    {
      name: clkmgr_aon_fatal_fault
      width: 1
      type: alert
      async: "1"
      module_name: clkmgr_aon
      lpg_name: powerup_por_io_div4_Aon
      lpg_idx: 6
    }
    {
      name: pinmux_aon_fatal_fault
      width: 1
      type: alert
      async: "1"
      module_name: pinmux_aon
      lpg_name: powerup_lc_io_div4_Aon
      lpg_idx: 7
    }
    {
      name: aon_timer_aon_fatal_fault
      width: 1
      type: alert
      async: "1"
      module_name: aon_timer_aon
      lpg_name: timers_sys_io_div4_Aon
      lpg_idx: 8
    }
    {
      name: flash_ctrl_recov_err
      width: 1
      type: alert
      async: "1"
      module_name: flash_ctrl
      lpg_name: infra_lc_0
      lpg_idx: 10
    }
    {
      name: flash_ctrl_fatal_std_err
      width: 1
      type: alert
      async: "1"
      module_name: flash_ctrl
      lpg_name: infra_lc_0
      lpg_idx: 10
    }
    {
      name: flash_ctrl_fatal_err
      width: 1
      type: alert
      async: "1"
      module_name: flash_ctrl
      lpg_name: infra_lc_0
      lpg_idx: 10
    }
    {
      name: flash_ctrl_fatal_prim_flash_alert
      width: 1
      type: alert
      async: "1"
      module_name: flash_ctrl
      lpg_name: infra_lc_0
      lpg_idx: 10
    }
    {
      name: flash_ctrl_recov_prim_flash_alert
      width: 1
      type: alert
      async: "1"
      module_name: flash_ctrl
      lpg_name: infra_lc_0
      lpg_idx: 10
    }
    {
      name: rv_plic_fatal_fault
      width: 1
      type: alert
      async: "1"
      module_name: rv_plic
      lpg_name: secure_sys_0
      lpg_idx: 11
    }
    {
      name: aes_recov_ctrl_update_err
      width: 1
      type: alert
      async: "1"
      module_name: aes
      lpg_name: aes_trans_sys_0
      lpg_idx: 12
    }
    {
      name: aes_fatal_fault
      width: 1
      type: alert
      async: "1"
      module_name: aes
      lpg_name: aes_trans_sys_0
      lpg_idx: 12
    }
    {
      name: sram_ctrl_main_fatal_error
      width: 1
      type: alert
      async: "1"
      module_name: sram_ctrl_main
      lpg_name: secure_sys_0
      lpg_idx: 11
    }
    {
      name: rom_ctrl_fatal
      width: 1
      type: alert
      async: "1"
      module_name: rom_ctrl
      lpg_name: infra_sys_0
      lpg_idx: 13
    }
    {
      name: rv_core_ibex_fatal_sw_err
      width: 1
      type: alert
      async: "1"
      module_name: rv_core_ibex
      lpg_name: infra_sys_0
      lpg_idx: 13
    }
    {
      name: rv_core_ibex_recov_sw_err
      width: 1
      type: alert
      async: "1"
      module_name: rv_core_ibex
      lpg_name: infra_sys_0
      lpg_idx: 13
    }
    {
      name: rv_core_ibex_fatal_hw_err
      width: 1
      type: alert
      async: "1"
      module_name: rv_core_ibex
      lpg_name: infra_sys_0
      lpg_idx: 13
    }
    {
      name: rv_core_ibex_recov_hw_err
      width: 1
      type: alert
      async: "1"
      module_name: rv_core_ibex
      lpg_name: infra_sys_0
      lpg_idx: 13
    }
  ]
  exported_rsts: {}
  alert_lpgs:
  [
    {
      name: peri_lc_io_div4_0
      clock_group:
      {
        name: peri
        src: top
        sw_cg: yes
        unique: no
        clocks:
        {
          clk_io_div4_peri: io_div4
          clk_io_div2_peri: io_div2
          clk_io_peri: io
          clk_usb_peri: usb
          clk_aon_peri: aon
        }
      }
      clock_connection: clkmgr_aon_clocks.clk_io_div4_peri
      reset_connection:
      {
        name: lc_io_div4
        domain: "0"
      }
    }
    {
      name: peri_sys_io_div4_0
      clock_group:
      {
        name: peri
        src: top
        sw_cg: yes
        unique: no
        clocks:
        {
          clk_io_div4_peri: io_div4
          clk_io_div2_peri: io_div2
          clk_io_peri: io
          clk_usb_peri: usb
          clk_aon_peri: aon
        }
      }
      clock_connection: clkmgr_aon_clocks.clk_io_div4_peri
      reset_connection:
      {
        name: sys_io_div4
        domain: "0"
      }
    }
    {
      name: peri_spi_device_0
      clock_group:
      {
        name: peri
        src: top
        sw_cg: yes
        unique: no
        clocks:
        {
          clk_io_div4_peri: io_div4
          clk_io_div2_peri: io_div2
          clk_io_peri: io
          clk_usb_peri: usb
          clk_aon_peri: aon
        }
      }
      clock_connection: clkmgr_aon_clocks.clk_io_div4_peri
      reset_connection:
      {
        name: spi_device
        domain: "0"
      }
    }
    {
      name: peri_spi_host0_0
      clock_group:
      {
        name: peri
        src: top
        sw_cg: yes
        unique: no
        clocks:
        {
          clk_io_div4_peri: io_div4
          clk_io_div2_peri: io_div2
          clk_io_peri: io
          clk_usb_peri: usb
          clk_aon_peri: aon
        }
      }
      clock_connection: clkmgr_aon_clocks.clk_io_peri
      reset_connection:
      {
        name: spi_host0
        domain: "0"
      }
    }
    {
      name: timers_sys_io_div4_0
      clock_group:
      {
        name: timers
        src: top
        sw_cg: no
        unique: no
        clocks:
        {
          clk_io_div4_timers: io_div4
          clk_aon_timers: aon
        }
      }
      clock_connection: clkmgr_aon_clocks.clk_io_div4_timers
      reset_connection:
      {
        name: sys_io_div4
        domain: "0"
      }
    }
    {
      name: peri_usb_0
      clock_group:
      {
        name: peri
        src: top
        sw_cg: yes
        unique: no
        clocks:
        {
          clk_io_div4_peri: io_div4
          clk_io_div2_peri: io_div2
          clk_io_peri: io
          clk_usb_peri: usb
          clk_aon_peri: aon
        }
      }
      clock_connection: clkmgr_aon_clocks.clk_usb_peri
      reset_connection:
      {
        name: usb
        domain: "0"
      }
    }
    {
      name: powerup_por_io_div4_Aon
      clock_group:
      {
        name: powerup
        src: top
        sw_cg: no
        unique: no
        clocks:
        {
          clk_io_div4_powerup: io_div4
          clk_aon_powerup: aon
          clk_main_powerup: main
          clk_io_powerup: io
          clk_usb_powerup: usb
          clk_io_div2_powerup: io_div2
        }
      }
      clock_connection: clkmgr_aon_clocks.clk_io_div4_powerup
      reset_connection:
      {
        name: por_io_div4
        domain: Aon
      }
    }
    {
      name: powerup_lc_io_div4_Aon
      clock_group:
      {
        name: powerup
        src: top
        sw_cg: no
        unique: no
        clocks:
        {
          clk_io_div4_powerup: io_div4
          clk_aon_powerup: aon
          clk_main_powerup: main
          clk_io_powerup: io
          clk_usb_powerup: usb
          clk_io_div2_powerup: io_div2
        }
      }
      clock_connection: clkmgr_aon_clocks.clk_io_div4_powerup
      reset_connection:
      {
        name: lc_io_div4
        domain: Aon
      }
    }
    {
      name: timers_sys_io_div4_Aon
      clock_group:
      {
        name: timers
        src: top
        sw_cg: no
        unique: no
        clocks:
        {
          clk_io_div4_timers: io_div4
          clk_aon_timers: aon
        }
      }
      clock_connection: clkmgr_aon_clocks.clk_io_div4_timers
      reset_connection:
      {
        name: sys_io_div4
        domain: Aon
      }
    }
    {
      name: secure_lc_io_div4_0
      clock_group:
      {
        name: secure
        src: top
        sw_cg: no
        unique: no
        clocks:
        {
          clk_io_div4_secure: io_div4
          clk_aon_secure: aon
          clk_main_secure: main
        }
      }
      clock_connection: clkmgr_aon_clocks.clk_io_div4_secure
      reset_connection:
      {
        name: lc_io_div4
        domain: "0"
      }
    }
    {
      name: infra_lc_0
      clock_group:
      {
        name: infra
        src: top
        sw_cg: no
        unique: no
        clocks:
        {
          clk_main_infra: main
          clk_io_div4_infra: io_div4
          clk_io_infra: io
          clk_usb_infra: usb
        }
      }
      clock_connection: clkmgr_aon_clocks.clk_main_infra
      reset_connection:
      {
        name: lc
        domain: "0"
      }
    }
    {
      name: secure_sys_0
      clock_group:
      {
        name: secure
        src: top
        sw_cg: no
        unique: no
        clocks:
        {
          clk_io_div4_secure: io_div4
          clk_aon_secure: aon
          clk_main_secure: main
        }
      }
      clock_connection: clkmgr_aon_clocks.clk_main_secure
      reset_connection:
      {
        name: sys
        domain: "0"
      }
    }
    {
      name: aes_trans_sys_0
      clock_group:
      {
        name: trans
        src: top
        sw_cg: hint
        unique: yes
        clocks:
        {
          clk_main_aes: main
        }
      }
      clock_connection: clkmgr_aon_clocks.clk_main_aes
      reset_connection:
      {
        name: sys
        domain: "0"
      }
    }
    {
      name: infra_sys_0
      clock_group:
      {
        name: infra
        src: top
        sw_cg: no
        unique: no
        clocks:
        {
          clk_main_infra: main
          clk_io_div4_infra: io_div4
          clk_io_infra: io
          clk_usb_infra: usb
        }
      }
      clock_connection: clkmgr_aon_clocks.clk_main_infra
      reset_connection:
      {
        name: sys
        domain: "0"
      }
    }
  ]
  inter_signal:
  {
    signals:
    [
      {
        name: tl
        struct: tl
        package: tlul_pkg
        type: req_rsp
        act: rsp
        width: 1
        inst_name: uart0
        default: ""
        end_idx: -1
        top_signame: uart0_tl
        index: -1
      }
      {
        name: tl
        struct: tl
        package: tlul_pkg
        type: req_rsp
        act: rsp
        width: 1
        inst_name: uart1
        default: ""
        end_idx: -1
        top_signame: uart1_tl
        index: -1
      }
      {
        name: tl
        struct: tl
        package: tlul_pkg
        type: req_rsp
        act: rsp
        width: 1
        inst_name: gpio
        default: ""
        end_idx: -1
        top_signame: gpio_tl
        index: -1
      }
      {
        name: ram_cfg
        struct: ram_2p_cfg
        package: prim_ram_2p_pkg
        type: uni
        act: rcv
        width: 1
        inst_name: spi_device
        index: -1
      }
      {
        name: passthrough
        struct: passthrough
        package: spi_device_pkg
        type: req_rsp
        act: req
        width: 1
        inst_name: spi_device
        default: ""
        end_idx: -1
        top_signame: spi_device_passthrough
        index: -1
      }
      {
        name: mbist_en
        struct: logic
        type: uni
        act: rcv
        width: 1
        inst_name: spi_device
        index: -1
      }
      {
        name: sck_monitor
        struct: logic
        type: uni
        act: req
        width: 1
        inst_name: spi_device
        default: ""
        package: ""
        external: true
        top_signame: sck_monitor
        conn_type: false
        index: -1
      }
      {
        name: tl
        struct: tl
        package: tlul_pkg
        type: req_rsp
        act: rsp
        width: 1
        inst_name: spi_device
        default: ""
        end_idx: -1
        top_signame: spi_device_tl
        index: -1
      }
      {
        name: passthrough
        struct: passthrough
        package: spi_device_pkg
        type: req_rsp
        act: rsp
        width: 1
        inst_name: spi_host0
        default: ""
        top_signame: spi_device_passthrough
        index: -1
      }
      {
        name: tl
        struct: tl
        package: tlul_pkg
        type: req_rsp
        act: rsp
        width: 1
        inst_name: spi_host0
        default: ""
        end_idx: -1
        top_signame: spi_host0_tl
        index: -1
      }
      {
        name: tl
        struct: tl
        package: tlul_pkg
        type: req_rsp
        act: rsp
        width: 1
        inst_name: rv_timer
        default: ""
        end_idx: -1
        top_signame: rv_timer_tl
        index: -1
      }
      {
        name: usb_rx_d
        desc: USB RX data from an external differential receiver, if available
        struct: logic
        type: uni
        act: rcv
        width: 1
        inst_name: usbdev
        default: ""
        package: ""
        external: true
        top_signame: usbdev_usb_rx_d
        conn_type: false
        index: -1
      }
      {
        name: usb_tx_d
        desc: USB transmit data value (not used if usb_tx_se0 is set)
        struct: logic
        type: uni
        act: req
        width: 1
        inst_name: usbdev
        default: ""
        package: ""
        external: true
        top_signame: usbdev_usb_tx_d
        conn_type: false
        index: -1
      }
      {
        name: usb_tx_se0
        desc: Force transmission of a USB single-ended zero (i.e. both D+ and D- are low) regardless of usb_tx_d
        struct: logic
        type: uni
        act: req
        width: 1
        inst_name: usbdev
        default: ""
        package: ""
        external: true
        top_signame: usbdev_usb_tx_se0
        conn_type: false
        index: -1
      }
      {
        name: usb_tx_use_d_se0
        desc: Use the usb_tx_d and usb_tx_se0 TX interface, instead of usb_dp_o and usb_dn_o
        struct: logic
        type: uni
        act: req
        width: 1
        inst_name: usbdev
        default: ""
        package: ""
        external: true
        top_signame: usbdev_usb_tx_use_d_se0
        conn_type: false
        index: -1
      }
      {
        name: usb_dp_pullup
        desc: USB D+ pullup control
        struct: logic
        type: uni
        act: req
        width: 1
        inst_name: usbdev
        default: ""
        package: ""
        end_idx: -1
        top_type: broadcast
        top_signame: usbdev_usb_dp_pullup
        index: -1
      }
      {
        name: usb_dn_pullup
        desc: USB D- pullup control
        struct: logic
        type: uni
        act: req
        width: 1
        inst_name: usbdev
        default: ""
        package: ""
        end_idx: -1
        top_type: broadcast
        top_signame: usbdev_usb_dn_pullup
        index: -1
      }
      {
        name: usb_rx_enable
        desc: USB differential receiver enable
        struct: logic
        type: uni
        act: req
        width: 1
        inst_name: usbdev
        default: ""
        package: ""
        external: true
        top_signame: usbdev_usb_rx_enable
        conn_type: false
        index: -1
      }
      {
        name: usb_ref_val
        desc: This indicates that USB timing reference signal 'usb_ref_pulse' is valid
        struct: logic
        type: uni
        act: req
        width: 1
        inst_name: usbdev
        default: ""
        package: ""
        external: true
        top_signame: usbdev_usb_ref_val
        conn_type: false
        index: -1
      }
      {
        name: usb_ref_pulse
        desc: USB timing reference signal. This signal pulses for a single 48MHz clock every 1ms USB frame
        struct: logic
        type: uni
        act: req
        width: 1
        inst_name: usbdev
        default: ""
        package: ""
        external: true
        top_signame: usbdev_usb_ref_pulse
        conn_type: false
        index: -1
      }
      {
        name: usb_aon_suspend_req
        desc: Request to activate the AON/Wake module and take control of the USB pullups
        struct: logic
        type: uni
        act: req
        width: 1
        inst_name: usbdev
        default: ""
        package: ""
        end_idx: -1
        top_type: broadcast
        top_signame: usbdev_usb_aon_suspend_req
        index: -1
      }
      {
        name: usb_aon_wake_ack
        desc: Acknowledge a wake signal from the AON/Wake and relinquish control of the USB pullups
        struct: logic
        type: uni
        act: req
        width: 1
        inst_name: usbdev
        default: ""
        package: ""
        end_idx: -1
        top_type: broadcast
        top_signame: usbdev_usb_aon_wake_ack
        index: -1
      }
      {
        name: usb_aon_bus_reset
        desc: Indicates that the reason for waking was that a USB Bus Reset occurred
        struct: logic
        type: uni
        act: rcv
        width: 1
        inst_name: usbdev
        default: ""
        package: ""
        end_idx: -1
        top_type: broadcast
        top_signame: usbdev_usb_aon_bus_reset
        index: -1
      }
      {
        name: usb_aon_sense_lost
        desc: Indicates that the reason for waking was that the VBUS/SENSE signal became deasserted
        struct: logic
        type: uni
        act: rcv
        width: 1
        inst_name: usbdev
        default: ""
        package: ""
        end_idx: -1
        top_type: broadcast
        top_signame: usbdev_usb_aon_sense_lost
        index: -1
      }
      {
        name: usb_aon_bus_not_idle
        desc: Indicates that the reason for waking was that the USB is in a non-idle state
        struct: logic
        type: uni
        act: rcv
        width: 1
        inst_name: usbdev
        index: -1
      }
      {
        name: usb_aon_wake_detect_active
        desc: Indicates that the external AON/Wake module is active and controlling the USB pullups
        struct: logic
        type: uni
        act: rcv
        width: 1
        inst_name: usbdev
        default: ""
        package: ""
        top_signame: pinmux_aon_usbdev_wake_detect_active
        index: -1
      }
      {
        name: ram_cfg
        struct: ram_1p_cfg
        package: prim_ram_1p_pkg
        type: uni
        act: rcv
        width: 1
        inst_name: usbdev
        index: -1
      }
      {
        name: tl
        struct: tl
        package: tlul_pkg
        type: req_rsp
        act: rsp
        width: 1
        inst_name: usbdev
        default: ""
        end_idx: -1
        top_signame: usbdev_tl
        index: -1
      }
      {
        name: pwr_ast
        struct: pwr_ast
        package: pwrmgr_pkg
        type: req_rsp
        act: req
        width: 1
        inst_name: pwrmgr_aon
        default: ""
        external: true
        top_signame: pwrmgr_ast
        conn_type: false
        index: -1
      }
      {
        name: pwr_rst
        struct: pwr_rst
        package: pwrmgr_pkg
        type: req_rsp
        act: req
        width: 1
        inst_name: pwrmgr_aon
        default: ""
        end_idx: -1
        top_signame: pwrmgr_aon_pwr_rst
        index: -1
      }
      {
        name: pwr_clk
        struct: pwr_clk
        package: pwrmgr_pkg
        type: req_rsp
        act: req
        width: 1
        inst_name: pwrmgr_aon
        default: ""
        end_idx: -1
        top_signame: pwrmgr_aon_pwr_clk
        index: -1
      }
      {
        name: pwr_otp
        struct: pwr_otp
        package: pwrmgr_pkg
        type: req_rsp
        act: req
        width: 1
        inst_name: pwrmgr_aon
        index: -1
      }
      {
        name: pwr_lc
        struct: pwr_lc
        package: pwrmgr_pkg
        type: req_rsp
        act: req
        width: 1
        inst_name: pwrmgr_aon
        index: -1
      }
      {
        name: pwr_flash
        struct: pwr_flash
        package: pwrmgr_pkg
        type: uni
        act: rcv
        width: 1
        inst_name: pwrmgr_aon
        default: ""
        end_idx: -1
        top_type: broadcast
        top_signame: pwrmgr_aon_pwr_flash
        index: -1
      }
      {
        name: esc_rst_tx
        struct: esc_tx
        package: prim_esc_pkg
        type: uni
        act: rcv
        width: 1
        inst_name: pwrmgr_aon
        index: -1
      }
      {
        name: esc_rst_rx
        struct: esc_rx
        package: prim_esc_pkg
        type: uni
        act: req
        width: 1
        inst_name: pwrmgr_aon
        index: -1
      }
      {
        name: pwr_cpu
        struct: pwr_cpu
        package: pwrmgr_pkg
        type: uni
        act: rcv
        width: 1
        inst_name: pwrmgr_aon
        default: ""
        top_signame: rv_core_ibex_pwrmgr
        index: -1
      }
      {
        name: wakeups
        struct: logic
        type: uni
        act: rcv
        width: 3
        inst_name: pwrmgr_aon
        default: ""
        package: ""
        end_idx: -1
        top_type: one-to-N
        top_signame: pwrmgr_aon_wakeups
        index: -1
      }
      {
        name: rstreqs
        struct: logic
        type: uni
        act: rcv
        width: 1
        inst_name: pwrmgr_aon
        default: ""
        package: ""
        end_idx: -1
        top_type: broadcast
        top_signame: pwrmgr_aon_rstreqs
        index: -1
      }
      {
        name: ndmreset_req
        struct: logic
        type: uni
        act: rcv
        width: 1
        inst_name: pwrmgr_aon
        index: -1
      }
      {
        name: strap
        struct: logic
        type: uni
        act: req
        width: 1
        inst_name: pwrmgr_aon
        default: ""
        package: ""
        end_idx: -1
        top_type: broadcast
        top_signame: pwrmgr_aon_strap
        index: -1
      }
      {
        name: low_power
        struct: logic
        type: uni
        act: req
        width: 1
        inst_name: pwrmgr_aon
        default: ""
        package: ""
        end_idx: -1
        top_type: broadcast
        top_signame: pwrmgr_aon_low_power
        index: -1
      }
      {
        name: rom_ctrl
        struct: pwrmgr_data
        package: rom_ctrl_pkg
        type: uni
        act: rcv
        width: 1
        inst_name: pwrmgr_aon
        index: -1
      }
      {
        name: fetch_en
        struct: lc_tx
        package: lc_ctrl_pkg
        type: uni
        act: req
        width: 1
        inst_name: pwrmgr_aon
        default: ""
        end_idx: -1
        top_type: broadcast
        top_signame: pwrmgr_aon_fetch_en
        index: -1
      }
      {
        name: lc_dft_en
        struct: lc_tx
        package: lc_ctrl_pkg
        type: uni
        act: rcv
        width: 1
        inst_name: pwrmgr_aon
        index: -1
      }
      {
        name: lc_hw_debug_en
        struct: lc_tx
        package: lc_ctrl_pkg
        type: uni
        act: rcv
        width: 1
        inst_name: pwrmgr_aon
        index: -1
      }
      {
        name: sw_rst_req
        struct: mubi4
        package: prim_mubi_pkg
        type: uni
        act: rcv
        width: 1
        inst_name: pwrmgr_aon
        default: ""
        top_signame: rstmgr_aon_sw_rst_req
        index: -1
      }
      {
        name: tl
        struct: tl
        package: tlul_pkg
        type: req_rsp
        act: rsp
        width: 1
        inst_name: pwrmgr_aon
        default: ""
        end_idx: -1
        top_signame: pwrmgr_aon_tl
        index: -1
      }
      {
        name: por_n
        desc:
          '''
          Root power on reset signals from ast.
          There is one root reset signal for each core power domain.
          '''
        struct: logic
        type: uni
        act: rcv
        width: 2
        inst_name: rstmgr_aon
        default: ""
        package: ""
        external: true
        top_signame: por_n
        conn_type: false
        index: -1
      }
      {
        name: pwr
        desc:
          '''
          Reset request signals from power manager.
          Power manager can request for specific domains of the lc/sys reset tree to assert.
          '''
        struct: pwr_rst
        type: req_rsp
        act: rsp
        width: 1
        inst_name: rstmgr_aon
        default: ""
        package: pwrmgr_pkg
        top_signame: pwrmgr_aon_pwr_rst
        index: -1
      }
      {
        name: resets
        desc: Leaf resets fed to the system.
        struct: rstmgr_out
        package: rstmgr_pkg
        type: uni
        act: req
        width: 1
        inst_name: rstmgr_aon
        default: ""
        top_signame: rstmgr_aon_resets
        index: -1
      }
      {
        name: rst_en
        desc: Low-power-group outputs used by alert handler.
        struct: rstmgr_rst_en
        package: rstmgr_pkg
        type: uni
        act: req
        width: 1
        inst_name: rstmgr_aon
        default: ""
        top_signame: rstmgr_aon_rst_en
        index: -1
      }
      {
        name: alert_dump
        desc: Alert handler crash dump information.
        struct: alert_crashdump
        package: alert_pkg
        type: uni
        act: rcv
        width: 1
        inst_name: rstmgr_aon
        index: -1
      }
      {
        name: cpu_dump
        desc: Main processing element crash dump information.
        struct: cpu_crash_dump
        package: rv_core_ibex_pkg
        type: uni
        act: rcv
        width: 1
        inst_name: rstmgr_aon
        default: ""
        top_signame: rv_core_ibex_crash_dump
        index: -1
      }
      {
        name: sw_rst_req
        desc: Software requested system reset to pwrmgr.
        struct: mubi4
        package: prim_mubi_pkg
        type: uni
        act: req
        width: 1
        inst_name: rstmgr_aon
        default: ""
        end_idx: -1
        top_type: broadcast
        top_signame: rstmgr_aon_sw_rst_req
        index: -1
      }
      {
        name: tl
        struct: tl
        package: tlul_pkg
        type: req_rsp
        act: rsp
        width: 1
        inst_name: rstmgr_aon
        default: ""
        end_idx: -1
        top_signame: rstmgr_aon_tl
        index: -1
      }
      {
        name: clocks
        struct: clkmgr_out
        package: clkmgr_pkg
        type: uni
        act: req
        width: 1
        inst_name: clkmgr_aon
        default: ""
        top_signame: clkmgr_aon_clocks
        index: -1
      }
      {
        name: cg_en
        struct: clkmgr_cg_en
        package: clkmgr_pkg
        type: uni
        act: req
        width: 1
        inst_name: clkmgr_aon
        default: ""
        top_signame: clkmgr_aon_cg_en
        index: -1
      }
      {
        name: lc_hw_debug_en
        struct: lc_tx
        package: lc_ctrl_pkg
        type: uni
        act: rcv
        width: 1
        inst_name: clkmgr_aon
        index: -1
      }
      {
        name: io_clk_byp_req
        struct: mubi4
        package: prim_mubi_pkg
        type: uni
        act: req
        width: 1
        inst_name: clkmgr_aon
        default: ""
        external: true
        top_signame: io_clk_byp_req
        conn_type: false
        index: -1
      }
      {
        name: io_clk_byp_ack
        struct: mubi4
        package: prim_mubi_pkg
        type: uni
        act: rcv
        width: 1
        inst_name: clkmgr_aon
        default: ""
        external: true
        top_signame: io_clk_byp_ack
        conn_type: false
        index: -1
      }
      {
        name: all_clk_byp_req
        struct: mubi4
        package: prim_mubi_pkg
        type: uni
        act: req
        width: 1
        inst_name: clkmgr_aon
        default: ""
        external: true
        top_signame: all_clk_byp_req
        conn_type: false
        index: -1
      }
      {
        name: all_clk_byp_ack
        struct: mubi4
        package: prim_mubi_pkg
        type: uni
        act: rcv
        width: 1
        inst_name: clkmgr_aon
        default: ""
        external: true
        top_signame: all_clk_byp_ack
        conn_type: false
        index: -1
      }
      {
        name: hi_speed_sel
        struct: mubi4
        package: prim_mubi_pkg
        type: uni
        act: req
        width: 1
        inst_name: clkmgr_aon
        default: ""
        external: true
        top_signame: hi_speed_sel
        conn_type: false
        index: -1
      }
      {
        name: div_step_down_req
        struct: mubi4
        package: prim_mubi_pkg
        type: uni
        act: rcv
        width: 1
        inst_name: clkmgr_aon
        default: ""
        external: true
        top_signame: div_step_down_req
        conn_type: false
        index: -1
      }
      {
        name: lc_clk_byp_req
        struct: lc_tx
        package: lc_ctrl_pkg
        type: uni
        act: rcv
        width: 1
        inst_name: clkmgr_aon
        index: -1
      }
      {
        name: lc_clk_byp_ack
        struct: lc_tx
        package: lc_ctrl_pkg
        type: uni
        act: req
        width: 1
        inst_name: clkmgr_aon
        index: -1
      }
      {
        name: jitter_en
        struct: mubi4
        package: prim_mubi_pkg
        type: uni
        act: req
        width: 1
        inst_name: clkmgr_aon
        default: ""
        external: true
        top_signame: clk_main_jitter_en
        conn_type: false
        index: -1
      }
      {
        name: pwr
        struct: pwr_clk
        type: req_rsp
        act: rsp
        width: 1
        inst_name: clkmgr_aon
        default: ""
        package: pwrmgr_pkg
        top_signame: pwrmgr_aon_pwr_clk
        index: -1
      }
      {
        name: idle
        struct: mubi4
        package: prim_mubi_pkg
        type: uni
        act: rcv
        width: 1
        inst_name: clkmgr_aon
        default: ""
        end_idx: -1
        top_type: broadcast
        top_signame: clkmgr_aon_idle
        index: -1
      }
      {
        name: calib_rdy
        desc: Indicates clocks are calibrated and frequencies accurate
        struct: mubi4
        package: prim_mubi_pkg
        type: uni
        act: rcv
        width: 1
        default: prim_mubi_pkg::MuBi4True
        inst_name: clkmgr_aon
        index: -1
      }
      {
        name: tl
        struct: tl
        package: tlul_pkg
        type: req_rsp
        act: rsp
        width: 1
        inst_name: clkmgr_aon
        default: ""
        end_idx: -1
        top_signame: clkmgr_aon_tl
        index: -1
      }
      {
        name: lc_hw_debug_en
        desc: Debug enable qualifier coming from life cycle controller, used for HW strap qualification.
        struct: lc_tx
        package: lc_ctrl_pkg
        type: uni
        act: rcv
        width: 1
        default: lc_ctrl_pkg::Off
        inst_name: pinmux_aon
        index: -1
      }
      {
        name: lc_dft_en
        desc: Test enable qualifier coming from life cycle controller, used for HW strap qualification.
        struct: lc_tx
        package: lc_ctrl_pkg
        type: uni
        act: rcv
        width: 1
        default: lc_ctrl_pkg::Off
        inst_name: pinmux_aon
        index: -1
      }
      {
        name: lc_escalate_en
        desc:
          '''
          Escalation enable signal coming from life cycle controller, used for invalidating
          the latched lc_hw_debug_en state inside the strap sampling logic.
          '''
        struct: lc_tx
        package: lc_ctrl_pkg
        type: uni
        act: rcv
        width: 1
        default: lc_ctrl_pkg::Off
        inst_name: pinmux_aon
        index: -1
      }
      {
        name: lc_check_byp_en
        desc:
          '''
          Check bypass enable signal coming from life cycle controller, used for invalidating
          the latched lc_hw_debug_en state inside the strap sampling logic. This signal is asserted
          whenever the life cycle controller performs a life cycle transition. Its main use is
          to skip any background checks inside the life cycle partition of the OTP controller while
          a life cycle transition is in progress.
          '''
        struct: lc_tx
        package: lc_ctrl_pkg
        type: uni
        act: rcv
        width: 1
        default: lc_ctrl_pkg::Off
        inst_name: pinmux_aon
        index: -1
      }
      {
        name: pinmux_hw_debug_en
        desc:
          '''
          This is the latched version of lc_hw_debug_en_i. We use it exclusively to gate the JTAG
          signals and TAP side of the RV_DM so that RV_DM can remain live during an NDM reset cycle.
          '''
        struct: lc_tx
        package: lc_ctrl_pkg
        type: uni
        act: req
        width: 1
        default: lc_ctrl_pkg::Off
        inst_name: pinmux_aon
        index: -1
      }
      {
        name: lc_jtag
        desc: Qualified JTAG signals for life cycle controller TAP.
        struct: jtag
        package: jtag_pkg
        type: req_rsp
        act: req
        width: 1
        inst_name: pinmux_aon
        index: -1
      }
      {
        name: rv_jtag
        desc: Qualified JTAG signals for RISC-V processor TAP.
        struct: jtag
        package: jtag_pkg
        type: req_rsp
        act: req
        width: 1
        inst_name: pinmux_aon
        index: -1
      }
      {
        name: dft_jtag
        desc: Qualified JTAG signals for DFT TAP.
        struct: jtag
        package: jtag_pkg
        type: req_rsp
        act: req
        width: 1
        inst_name: pinmux_aon
        default: ""
        top_signame: pinmux_aon_dft_jtag
        index: -1
      }
      {
        name: dft_strap_test
        desc: Sampled DFT strap values, going to the DFT TAP.
        struct: dft_strap_test_req
        package: pinmux_pkg
        type: uni
        act: req
        width: 1
        default: "'0"
        inst_name: pinmux_aon
        external: true
        top_signame: dft_strap_test
        conn_type: false
        index: -1
      }
      {
        name: dft_hold_tap_sel
        desc: TAP selection hold indication, asserted by the DFT TAP during boundary scan.
        struct: logic
        type: uni
        act: rcv
        width: 1
        default: "'0"
        inst_name: pinmux_aon
        package: ""
        external: true
        top_signame: dft_hold_tap_sel
        conn_type: false
        index: -1
      }
      {
        name: sleep_en
        desc: Level signal that is asserted when the power manager enters sleep.
        struct: logic
        type: uni
        act: rcv
        width: 1
        default: 1'b0
        inst_name: pinmux_aon
        package: ""
        top_signame: pwrmgr_aon_low_power
        index: -1
      }
      {
        name: strap_en
        desc: This signal is pulsed high by the power manager after reset in order to sample the HW straps.
        struct: logic
        type: uni
        act: rcv
        width: 1
        default: 1'b0
        inst_name: pinmux_aon
        package: ""
        top_signame: pwrmgr_aon_strap
        index: -1
      }
      {
        name: strap_en_override
        desc:
          '''
          This signal transitions from 0 -> 1 by the lc_ctrl manager after volatile RAW_UNLOCK in order to re-sample the HW straps.
          The signal must stay at 1 until reset.
          Note that this is only used in test chips when SecVolatileRawUnlockEn = 1.
          Otherwise this signal is unused.
          '''
        struct: logic
        type: uni
        act: rcv
        width: 1
        default: 1'b0
        inst_name: pinmux_aon
        index: -1
      }
      {
        name: pin_wkup_req
        desc: Wakeup request from wakeup detectors, to the power manager, running on the AON clock.
        struct: logic
        type: uni
        act: req
        width: 1
        default: 1'b0
        inst_name: pinmux_aon
        package: ""
        top_signame: pwrmgr_aon_wakeups
        index: 0
      }
      {
        name: usbdev_dppullup_en
        desc: Pullup enable signal coming from the USB IP.
        struct: logic
        type: uni
        act: rcv
        width: 1
        inst_name: pinmux_aon
        default: ""
        package: ""
        top_signame: usbdev_usb_dp_pullup
        index: -1
      }
      {
        name: usbdev_dnpullup_en
        desc: Pullup enable signal coming from the USB IP.
        struct: logic
        type: uni
        act: rcv
        width: 1
        inst_name: pinmux_aon
        default: ""
        package: ""
        top_signame: usbdev_usb_dn_pullup
        index: -1
      }
      {
        name: usb_dppullup_en
        desc: " Pullup enable signal going to USB PHY, needs to be maintained in low-power mode."
        struct: logic
        type: uni
        act: req
        width: 1
        default: 1'b0
        inst_name: pinmux_aon
        package: ""
        external: true
        top_signame: usb_dp_pullup_en
        conn_type: false
        index: -1
      }
      {
        name: usb_dnpullup_en
        desc: Pullup enable signal going to USB PHY, needs to be maintained in low-power mode.
        struct: logic
        type: uni
        act: req
        width: 1
        default: 1'b0
        inst_name: pinmux_aon
        package: ""
        external: true
        top_signame: usb_dn_pullup_en
        conn_type: false
        index: -1
      }
      {
        name: usb_wkup_req
        desc: Wakeup request from USB wakeup detector, going to the power manager, running on the AON clock.
        struct: logic
        type: uni
        act: req
        width: 1
        default: 1'b0
        inst_name: pinmux_aon
        package: ""
        top_signame: pwrmgr_aon_wakeups
        index: 1
      }
      {
        name: usbdev_suspend_req
        desc: Indicates whether USB is in suspended state, coming from the USB device.
        struct: logic
        type: uni
        act: rcv
        width: 1
        inst_name: pinmux_aon
        default: ""
        package: ""
        top_signame: usbdev_usb_aon_suspend_req
        index: -1
      }
      {
        name: usbdev_wake_ack
        desc: Acknowledges the USB wakeup request, coming from the USB device.
        struct: logic
        type: uni
        act: rcv
        width: 1
        inst_name: pinmux_aon
        default: ""
        package: ""
        top_signame: usbdev_usb_aon_wake_ack
        index: -1
      }
      {
        name: usbdev_bus_not_idle
        desc: Event signal that indicates that the USB was not idle while monitoring.
        struct: logic
        type: uni
        act: req
        width: 1
        default: 1'b0
        inst_name: pinmux_aon
        index: -1
      }
      {
        name: usbdev_bus_reset
        desc: Event signal that indicates that the USB issued a Bus Reset while monitoring.
        struct: logic
        type: uni
        act: req
        width: 1
        default: 1'b0
        inst_name: pinmux_aon
        package: ""
        top_signame: usbdev_usb_aon_bus_reset
        index: -1
      }
      {
        name: usbdev_sense_lost
        desc: Event signal that indicates that USB SENSE signal was lost while monitoring.
        struct: logic
        type: uni
        act: req
        width: 1
        default: 1'b0
        inst_name: pinmux_aon
        package: ""
        top_signame: usbdev_usb_aon_sense_lost
        index: -1
      }
      {
        name: usbdev_wake_detect_active
        desc: State debug information.
        struct: logic
        type: uni
        act: req
        width: 1
        default: 1'b0
        inst_name: pinmux_aon
        package: ""
        end_idx: -1
        top_type: broadcast
        top_signame: pinmux_aon_usbdev_wake_detect_active
        index: -1
      }
      {
        name: tl
        struct: tl
        package: tlul_pkg
        type: req_rsp
        act: rsp
        width: 1
        inst_name: pinmux_aon
        default: ""
        end_idx: -1
        top_signame: pinmux_aon_tl
        index: -1
      }
      {
        name: nmi_wdog_timer_bark
        struct: logic
        type: uni
        act: req
        width: 1
        default: 1'b0
        inst_name: aon_timer_aon
        index: -1
      }
      {
        name: wkup_req
        struct: logic
        type: uni
        act: req
        width: 1
        default: 1'b0
        inst_name: aon_timer_aon
        package: ""
        top_signame: pwrmgr_aon_wakeups
        index: 2
      }
      {
        name: aon_timer_rst_req
        struct: logic
        type: uni
        act: req
        width: 1
        default: 1'b0
        inst_name: aon_timer_aon
        package: ""
        top_signame: pwrmgr_aon_rstreqs
        index: -1
      }
      {
        name: lc_escalate_en
        struct: lc_tx
        package: lc_ctrl_pkg
        type: uni
        act: rcv
        width: 1
        default: lc_ctrl_pkg::Off
        inst_name: aon_timer_aon
        index: -1
      }
      {
        name: sleep_mode
        struct: logic
        type: uni
        act: rcv
        width: 1
        inst_name: aon_timer_aon
        default: ""
        package: ""
        top_signame: pwrmgr_aon_low_power
        index: -1
      }
      {
        name: tl
        struct: tl
        package: tlul_pkg
        type: req_rsp
        act: rsp
        width: 1
        inst_name: aon_timer_aon
        index: -1
      }
      {
        name: tl
        struct: tl
        package: tlul_pkg
        type: req_rsp
        act: rsp
        width: 1
        inst_name: ast
        index: -1
      }
      {
        name: otp
        struct: flash_otp_key
        package: otp_ctrl_pkg
        type: req_rsp
        act: req
        width: 1
        inst_name: flash_ctrl
        index: -1
      }
      {
        name: lc_nvm_debug_en
        struct: lc_tx
        package: lc_ctrl_pkg
        type: uni
        act: rcv
        width: 1
        inst_name: flash_ctrl
        index: -1
      }
      {
        name: flash_bist_enable
        struct: mubi4
        package: prim_mubi_pkg
        type: uni
        act: rcv
        width: 1
        inst_name: flash_ctrl
        default: ""
        external: true
        top_signame: flash_bist_enable
        conn_type: false
        index: -1
      }
      {
        name: flash_power_down_h
        struct: logic
        type: uni
        act: rcv
        width: 1
        inst_name: flash_ctrl
        default: ""
        package: ""
        external: true
        top_signame: flash_power_down_h
        conn_type: false
        index: -1
      }
      {
        name: flash_power_ready_h
        struct: logic
        type: uni
        act: rcv
        width: 1
        inst_name: flash_ctrl
        default: ""
        package: ""
        external: true
        top_signame: flash_power_ready_h
        conn_type: false
        index: -1
      }
      {
        name: flash_test_mode_a
        struct: ""
        type: io
        act: none
        width: 2
        inst_name: flash_ctrl
        index: -1
      }
      {
        name: flash_test_voltage_h
        struct: ""
        type: io
        act: none
        width: 1
        inst_name: flash_ctrl
        index: -1
      }
      {
        name: lc_creator_seed_sw_rw_en
        struct: lc_tx
        package: lc_ctrl_pkg
        type: uni
        act: rcv
        width: 1
        inst_name: flash_ctrl
        index: -1
      }
      {
        name: lc_owner_seed_sw_rw_en
        struct: lc_tx
        package: lc_ctrl_pkg
        type: uni
        act: rcv
        width: 1
        inst_name: flash_ctrl
        index: -1
      }
      {
        name: lc_iso_part_sw_rd_en
        struct: lc_tx
        package: lc_ctrl_pkg
        type: uni
        act: rcv
        width: 1
        inst_name: flash_ctrl
        index: -1
      }
      {
        name: lc_iso_part_sw_wr_en
        struct: lc_tx
        package: lc_ctrl_pkg
        type: uni
        act: rcv
        width: 1
        inst_name: flash_ctrl
        index: -1
      }
      {
        name: lc_seed_hw_rd_en
        struct: lc_tx
        package: lc_ctrl_pkg
        type: uni
        act: rcv
        width: 1
        inst_name: flash_ctrl
        index: -1
      }
      {
        name: lc_escalate_en
        struct: lc_tx
        package: lc_ctrl_pkg
        type: uni
        act: rcv
        width: 1
        inst_name: flash_ctrl
        index: -1
      }
      {
        name: rma_req
        struct: lc_tx
        package: lc_ctrl_pkg
        type: uni
        act: rcv
        width: 1
        inst_name: flash_ctrl
        index: -1
      }
      {
        name: rma_ack
        struct: lc_tx
        package: lc_ctrl_pkg
        type: uni
        act: req
        width: 1
        inst_name: flash_ctrl
        index: -1
      }
      {
        name: rma_seed
        struct: lc_flash_rma_seed
        package: lc_ctrl_pkg
        type: uni
        act: rcv
        width: 1
        inst_name: flash_ctrl
        index: -1
      }
      {
        name: pwrmgr
        struct: pwr_flash
        package: pwrmgr_pkg
        type: uni
        act: req
        width: 1
        inst_name: flash_ctrl
        default: ""
        top_signame: pwrmgr_aon_pwr_flash
        index: -1
      }
      {
        name: keymgr
        struct: keymgr_flash
        package: flash_ctrl_pkg
        type: uni
        act: req
        width: 1
        inst_name: flash_ctrl
        index: -1
      }
      {
        name: obs_ctrl
        struct: ast_obs_ctrl
        package: ast_pkg
        type: uni
        act: rcv
        width: 1
        inst_name: flash_ctrl
        default: ""
        external: true
        top_signame: obs_ctrl
        conn_type: false
        index: -1
      }
      {
        name: fla_obs
        struct: logic
        type: uni
        act: req
        width: 8
        inst_name: flash_ctrl
        default: ""
        package: ""
        external: true
        top_signame: flash_obs
        conn_type: false
        index: -1
      }
      {
        name: core_tl
        struct: tl
        package: tlul_pkg
        type: req_rsp
        act: rsp
        width: 1
        inst_name: flash_ctrl
        default: ""
        end_idx: -1
        top_signame: flash_ctrl_core_tl
        index: -1
      }
      {
        name: prim_tl
        struct: tl
        package: tlul_pkg
        type: req_rsp
        act: rsp
        width: 1
        inst_name: flash_ctrl
        default: ""
        end_idx: -1
        top_signame: flash_ctrl_prim_tl
        index: -1
      }
      {
        name: mem_tl
        struct: tl
        package: tlul_pkg
        type: req_rsp
        act: rsp
        width: 1
        inst_name: flash_ctrl
        default: ""
        end_idx: -1
        top_signame: flash_ctrl_mem_tl
        index: -1
      }
      {
        name: irq
        struct: logic
        type: uni
        act: req
        width: 1
        inst_name: rv_plic
        default: ""
        package: ""
        end_idx: -1
        top_type: broadcast
        top_signame: rv_plic_irq
        index: -1
      }
      {
        name: irq_id
        struct: logic
        type: uni
        act: req
        width: 1
        inst_name: rv_plic
        index: -1
      }
      {
        name: msip
        struct: logic
        type: uni
        act: req
        width: 1
        inst_name: rv_plic
        default: ""
        package: ""
        end_idx: -1
        top_type: broadcast
        top_signame: rv_plic_msip
        index: -1
      }
      {
        name: tl
        struct: tl
        package: tlul_pkg
        type: req_rsp
        act: rsp
        width: 1
        inst_name: rv_plic
        default: ""
        end_idx: -1
        top_signame: rv_plic_tl
        index: -1
      }
      {
        name: idle
        struct: mubi4
        package: prim_mubi_pkg
        type: uni
        act: req
        width: 1
        inst_name: aes
        default: ""
        top_signame: clkmgr_aon_idle
        index: -1
      }
      {
        name: lc_escalate_en
        struct: lc_tx
        package: lc_ctrl_pkg
        type: uni
        act: rcv
        width: 1
        default: lc_ctrl_pkg::Off
        inst_name: aes
        index: -1
      }
      {
        name: edn
        struct: edn
        package: edn_pkg
        type: req_rsp
        act: req
        width: 1
        inst_name: aes
        index: -1
      }
      {
        name: keymgr_key
        struct: hw_key_req
        package: keymgr_pkg
        type: uni
        act: rcv
        width: 1
        inst_name: aes
        index: -1
      }
      {
        name: tl
        struct: tl
        package: tlul_pkg
        type: req_rsp
        act: rsp
        width: 1
        inst_name: aes
        default: ""
        end_idx: -1
        top_signame: aes_tl
        index: -1
      }
      {
        name: sram_otp_key
        struct: sram_otp_key
        package: otp_ctrl_pkg
        type: req_rsp
        act: req
        width: 1
        inst_name: sram_ctrl_main
        index: -1
      }
      {
        name: cfg
        struct: ram_1p_cfg
        package: prim_ram_1p_pkg
        type: uni
        act: rcv
        width: 1
        default: "'0"
        inst_name: sram_ctrl_main
        index: -1
      }
      {
        name: lc_escalate_en
        struct: lc_tx
        package: lc_ctrl_pkg
        type: uni
        act: rcv
        width: 1
        default: lc_ctrl_pkg::Off
        inst_name: sram_ctrl_main
        index: -1
      }
      {
        name: lc_hw_debug_en
        struct: lc_tx
        package: lc_ctrl_pkg
        type: uni
        act: rcv
        width: 1
        default: lc_ctrl_pkg::Off
        inst_name: sram_ctrl_main
        index: -1
      }
      {
        name: otp_en_sram_ifetch
        struct: mubi8
        package: prim_mubi_pkg
        type: uni
        act: rcv
        width: 1
        default: prim_mubi_pkg::MuBi8False
        inst_name: sram_ctrl_main
        top_signame: sram_ctrl_main_otp_en_sram_ifetch
        index: -1
      }
      {
        name: regs_tl
        struct: tl
        package: tlul_pkg
        type: req_rsp
        act: rsp
        width: 1
        inst_name: sram_ctrl_main
        default: ""
        end_idx: -1
        top_signame: sram_ctrl_main_regs_tl
        index: -1
      }
      {
        name: ram_tl
        struct: tl
        package: tlul_pkg
        type: req_rsp
        act: rsp
        width: 1
        inst_name: sram_ctrl_main
        default: ""
        end_idx: -1
        top_signame: sram_ctrl_main_ram_tl
        index: -1
      }
      {
        name: rom_cfg
        struct: rom_cfg
        package: prim_rom_pkg
        type: uni
        act: rcv
        width: 1
        inst_name: rom_ctrl
        index: -1
      }
      {
        name: pwrmgr_data
        struct: pwrmgr_data
        package: rom_ctrl_pkg
        type: uni
        act: req
        width: 1
        inst_name: rom_ctrl
        index: -1
      }
      {
        name: keymgr_data
        struct: keymgr_data
        package: rom_ctrl_pkg
        type: uni
        act: req
        width: 1
        inst_name: rom_ctrl
        index: -1
      }
      {
        name: kmac_data
        struct: app
        package: kmac_pkg
        type: req_rsp
        act: req
        width: 1
        inst_name: rom_ctrl
        index: -1
      }
      {
        name: regs_tl
        struct: tl
        package: tlul_pkg
        type: req_rsp
        act: rsp
        width: 1
        inst_name: rom_ctrl
        default: ""
        end_idx: -1
        top_signame: rom_ctrl_regs_tl
        index: -1
      }
      {
        name: rom_tl
        struct: tl
        package: tlul_pkg
        type: req_rsp
        act: rsp
        width: 1
        inst_name: rom_ctrl
        default: ""
        end_idx: -1
        top_signame: rom_ctrl_rom_tl
        index: -1
      }
      {
        name: rst_cpu_n
        struct: logic
        type: uni
        act: req
        width: 1
        inst_name: rv_core_ibex
        index: -1
      }
      {
        name: ram_cfg
        struct: ram_1p_cfg
        package: prim_ram_1p_pkg
        type: uni
        act: rcv
        width: 1
        inst_name: rv_core_ibex
        index: -1
      }
      {
        name: hart_id
        struct: logic
        type: uni
        act: rcv
        width: 32
        inst_name: rv_core_ibex
        default: ""
        package: ""
        top_signame: rv_core_ibex_hart_id
        index: -1
      }
      {
        name: boot_addr
        struct: logic
        type: uni
        act: rcv
        width: 32
        inst_name: rv_core_ibex
        default: ""
        package: ""
        top_signame: rv_core_ibex_boot_addr
        index: -1
      }
      {
        name: irq_software
        struct: logic
        type: uni
        act: rcv
        width: 1
        inst_name: rv_core_ibex
        default: ""
        package: ""
        top_signame: rv_plic_msip
        index: -1
      }
      {
        name: irq_timer
        struct: logic
        type: uni
        act: rcv
        width: 1
        inst_name: rv_core_ibex
        default: ""
        package: ""
        top_signame: rv_core_ibex_irq_timer
        index: -1
      }
      {
        name: irq_external
        struct: logic
        type: uni
        act: rcv
        width: 1
        inst_name: rv_core_ibex
        default: ""
        package: ""
        top_signame: rv_plic_irq
        index: -1
      }
      {
        name: esc_tx
        struct: esc_tx
        package: prim_esc_pkg
        type: uni
        act: rcv
        width: 1
        inst_name: rv_core_ibex
        index: -1
      }
      {
        name: esc_rx
        struct: esc_rx
        package: prim_esc_pkg
        type: uni
        act: req
        width: 1
        inst_name: rv_core_ibex
        index: -1
      }
      {
        name: debug_req
        struct: logic
        type: uni
        act: rcv
        width: 1
        inst_name: rv_core_ibex
        index: -1
      }
      {
        name: crash_dump
        struct: cpu_crash_dump
        package: rv_core_ibex_pkg
        type: uni
        act: req
        width: 1
        inst_name: rv_core_ibex
        default: ""
        end_idx: -1
        top_type: broadcast
        top_signame: rv_core_ibex_crash_dump
        index: -1
      }
      {
        name: lc_cpu_en
        struct: lc_tx
        package: lc_ctrl_pkg
        type: uni
        act: rcv
        width: 1
        inst_name: rv_core_ibex
        default: ""
        top_signame: rv_core_ibex_lc_cpu_en
        index: -1
      }
      {
        name: pwrmgr_cpu_en
        struct: lc_tx
        package: lc_ctrl_pkg
        type: uni
        act: rcv
        width: 1
        inst_name: rv_core_ibex
        default: ""
        top_signame: pwrmgr_aon_fetch_en
        index: -1
      }
      {
        name: pwrmgr
        struct: pwr_cpu
        package: pwrmgr_pkg
        type: uni
        act: req
        width: 1
        inst_name: rv_core_ibex
        default: ""
        end_idx: -1
        top_type: broadcast
        top_signame: rv_core_ibex_pwrmgr
        index: -1
      }
      {
        name: nmi_wdog
        struct: logic
        type: uni
        act: rcv
        width: 1
        inst_name: rv_core_ibex
        index: -1
      }
      {
        name: edn
        struct: edn
        package: edn_pkg
        type: req_rsp
        act: req
        width: 1
        inst_name: rv_core_ibex
        index: -1
      }
      {
        name: icache_otp_key
        struct: sram_otp_key
        package: otp_ctrl_pkg
        type: req_rsp
        act: req
        width: 1
        inst_name: rv_core_ibex
        index: -1
      }
      {
        name: fpga_info
        struct: logic
        type: uni
        act: rcv
        width: 32
        inst_name: rv_core_ibex
        default: ""
        package: ""
        external: true
        top_signame: fpga_info
        conn_type: false
        index: -1
      }
      {
        name: corei_tl_h
        struct: tl
        package: tlul_pkg
        type: req_rsp
        act: req
        width: 1
        inst_name: rv_core_ibex
        default: ""
        top_signame: main_tl_rv_core_ibex__corei
        index: -1
      }
      {
        name: cored_tl_h
        struct: tl
        package: tlul_pkg
        type: req_rsp
        act: req
        width: 1
        inst_name: rv_core_ibex
        default: ""
        top_signame: main_tl_rv_core_ibex__cored
        index: -1
      }
      {
        name: cfg_tl_d
        struct: tl
        package: tlul_pkg
        type: req_rsp
        act: rsp
        width: 1
        inst_name: rv_core_ibex
        default: ""
        end_idx: -1
        top_signame: rv_core_ibex_cfg_tl_d
        index: -1
      }
      {
        name: tl_rv_core_ibex__corei
        struct: tl
        package: tlul_pkg
        type: req_rsp
        act: rsp
        width: 1
        inst_name: main
        default: ""
        end_idx: -1
        top_signame: main_tl_rv_core_ibex__corei
        index: -1
      }
      {
        name: tl_rv_core_ibex__cored
        struct: tl
        package: tlul_pkg
        type: req_rsp
        act: rsp
        width: 1
        inst_name: main
        default: ""
        end_idx: -1
        top_signame: main_tl_rv_core_ibex__cored
        index: -1
      }
      {
        name: tl_rom_ctrl__rom
        struct: tl
        package: tlul_pkg
        type: req_rsp
        act: req
        width: 1
        inst_name: main
        default: ""
        top_signame: rom_ctrl_rom_tl
        index: -1
      }
      {
        name: tl_rom_ctrl__regs
        struct: tl
        package: tlul_pkg
        type: req_rsp
        act: req
        width: 1
        inst_name: main
        default: ""
        top_signame: rom_ctrl_regs_tl
        index: -1
      }
      {
        name: tl_peri
        struct: tl
        package: tlul_pkg
        type: req_rsp
        act: req
        width: 1
        inst_name: main
        default: ""
        end_idx: -1
        top_signame: main_tl_peri
        index: -1
      }
      {
        name: tl_flash_ctrl__core
        struct: tl
        package: tlul_pkg
        type: req_rsp
        act: req
        width: 1
        inst_name: main
        default: ""
        top_signame: flash_ctrl_core_tl
        index: -1
      }
      {
        name: tl_flash_ctrl__prim
        struct: tl
        package: tlul_pkg
        type: req_rsp
        act: req
        width: 1
        inst_name: main
        default: ""
        top_signame: flash_ctrl_prim_tl
        index: -1
      }
      {
        name: tl_flash_ctrl__mem
        struct: tl
        package: tlul_pkg
        type: req_rsp
        act: req
        width: 1
        inst_name: main
        default: ""
        top_signame: flash_ctrl_mem_tl
        index: -1
      }
      {
        name: tl_aes
        struct: tl
        package: tlul_pkg
        type: req_rsp
        act: req
        width: 1
        inst_name: main
        default: ""
        top_signame: aes_tl
        index: -1
      }
      {
        name: tl_rv_plic
        struct: tl
        package: tlul_pkg
        type: req_rsp
        act: req
        width: 1
        inst_name: main
        default: ""
        top_signame: rv_plic_tl
        index: -1
      }
      {
        name: tl_rv_core_ibex__cfg
        struct: tl
        package: tlul_pkg
        type: req_rsp
        act: req
        width: 1
        inst_name: main
        default: ""
        top_signame: rv_core_ibex_cfg_tl_d
        index: -1
      }
      {
        name: tl_sram_ctrl_main__regs
        struct: tl
        package: tlul_pkg
        type: req_rsp
        act: req
        width: 1
        inst_name: main
        default: ""
        top_signame: sram_ctrl_main_regs_tl
        index: -1
      }
      {
        name: tl_sram_ctrl_main__ram
        struct: tl
        package: tlul_pkg
        type: req_rsp
        act: req
        width: 1
        inst_name: main
        default: ""
        top_signame: sram_ctrl_main_ram_tl
        index: -1
      }
      {
        name: tl_main
        struct: tl
        package: tlul_pkg
        type: req_rsp
        act: rsp
        width: 1
        inst_name: peri
        default: ""
        top_signame: main_tl_peri
        index: -1
      }
      {
        name: tl_uart0
        struct: tl
        package: tlul_pkg
        type: req_rsp
        act: req
        width: 1
        inst_name: peri
        default: ""
        top_signame: uart0_tl
        index: -1
      }
      {
        name: tl_uart1
        struct: tl
        package: tlul_pkg
        type: req_rsp
        act: req
        width: 1
        inst_name: peri
        default: ""
        top_signame: uart1_tl
        index: -1
      }
      {
        name: tl_gpio
        struct: tl
        package: tlul_pkg
        type: req_rsp
        act: req
        width: 1
        inst_name: peri
        default: ""
        top_signame: gpio_tl
        index: -1
      }
      {
        name: tl_spi_device
        struct: tl
        package: tlul_pkg
        type: req_rsp
        act: req
        width: 1
        inst_name: peri
        default: ""
        top_signame: spi_device_tl
        index: -1
      }
      {
        name: tl_spi_host0
        struct: tl
        package: tlul_pkg
        type: req_rsp
        act: req
        width: 1
        inst_name: peri
        default: ""
        top_signame: spi_host0_tl
        index: -1
      }
      {
        name: tl_rv_timer
        struct: tl
        package: tlul_pkg
        type: req_rsp
        act: req
        width: 1
        inst_name: peri
        default: ""
        top_signame: rv_timer_tl
        index: -1
      }
      {
        name: tl_usbdev
        struct: tl
        package: tlul_pkg
        type: req_rsp
        act: req
        width: 1
        inst_name: peri
        default: ""
        top_signame: usbdev_tl
        index: -1
      }
      {
        name: tl_pwrmgr_aon
        struct: tl
        package: tlul_pkg
        type: req_rsp
        act: req
        width: 1
        inst_name: peri
        default: ""
        top_signame: pwrmgr_aon_tl
        index: -1
      }
      {
        name: tl_rstmgr_aon
        struct: tl
        package: tlul_pkg
        type: req_rsp
        act: req
        width: 1
        inst_name: peri
        default: ""
        top_signame: rstmgr_aon_tl
        index: -1
      }
      {
        name: tl_clkmgr_aon
        struct: tl
        package: tlul_pkg
        type: req_rsp
        act: req
        width: 1
        inst_name: peri
        default: ""
        top_signame: clkmgr_aon_tl
        index: -1
      }
      {
        name: tl_pinmux_aon
        struct: tl
        package: tlul_pkg
        type: req_rsp
        act: req
        width: 1
        inst_name: peri
        default: ""
        top_signame: pinmux_aon_tl
        index: -1
      }
      {
        name: tl_ast
        struct: tl
        package: tlul_pkg
        type: req_rsp
        act: req
        width: 1
        inst_name: peri
        default: ""
        external: true
        top_signame: ast_tl
        conn_type: false
        index: -1
      }
      {
        struct: edn
        type: req_rsp
        name: edn
        act: rsp
        package: edn_pkg
        inst_name: ast
        width: 1
        default: ""
        external: true
        top_signame: ast_edn
        conn_type: false
        index: -1
      }
      {
        struct: lc_tx
        type: uni
        name: lc_dft_en
        act: req
        package: lc_ctrl_pkg
        inst_name: ast
        width: 1
        default: ""
        external: true
        top_signame: ast_lc_dft_en
        conn_type: false
        index: -1
      }
      {
        struct: ram_1p_cfg
        package: prim_ram_1p_pkg
        type: uni
        name: ram_1p_cfg
        act: rcv
        inst_name: ast
        width: 1
        default: ""
        external: true
        top_signame: ram_1p_cfg
        conn_type: false
        index: -1
      }
      {
        struct: ram_2p_cfg
        package: prim_ram_2p_pkg
        type: uni
        name: spi_ram_2p_cfg
        act: rcv
        inst_name: ast
        width: 1
        default: ""
        external: true
        top_signame: spi_ram_2p_cfg
        conn_type: false
        index: -1
      }
      {
        struct: ram_1p_cfg
        package: prim_ram_1p_pkg
        type: uni
        name: usb_ram_1p_cfg
        act: rcv
        inst_name: ast
        width: 1
        default: ""
        external: true
        top_signame: usb_ram_1p_cfg
        conn_type: false
        index: -1
      }
      {
        struct: rom_cfg
        package: prim_rom_pkg
        type: uni
        name: rom_cfg
        act: rcv
        inst_name: ast
        width: 1
        default: ""
        external: true
        top_signame: rom_cfg
        conn_type: false
        index: -1
      }
    ]
    external:
    [
      {
        package: edn_pkg
        struct: edn_req
        signame: ast_edn_req_i
        width: 1
        type: req_rsp
        default: ""
        direction: in
        conn_type: false
        index: -1
        netname: ast_edn_req
      }
      {
        package: edn_pkg
        struct: edn_rsp
        signame: ast_edn_rsp_o
        width: 1
        type: req_rsp
        default: ""
        direction: out
        conn_type: false
        index: -1
        netname: ast_edn_rsp
      }
      {
        package: lc_ctrl_pkg
        struct: lc_tx
        signame: ast_lc_dft_en_o
        width: 1
        type: uni
        default: ""
        direction: out
        conn_type: false
        index: -1
        netname: ast_lc_dft_en
      }
      {
        package: prim_ram_1p_pkg
        struct: ram_1p_cfg
        signame: ram_1p_cfg_i
        width: 1
        type: uni
        default: ""
        direction: in
        conn_type: false
        index: -1
        netname: ram_1p_cfg
      }
      {
        package: prim_ram_2p_pkg
        struct: ram_2p_cfg
        signame: spi_ram_2p_cfg_i
        width: 1
        type: uni
        default: ""
        direction: in
        conn_type: false
        index: -1
        netname: spi_ram_2p_cfg
      }
      {
        package: prim_ram_1p_pkg
        struct: ram_1p_cfg
        signame: usb_ram_1p_cfg_i
        width: 1
        type: uni
        default: ""
        direction: in
        conn_type: false
        index: -1
        netname: usb_ram_1p_cfg
      }
      {
        package: prim_rom_pkg
        struct: rom_cfg
        signame: rom_cfg_i
        width: 1
        type: uni
        default: ""
        direction: in
        conn_type: false
        index: -1
        netname: rom_cfg
      }
      {
        package: prim_mubi_pkg
        struct: mubi4
        signame: clk_main_jitter_en_o
        width: 1
        type: uni
        default: ""
        direction: out
        conn_type: false
        index: -1
        netname: clk_main_jitter_en
      }
      {
        package: prim_mubi_pkg
        struct: mubi4
        signame: hi_speed_sel_o
        width: 1
        type: uni
        default: ""
        direction: out
        conn_type: false
        index: -1
        netname: hi_speed_sel
      }
      {
        package: prim_mubi_pkg
        struct: mubi4
        signame: div_step_down_req_i
        width: 1
        type: uni
        default: ""
        direction: in
        conn_type: false
        index: -1
        netname: div_step_down_req
      }
      {
        package: prim_mubi_pkg
        struct: mubi4
        signame: all_clk_byp_req_o
        width: 1
        type: uni
        default: ""
        direction: out
        conn_type: false
        index: -1
        netname: all_clk_byp_req
      }
      {
        package: prim_mubi_pkg
        struct: mubi4
        signame: all_clk_byp_ack_i
        width: 1
        type: uni
        default: ""
        direction: in
        conn_type: false
        index: -1
        netname: all_clk_byp_ack
      }
      {
        package: prim_mubi_pkg
        struct: mubi4
        signame: io_clk_byp_req_o
        width: 1
        type: uni
        default: ""
        direction: out
        conn_type: false
        index: -1
        netname: io_clk_byp_req
      }
      {
        package: prim_mubi_pkg
        struct: mubi4
        signame: io_clk_byp_ack_i
        width: 1
        type: uni
        default: ""
        direction: in
        conn_type: false
        index: -1
        netname: io_clk_byp_ack
      }
      {
        package: prim_mubi_pkg
        struct: mubi4
        signame: flash_bist_enable_i
        width: 1
        type: uni
        default: ""
        direction: in
        conn_type: false
        index: -1
        netname: flash_bist_enable
      }
      {
        package: ""
        struct: logic
        signame: flash_power_down_h_i
        width: 1
        type: uni
        default: ""
        direction: in
        conn_type: false
        index: -1
        netname: flash_power_down_h
      }
      {
        package: ""
        struct: logic
        signame: flash_power_ready_h_i
        width: 1
        type: uni
        default: ""
        direction: in
        conn_type: false
        index: -1
        netname: flash_power_ready_h
      }
      {
        package: ast_pkg
        struct: ast_obs_ctrl
        signame: obs_ctrl_i
        width: 1
        type: uni
        default: ""
        direction: in
        conn_type: false
        index: -1
        netname: obs_ctrl
      }
      {
        package: ""
        struct: logic
        signame: flash_obs_o
        width: 8
        type: uni
        default: ""
        direction: out
        conn_type: false
        index: -1
        netname: flash_obs
      }
      {
        package: tlul_pkg
        struct: tl_h2d
        signame: ast_tl_req_o
        width: 1
        type: req_rsp
        default: ""
        direction: out
        conn_type: false
        index: -1
        netname: ast_tl_h2d
      }
      {
        package: tlul_pkg
        struct: tl_d2h
        signame: ast_tl_rsp_i
        width: 1
        type: req_rsp
        default: ""
        direction: in
        conn_type: false
        index: -1
        netname: ast_tl_d2h
      }
      {
        package: pinmux_pkg
        struct: dft_strap_test_req
        signame: dft_strap_test_o
        width: 1
        type: uni
        default: "'0"
        direction: out
        conn_type: false
        index: -1
        netname: dft_strap_test
      }
      {
        package: ""
        struct: logic
        signame: dft_hold_tap_sel_i
        width: 1
        type: uni
        default: "'0"
        direction: in
        conn_type: false
        index: -1
        netname: dft_hold_tap_sel
      }
      {
        package: ""
        struct: logic
        signame: usb_dp_pullup_en_o
        width: 1
        type: uni
        default: 1'b0
        direction: out
        conn_type: false
        index: -1
        netname: usb_dp_pullup_en
      }
      {
        package: ""
        struct: logic
        signame: usb_dn_pullup_en_o
        width: 1
        type: uni
        default: 1'b0
        direction: out
        conn_type: false
        index: -1
        netname: usb_dn_pullup_en
      }
      {
        package: pwrmgr_pkg
        struct: pwr_ast_req
        signame: pwrmgr_ast_req_o
        width: 1
        type: req_rsp
        default: ""
        direction: out
        conn_type: false
        index: -1
        netname: pwrmgr_ast_req
      }
      {
        package: pwrmgr_pkg
        struct: pwr_ast_rsp
        signame: pwrmgr_ast_rsp_i
        width: 1
        type: req_rsp
        default: ""
        direction: in
        conn_type: false
        index: -1
        netname: pwrmgr_ast_rsp
      }
      {
        package: ""
        struct: logic
        signame: por_n_i
        width: 2
        type: uni
        default: ""
        direction: in
        conn_type: false
        index: -1
        netname: por_n
      }
      {
        package: ""
        struct: logic
        signame: fpga_info_i
        width: 32
        type: uni
        default: ""
        direction: in
        conn_type: false
        index: -1
        netname: fpga_info
      }
      {
        package: ""
        struct: logic
        signame: usbdev_usb_rx_d_i
        width: 1
        type: uni
        default: ""
        direction: in
        conn_type: false
        index: -1
        netname: usbdev_usb_rx_d
      }
      {
        package: ""
        struct: logic
        signame: usbdev_usb_tx_d_o
        width: 1
        type: uni
        default: ""
        direction: out
        conn_type: false
        index: -1
        netname: usbdev_usb_tx_d
      }
      {
        package: ""
        struct: logic
        signame: usbdev_usb_tx_se0_o
        width: 1
        type: uni
        default: ""
        direction: out
        conn_type: false
        index: -1
        netname: usbdev_usb_tx_se0
      }
      {
        package: ""
        struct: logic
        signame: usbdev_usb_tx_use_d_se0_o
        width: 1
        type: uni
        default: ""
        direction: out
        conn_type: false
        index: -1
        netname: usbdev_usb_tx_use_d_se0
      }
      {
        package: ""
        struct: logic
        signame: usbdev_usb_rx_enable_o
        width: 1
        type: uni
        default: ""
        direction: out
        conn_type: false
        index: -1
        netname: usbdev_usb_rx_enable
      }
      {
        package: ""
        struct: logic
        signame: usbdev_usb_ref_val_o
        width: 1
        type: uni
        default: ""
        direction: out
        conn_type: false
        index: -1
        netname: usbdev_usb_ref_val
      }
      {
        package: ""
        struct: logic
        signame: usbdev_usb_ref_pulse_o
        width: 1
        type: uni
        default: ""
        direction: out
        conn_type: false
        index: -1
        netname: usbdev_usb_ref_pulse
      }
      {
        package: ""
        struct: logic
        signame: sck_monitor_o
        width: 1
        type: uni
        default: ""
        direction: out
        conn_type: false
        index: -1
        netname: sck_monitor
      }
    ]
    definitions:
    [
      {
        package: pwrmgr_pkg
        struct: pwr_flash
        signame: pwrmgr_aon_pwr_flash
        width: 1
        type: uni
        end_idx: -1
        act: rcv
        suffix: ""
        default: pwrmgr_pkg::PWR_FLASH_DEFAULT
      }
      {
        package: pwrmgr_pkg
        struct: pwr_rst_req
        signame: pwrmgr_aon_pwr_rst_req
        width: 1
        type: req_rsp
        end_idx: -1
        act: req
        suffix: req
        default: ""
      }
      {
        package: pwrmgr_pkg
        struct: pwr_rst_rsp
        signame: pwrmgr_aon_pwr_rst_rsp
        width: 1
        type: req_rsp
        end_idx: -1
        act: req
        suffix: rsp
        default: pwrmgr_pkg::PWR_RST_RSP_DEFAULT
      }
      {
        package: pwrmgr_pkg
        struct: pwr_clk_req
        signame: pwrmgr_aon_pwr_clk_req
        width: 1
        type: req_rsp
        end_idx: -1
        act: req
        suffix: req
        default: ""
      }
      {
        package: pwrmgr_pkg
        struct: pwr_clk_rsp
        signame: pwrmgr_aon_pwr_clk_rsp
        width: 1
        type: req_rsp
        end_idx: -1
        act: req
        suffix: rsp
        default: pwrmgr_pkg::PWR_CLK_RSP_DEFAULT
      }
      {
        package: ""
        struct: logic
        signame: pwrmgr_aon_strap
        width: 1
        type: uni
        end_idx: -1
        act: req
        suffix: ""
        default: "'0"
      }
      {
        package: ""
        struct: logic
        signame: pwrmgr_aon_low_power
        width: 1
        type: uni
        end_idx: -1
        act: req
        suffix: ""
        default: "'0"
      }
      {
        package: lc_ctrl_pkg
        struct: lc_tx
        signame: pwrmgr_aon_fetch_en
        width: 1
        type: uni
        end_idx: -1
        act: req
        suffix: ""
        default: lc_ctrl_pkg::LC_TX_DEFAULT
      }
      {
        package: ""
        struct: logic
        signame: usbdev_usb_dp_pullup
        width: 1
        type: uni
        end_idx: -1
        act: req
        suffix: ""
        default: "'0"
      }
      {
        package: ""
        struct: logic
        signame: usbdev_usb_dn_pullup
        width: 1
        type: uni
        end_idx: -1
        act: req
        suffix: ""
        default: "'0"
      }
      {
        package: ""
        struct: logic
        signame: usbdev_usb_aon_suspend_req
        width: 1
        type: uni
        end_idx: -1
        act: req
        suffix: ""
        default: "'0"
      }
      {
        package: ""
        struct: logic
        signame: usbdev_usb_aon_wake_ack
        width: 1
        type: uni
        end_idx: -1
        act: req
        suffix: ""
        default: "'0"
      }
      {
        package: ""
        struct: logic
        signame: usbdev_usb_aon_bus_reset
        width: 1
        type: uni
        end_idx: -1
        act: rcv
        suffix: ""
        default: "'0"
      }
      {
        package: ""
        struct: logic
        signame: usbdev_usb_aon_sense_lost
        width: 1
        type: uni
        end_idx: -1
        act: rcv
        suffix: ""
        default: "'0"
      }
      {
        package: ""
        struct: logic
        signame: pinmux_aon_usbdev_wake_detect_active
        width: 1
        type: uni
        end_idx: -1
        act: req
        suffix: ""
        default: 1'b0
      }
      {
        package: prim_mubi_pkg
        struct: mubi4
        signame: clkmgr_aon_idle
        width: 1
        type: uni
        end_idx: -1
        act: rcv
        suffix: ""
        default: prim_mubi_pkg::MUBI4_DEFAULT
      }
      {
        package: ""
        struct: logic
        signame: rv_plic_msip
        width: 1
        type: uni
        end_idx: -1
        act: req
        suffix: ""
        default: "'0"
      }
      {
        package: ""
        struct: logic
        signame: rv_plic_irq
        width: 1
        type: uni
        end_idx: -1
        act: req
        suffix: ""
        default: "'0"
      }
      {
        package: rv_core_ibex_pkg
        struct: cpu_crash_dump
        signame: rv_core_ibex_crash_dump
        width: 1
        type: uni
        end_idx: -1
        act: req
        suffix: ""
        default: rv_core_ibex_pkg::CPU_CRASH_DUMP_DEFAULT
      }
      {
        package: pwrmgr_pkg
        struct: pwr_cpu
        signame: rv_core_ibex_pwrmgr
        width: 1
        type: uni
        end_idx: -1
        act: req
        suffix: ""
        default: pwrmgr_pkg::PWR_CPU_DEFAULT
      }
      {
        package: spi_device_pkg
        struct: passthrough_req
        signame: spi_device_passthrough_req
        width: 1
        type: req_rsp
        end_idx: -1
        act: req
        suffix: req
        default: ""
      }
      {
        package: spi_device_pkg
        struct: passthrough_rsp
        signame: spi_device_passthrough_rsp
        width: 1
        type: req_rsp
        end_idx: -1
        act: req
        suffix: rsp
        default: spi_device_pkg::PASSTHROUGH_RSP_DEFAULT
      }
      {
        package: prim_mubi_pkg
        struct: mubi4
        signame: rstmgr_aon_sw_rst_req
        width: 1
        type: uni
        end_idx: -1
        act: req
        suffix: ""
        default: prim_mubi_pkg::MUBI4_DEFAULT
      }
      {
        package: ""
        struct: logic
        signame: pwrmgr_aon_wakeups
        width: 3
        type: uni
        end_idx: -1
        act: rcv
        suffix: ""
        default: "'0"
      }
      {
        package: ""
        struct: logic
        signame: pwrmgr_aon_rstreqs
        width: 1
        type: uni
        end_idx: -1
        act: rcv
        suffix: ""
        default: "'0"
      }
      {
        package: tlul_pkg
        struct: tl_h2d
        signame: main_tl_rv_core_ibex__corei_req
        width: 1
        type: req_rsp
        end_idx: -1
        act: rsp
        suffix: req
        default: tlul_pkg::TL_H2D_DEFAULT
      }
      {
        package: tlul_pkg
        struct: tl_d2h
        signame: main_tl_rv_core_ibex__corei_rsp
        width: 1
        type: req_rsp
        end_idx: -1
        act: rsp
        suffix: rsp
        default: ""
      }
      {
        package: tlul_pkg
        struct: tl_h2d
        signame: main_tl_rv_core_ibex__cored_req
        width: 1
        type: req_rsp
        end_idx: -1
        act: rsp
        suffix: req
        default: tlul_pkg::TL_H2D_DEFAULT
      }
      {
        package: tlul_pkg
        struct: tl_d2h
        signame: main_tl_rv_core_ibex__cored_rsp
        width: 1
        type: req_rsp
        end_idx: -1
        act: rsp
        suffix: rsp
        default: ""
      }
      {
        package: tlul_pkg
        struct: tl_h2d
        signame: rom_ctrl_rom_tl_req
        width: 1
        type: req_rsp
        end_idx: -1
        act: rsp
        suffix: req
        default: tlul_pkg::TL_H2D_DEFAULT
      }
      {
        package: tlul_pkg
        struct: tl_d2h
        signame: rom_ctrl_rom_tl_rsp
        width: 1
        type: req_rsp
        end_idx: -1
        act: rsp
        suffix: rsp
        default: ""
      }
      {
        package: tlul_pkg
        struct: tl_h2d
        signame: rom_ctrl_regs_tl_req
        width: 1
        type: req_rsp
        end_idx: -1
        act: rsp
        suffix: req
        default: tlul_pkg::TL_H2D_DEFAULT
      }
      {
        package: tlul_pkg
        struct: tl_d2h
        signame: rom_ctrl_regs_tl_rsp
        width: 1
        type: req_rsp
        end_idx: -1
        act: rsp
        suffix: rsp
        default: ""
      }
      {
        package: tlul_pkg
        struct: tl_h2d
        signame: main_tl_peri_req
        width: 1
        type: req_rsp
        end_idx: -1
        act: req
        suffix: req
        default: ""
      }
      {
        package: tlul_pkg
        struct: tl_d2h
        signame: main_tl_peri_rsp
        width: 1
        type: req_rsp
        end_idx: -1
        act: req
        suffix: rsp
        default: tlul_pkg::TL_D2H_DEFAULT
      }
      {
        package: tlul_pkg
        struct: tl_h2d
        signame: flash_ctrl_core_tl_req
        width: 1
        type: req_rsp
        end_idx: -1
        act: rsp
        suffix: req
        default: tlul_pkg::TL_H2D_DEFAULT
      }
      {
        package: tlul_pkg
        struct: tl_d2h
        signame: flash_ctrl_core_tl_rsp
        width: 1
        type: req_rsp
        end_idx: -1
        act: rsp
        suffix: rsp
        default: ""
      }
      {
        package: tlul_pkg
        struct: tl_h2d
        signame: flash_ctrl_prim_tl_req
        width: 1
        type: req_rsp
        end_idx: -1
        act: rsp
        suffix: req
        default: tlul_pkg::TL_H2D_DEFAULT
      }
      {
        package: tlul_pkg
        struct: tl_d2h
        signame: flash_ctrl_prim_tl_rsp
        width: 1
        type: req_rsp
        end_idx: -1
        act: rsp
        suffix: rsp
        default: ""
      }
      {
        package: tlul_pkg
        struct: tl_h2d
        signame: flash_ctrl_mem_tl_req
        width: 1
        type: req_rsp
        end_idx: -1
        act: rsp
        suffix: req
        default: tlul_pkg::TL_H2D_DEFAULT
      }
      {
        package: tlul_pkg
        struct: tl_d2h
        signame: flash_ctrl_mem_tl_rsp
        width: 1
        type: req_rsp
        end_idx: -1
        act: rsp
        suffix: rsp
        default: ""
      }
      {
        package: tlul_pkg
        struct: tl_h2d
        signame: aes_tl_req
        width: 1
        type: req_rsp
        end_idx: -1
        act: rsp
        suffix: req
        default: tlul_pkg::TL_H2D_DEFAULT
      }
      {
        package: tlul_pkg
        struct: tl_d2h
        signame: aes_tl_rsp
        width: 1
        type: req_rsp
        end_idx: -1
        act: rsp
        suffix: rsp
        default: ""
      }
      {
        package: tlul_pkg
        struct: tl_h2d
        signame: rv_plic_tl_req
        width: 1
        type: req_rsp
        end_idx: -1
        act: rsp
        suffix: req
        default: tlul_pkg::TL_H2D_DEFAULT
      }
      {
        package: tlul_pkg
        struct: tl_d2h
        signame: rv_plic_tl_rsp
        width: 1
        type: req_rsp
        end_idx: -1
        act: rsp
        suffix: rsp
        default: ""
      }
      {
        package: tlul_pkg
        struct: tl_h2d
        signame: rv_core_ibex_cfg_tl_d_req
        width: 1
        type: req_rsp
        end_idx: -1
        act: rsp
        suffix: req
        default: tlul_pkg::TL_H2D_DEFAULT
      }
      {
        package: tlul_pkg
        struct: tl_d2h
        signame: rv_core_ibex_cfg_tl_d_rsp
        width: 1
        type: req_rsp
        end_idx: -1
        act: rsp
        suffix: rsp
        default: ""
      }
      {
        package: tlul_pkg
        struct: tl_h2d
        signame: sram_ctrl_main_regs_tl_req
        width: 1
        type: req_rsp
        end_idx: -1
        act: rsp
        suffix: req
        default: tlul_pkg::TL_H2D_DEFAULT
      }
      {
        package: tlul_pkg
        struct: tl_d2h
        signame: sram_ctrl_main_regs_tl_rsp
        width: 1
        type: req_rsp
        end_idx: -1
        act: rsp
        suffix: rsp
        default: ""
      }
      {
        package: tlul_pkg
        struct: tl_h2d
        signame: sram_ctrl_main_ram_tl_req
        width: 1
        type: req_rsp
        end_idx: -1
        act: rsp
        suffix: req
        default: tlul_pkg::TL_H2D_DEFAULT
      }
      {
        package: tlul_pkg
        struct: tl_d2h
        signame: sram_ctrl_main_ram_tl_rsp
        width: 1
        type: req_rsp
        end_idx: -1
        act: rsp
        suffix: rsp
        default: ""
      }
      {
        package: tlul_pkg
        struct: tl_h2d
        signame: uart0_tl_req
        width: 1
        type: req_rsp
        end_idx: -1
        act: rsp
        suffix: req
        default: tlul_pkg::TL_H2D_DEFAULT
      }
      {
        package: tlul_pkg
        struct: tl_d2h
        signame: uart0_tl_rsp
        width: 1
        type: req_rsp
        end_idx: -1
        act: rsp
        suffix: rsp
        default: ""
      }
      {
        package: tlul_pkg
        struct: tl_h2d
        signame: uart1_tl_req
        width: 1
        type: req_rsp
        end_idx: -1
        act: rsp
        suffix: req
        default: tlul_pkg::TL_H2D_DEFAULT
      }
      {
        package: tlul_pkg
        struct: tl_d2h
        signame: uart1_tl_rsp
        width: 1
        type: req_rsp
        end_idx: -1
        act: rsp
        suffix: rsp
        default: ""
      }
      {
        package: tlul_pkg
        struct: tl_h2d
        signame: gpio_tl_req
        width: 1
        type: req_rsp
        end_idx: -1
        act: rsp
        suffix: req
        default: tlul_pkg::TL_H2D_DEFAULT
      }
      {
        package: tlul_pkg
        struct: tl_d2h
        signame: gpio_tl_rsp
        width: 1
        type: req_rsp
        end_idx: -1
        act: rsp
        suffix: rsp
        default: ""
      }
      {
        package: tlul_pkg
        struct: tl_h2d
        signame: spi_device_tl_req
        width: 1
        type: req_rsp
        end_idx: -1
        act: rsp
        suffix: req
        default: tlul_pkg::TL_H2D_DEFAULT
      }
      {
        package: tlul_pkg
        struct: tl_d2h
        signame: spi_device_tl_rsp
        width: 1
        type: req_rsp
        end_idx: -1
        act: rsp
        suffix: rsp
        default: ""
      }
      {
        package: tlul_pkg
        struct: tl_h2d
        signame: spi_host0_tl_req
        width: 1
        type: req_rsp
        end_idx: -1
        act: rsp
        suffix: req
        default: tlul_pkg::TL_H2D_DEFAULT
      }
      {
        package: tlul_pkg
        struct: tl_d2h
        signame: spi_host0_tl_rsp
        width: 1
        type: req_rsp
        end_idx: -1
        act: rsp
        suffix: rsp
        default: ""
      }
      {
        package: tlul_pkg
        struct: tl_h2d
        signame: rv_timer_tl_req
        width: 1
        type: req_rsp
        end_idx: -1
        act: rsp
        suffix: req
        default: tlul_pkg::TL_H2D_DEFAULT
      }
      {
        package: tlul_pkg
        struct: tl_d2h
        signame: rv_timer_tl_rsp
        width: 1
        type: req_rsp
        end_idx: -1
        act: rsp
        suffix: rsp
        default: ""
      }
      {
        package: tlul_pkg
        struct: tl_h2d
        signame: usbdev_tl_req
        width: 1
        type: req_rsp
        end_idx: -1
        act: rsp
        suffix: req
        default: tlul_pkg::TL_H2D_DEFAULT
      }
      {
        package: tlul_pkg
        struct: tl_d2h
        signame: usbdev_tl_rsp
        width: 1
        type: req_rsp
        end_idx: -1
        act: rsp
        suffix: rsp
        default: ""
      }
      {
        package: tlul_pkg
        struct: tl_h2d
        signame: pwrmgr_aon_tl_req
        width: 1
        type: req_rsp
        end_idx: -1
        act: rsp
        suffix: req
        default: tlul_pkg::TL_H2D_DEFAULT
      }
      {
        package: tlul_pkg
        struct: tl_d2h
        signame: pwrmgr_aon_tl_rsp
        width: 1
        type: req_rsp
        end_idx: -1
        act: rsp
        suffix: rsp
        default: ""
      }
      {
        package: tlul_pkg
        struct: tl_h2d
        signame: rstmgr_aon_tl_req
        width: 1
        type: req_rsp
        end_idx: -1
        act: rsp
        suffix: req
        default: tlul_pkg::TL_H2D_DEFAULT
      }
      {
        package: tlul_pkg
        struct: tl_d2h
        signame: rstmgr_aon_tl_rsp
        width: 1
        type: req_rsp
        end_idx: -1
        act: rsp
        suffix: rsp
        default: ""
      }
      {
        package: tlul_pkg
        struct: tl_h2d
        signame: clkmgr_aon_tl_req
        width: 1
        type: req_rsp
        end_idx: -1
        act: rsp
        suffix: req
        default: tlul_pkg::TL_H2D_DEFAULT
      }
      {
        package: tlul_pkg
        struct: tl_d2h
        signame: clkmgr_aon_tl_rsp
        width: 1
        type: req_rsp
        end_idx: -1
        act: rsp
        suffix: rsp
        default: ""
      }
      {
        package: tlul_pkg
        struct: tl_h2d
        signame: pinmux_aon_tl_req
        width: 1
        type: req_rsp
        end_idx: -1
        act: rsp
        suffix: req
        default: tlul_pkg::TL_H2D_DEFAULT
      }
      {
        package: tlul_pkg
        struct: tl_d2h
        signame: pinmux_aon_tl_rsp
        width: 1
        type: req_rsp
        end_idx: -1
        act: rsp
        suffix: rsp
        default: ""
      }
      {
        package: clkmgr_pkg
        struct: clkmgr_out
        signame: clkmgr_aon_clocks
        width: 1
        type: uni
        end_idx: -1
        default: ""
      }
      {
        package: clkmgr_pkg
        struct: clkmgr_cg_en
        signame: clkmgr_aon_cg_en
        width: 1
        type: uni
        end_idx: -1
        default: ""
      }
      {
        package: rstmgr_pkg
        struct: rstmgr_out
        signame: rstmgr_aon_resets
        width: 1
        type: uni
        end_idx: -1
        default: ""
      }
      {
        package: rstmgr_pkg
        struct: rstmgr_rst_en
        signame: rstmgr_aon_rst_en
        width: 1
        type: uni
        end_idx: -1
        default: ""
      }
      {
        package: ""
        struct: logic
        signame: rv_core_ibex_irq_timer
        width: 1
        type: uni
        end_idx: -1
        default: ""
      }
      {
        package: ""
        struct: logic
        signame: rv_core_ibex_hart_id
        width: 32
        type: uni
        end_idx: -1
        default: ""
      }
      {
        package: ""
        struct: logic
        signame: rv_core_ibex_boot_addr
        width: 32
        type: uni
        end_idx: -1
        default: ""
      }
      {
        package: lc_ctrl_pkg
        struct: lc_tx
        signame: rv_core_ibex_lc_cpu_en
        width: 1
        type: uni
        end_idx: -1
        default: ""
      }
      {
        package: jtag_pkg
        struct: jtag_req
        signame: pinmux_aon_dft_jtag_req
        width: 1
        type: req_rsp
        end_idx: -1
        default: ""
      }
      {
        package: jtag_pkg
        struct: jtag_rsp
        signame: pinmux_aon_dft_jtag_rsp
        width: 1
        type: req_rsp
        end_idx: -1
        default: ""
      }
      {
        package: prim_mubi_pkg
        struct: mubi8
        signame: sram_ctrl_main_otp_en_sram_ifetch
        width: 1
        type: uni
        end_idx: -1
        default: prim_mubi_pkg::MuBi8False
      }
    ]
  }
}
