// Copyright lowRISC contributors (OpenTitan project).
// Licensed under the Apache License, Version 2.0, see LICENSE for details.
// SPDX-License-Identifier: Apache-2.0
//
// ------------------- W A R N I N G: A U T O - G E N E R A T E D   C O D E !! -------------------//
// PLEASE DO NOT HAND-EDIT THIS FILE. IT HAS BEEN AUTO-GENERATED WITH THE FOLLOWING COMMAND:
// util/topgen.py -t hw/top_englishbreakfast/data/top_englishbreakfast.hjson
//                -o hw/top_englishbreakfast/
{
  name: englishbreakfast
  type: top
  datawidth: "32"
  power:
  {
    domains:
    [
      Aon
      Main
    ]
    default: Main
    wait_for_external_reset: false
  }
  unmanaged_clocks: {}
  clocks:
  {
    srcs:
    [
      {
        name: main
        aon: no
        freq: "100000000"
        ref: false
      }
      {
        name: io
        aon: no
        freq: "96000000"
        ref: false
      }
      {
        name: usb
        aon: no
        freq: "48000000"
        ref: false
      }
      {
        name: aon
        aon: yes
        freq: "200000"
        ref: false
      }
    ]
    derived_srcs:
    [
      {
        name: io_div4
        aon: no
        freq: "24000000"
        ref: false
        div: "4"
        src: io
      }
    ]
    groups:
    [
      {
        name: ast
        src: ext
        sw_cg: no
        unique: no
        clocks:
        {
          clk_main_i: main
          clk_io_i: io
          clk_usb_i: usb
          clk_aon_i: aon
        }
      }
      {
        name: powerup
        src: top
        sw_cg: no
        unique: no
        clocks:
        {
          clk_io_div4_powerup: io_div4
          clk_aon_powerup: aon
          clk_aon_gated_powerup: aon
          clk_main_powerup: main
          clk_io_powerup: io
          clk_usb_powerup: usb
        }
      }
      {
        name: trans
        src: top
        sw_cg: hint
        unique: yes
        clocks:
        {
          clk_main_aes: main
        }
      }
      {
        name: infra
        src: top
        sw_cg: no
        unique: no
        clocks:
        {
          clk_main_infra: main
          clk_io_div4_infra: io_div4
          clk_io_infra: io
          clk_usb_infra: usb
        }
      }
      {
        name: secure
        src: top
        sw_cg: no
        unique: no
        clocks:
        {
          clk_io_div4_secure: io_div4
          clk_aon_gated_secure: aon
          clk_main_secure: main
        }
      }
      {
        name: peri
        src: top
        sw_cg: yes
        unique: no
        clocks:
        {
          clk_io_div4_peri: io_div4
          clk_io_peri: io
          clk_usb_peri: usb
          clk_aon_gated_peri: aon
        }
      }
      {
        name: timers
        src: top
        sw_cg: no
        unique: no
        clocks:
        {
          clk_io_div4_timers: io_div4
          clk_aon_timers: aon
        }
      }
      {
        name: proc
        src: no
        sw_cg: no
        unique: no
        clocks: {}
      }
    ]
  }
  unmanaged_resets: {}
  resets:
  {
    nodes:
    [
      {
        name: por_aon
        gen: false
        type: top
        domains:
        [
          Aon
          Main
        ]
        shadowed: false
        sw: false
        path: rst_por_aon_n
        clock: aon
      }
      {
        name: lc_src
        gen: false
        type: int
        domains: []
        shadowed: false
        sw: false
        path: ""
        clock: io_div4
      }
      {
        name: sys_src
        gen: false
        type: int
        domains: []
        shadowed: false
        sw: false
        path: ""
        clock: io_div4
      }
      {
        name: por
        gen: true
        type: top
        domains:
        [
          Main
        ]
        shadowed: false
        sw: false
        path: rst_por_n
        parent: por_aon
        clock: main
      }
      {
        name: por_io
        gen: true
        type: top
        domains:
        [
          Main
        ]
        shadowed: false
        sw: false
        path: rst_por_io_n
        parent: por_aon
        clock: io
      }
      {
        name: por_io_div4
        gen: true
        type: top
        domains:
        [
          Aon
          Main
        ]
        shadowed: true
        sw: false
        path: rst_por_io_div4_n
        parent: por_aon
        clock: io_div4
      }
      {
        name: por_usb
        gen: true
        type: top
        domains:
        [
          Main
        ]
        shadowed: false
        sw: false
        path: rst_por_usb_n
        parent: por_aon
        clock: usb
      }
      {
        name: lc
        gen: true
        type: top
        domains:
        [
          Main
        ]
        shadowed: true
        sw: false
        path: rst_lc_n
        parent: lc_src
        clock: main
      }
      {
        name: lc_io_div4
        gen: true
        type: top
        domains:
        [
          Main
          Aon
        ]
        shadowed: false
        sw: false
        path: rst_lc_io_div4_n
        parent: lc_src
        clock: io_div4
      }
      {
        name: sys
        gen: true
        type: top
        domains:
        [
          Main
        ]
        shadowed: true
        sw: false
        path: rst_sys_n
        parent: sys_src
        clock: main
      }
      {
        name: sys_io_div4
        gen: true
        type: top
        domains:
        [
          Main
          Aon
        ]
        shadowed: false
        sw: false
        path: rst_sys_io_div4_n
        parent: sys_src
        clock: io_div4
      }
      {
        name: sys_aon
        gen: true
        type: top
        domains:
        [
          Main
          Aon
        ]
        shadowed: false
        sw: false
        path: rst_sys_aon_n
        parent: sys_src
        clock: aon
      }
      {
        name: spi_device
        gen: true
        type: top
        domains:
        [
          Main
        ]
        shadowed: false
        sw: true
        path: rst_spi_device_n
        parent: sys_src
        clock: io_div4
      }
      {
        name: spi_host0
        gen: true
        type: top
        domains:
        [
          Main
        ]
        shadowed: false
        sw: true
        path: rst_spi_host0_n
        parent: sys_src
        clock: io
      }
      {
        name: usb
        gen: true
        type: top
        domains:
        [
          Main
        ]
        shadowed: false
        sw: true
        path: rst_usb_n
        parent: sys_src
        clock: usb
      }
    ]
  }
  reset_requests:
  {
    int:
    [
      {
        name: MainPwr
        desc: main power glitch reset request
        module: pwrmgr
      }
      {
        name: Esc
        desc: escalation reset request
        module: alert_handler
      }
    ]
    debug:
    [
      {
        name: Ndm
        desc: non-debug-module reset request
        module: rv_dm
      }
    ]
    peripheral:
    [
      {
        name: aon_timer_rst_req
        width: "1"
        module: aon_timer
        desc: Watchdog reset request.
        enabled_after_reset: false
      }
    ]
  }
  num_cores: "1"
  default_plic: rv_plic
  default_alert_handler: null
  addr_spaces:
  [
    {
      name: hart
      desc: The main address space, shared between the CPU and DM
      subspaces:
      [
        {
          name: mmio
          desc:
            '''
            MMIO region excludes any memory that is separate from the module configuration
            space, i.e. ROM, main SRAM, and flash are excluded but retention SRAM, spi_device
            memory, or usbdev memory are included.
            '''
          nodes:
          [
            uart0
            uart1
            gpio0
            spi_device
            rv_timer
            spi_host0
            usbdev
            pwrmgr
            rstmgr
            clkmgr
            pinmux
            aon_timer
            ast
            flash_ctrl.core
            flash_ctrl.prim
            rv_plic
            aes
            sram_ctrl_main.regs
            rom_ctrl.regs
            rv_core_ibex
          ]
        }
      ]
    }
  ]
  module:
  [
    {
      name: uart0
      type: uart
      clock_srcs:
      {
        clk_i: io_div4
      }
      clock_group: peri
      reset_connections:
      {
        rst_ni:
        {
          name: lc_io_div4
          domain: Main
        }
      }
      outgoing_alert: englishbreakfast
      domain: Main
      clock_connections:
      {
        clk_i: clkmgr_clocks_i.clk_io_div4_peri
      }
      param_decl: {}
      memory: {}
      param_list: []
      inter_signal_list:
      [
        {
          name: lsio_trigger
          desc:
            '''
            Self-clearing status trigger for the DMA.
            Set when RX or TX FIFOs are past their configured watermarks matching watermark interrupt behaviour.
            '''
          struct: logic
          type: uni
          act: req
          width: 1
          inst_name: uart0
          index: -1
        }
        {
          name: racl_policies
          desc:
            '''
            Incoming RACL policy vector from a racl_ctrl instance.
            The policy selection vector (parameter) selects the policy for each register.
            '''
          struct: racl_policy_vec
          package: top_racl_pkg
          type: uni
          act: rcv
          width: 1
          inst_name: uart0
          index: -1
        }
        {
          name: racl_error
          desc: RACL error log information of this module.
          struct: racl_error_log
          package: top_racl_pkg
          type: uni
          act: req
          width: 1
          inst_name: uart0
          index: -1
        }
        {
          name: tl
          struct: tl
          package: tlul_pkg
          type: req_rsp
          act: rsp
          width: 1
          inst_name: uart0
          default: ""
          end_idx: -1
          top_type: one-to-one
          top_signame: uart0_tl
          index: -1
        }
      ]
      base_addrs:
      {
        null:
        {
          hart: 0x40000000
        }
      }
      generate_dif: true
    }
    {
      name: uart1
      type: uart
      clock_srcs:
      {
        clk_i: io_div4
      }
      clock_group: peri
      reset_connections:
      {
        rst_ni:
        {
          name: lc_io_div4
          domain: Main
        }
      }
      outgoing_alert: englishbreakfast
      domain: Main
      clock_connections:
      {
        clk_i: clkmgr_clocks_i.clk_io_div4_peri
      }
      param_decl: {}
      memory: {}
      param_list: []
      inter_signal_list:
      [
        {
          name: lsio_trigger
          desc:
            '''
            Self-clearing status trigger for the DMA.
            Set when RX or TX FIFOs are past their configured watermarks matching watermark interrupt behaviour.
            '''
          struct: logic
          type: uni
          act: req
          width: 1
          inst_name: uart1
          index: -1
        }
        {
          name: racl_policies
          desc:
            '''
            Incoming RACL policy vector from a racl_ctrl instance.
            The policy selection vector (parameter) selects the policy for each register.
            '''
          struct: racl_policy_vec
          package: top_racl_pkg
          type: uni
          act: rcv
          width: 1
          inst_name: uart1
          index: -1
        }
        {
          name: racl_error
          desc: RACL error log information of this module.
          struct: racl_error_log
          package: top_racl_pkg
          type: uni
          act: req
          width: 1
          inst_name: uart1
          index: -1
        }
        {
          name: tl
          struct: tl
          package: tlul_pkg
          type: req_rsp
          act: rsp
          width: 1
          inst_name: uart1
          default: ""
          end_idx: -1
          top_type: one-to-one
          top_signame: uart1_tl
          index: -1
        }
      ]
      base_addrs:
      {
        null:
        {
          hart: 0x40010000
        }
      }
      generate_dif: true
    }
    {
      name: gpio0
      type: gpio
      template_type: gpio
      clock_srcs:
      {
        clk_i: io_div4
      }
      clock_group: peri
      reset_connections:
      {
        rst_ni:
        {
          name: sys_io_div4
          domain: Main
        }
      }
      param_decl:
      {
        GpioAsyncOn: "1"
      }
      attr: ipgen
      outgoing_alert: englishbreakfast
      domain: Main
      clock_connections:
      {
        clk_i: clkmgr_clocks_i.clk_io_div4_peri
      }
      memory: {}
      param_list:
      [
        {
          name: GpioAsyncOn
          desc: Instantiates 2-flop synchronizers on all GPIO inputs if set to 1.
          type: bit
          default: "1"
          local: "false"
          expose: "true"
          name_top: Gpio0GpioAsyncOn
        }
        {
          name: GpioAsHwStrapsEn
          desc: Enable HW straps sampling logic for GPIO inputs at initial cold boot
          type: bit
          default: 1'b1
          local: "false"
          expose: "true"
          name_top: Gpio0GpioAsHwStrapsEn
        }
      ]
      inter_signal_list:
      [
        {
          name: strap_en
          desc:
            '''
            The strap enable signal tells gpio to take a snapshot of the input pins.
            The behaviour of this signal after that event will have no effect.

            If the `GpioAsHwStrapsEn` synthesis parameter is false this interface is unused.
            '''
          struct: logic
          type: uni
          act: rcv
          width: 1
          default: 1'b0
          inst_name: gpio0
          index: -1
        }
        {
          name: sampled_straps
          desc:
            '''
            This vector contains the sampled strap values.

            If the `GpioAsHwStrapsEn` synthesis parameter is false this interface is unused.
            '''
          struct: gpio_straps
          package: gpio_pkg
          type: uni
          act: req
          width: 1
          default: "'0"
          inst_name: gpio0
          index: -1
        }
        {
          name: racl_policies
          desc:
            '''
            Incoming RACL policy vector from a racl_ctrl instance.
            The policy selection vector (parameter) selects the policy for each register.

            If the `EnableRacl` synthesis parameter is false this interface is unused.
            '''
          struct: racl_policy_vec
          package: top_racl_pkg
          type: uni
          act: rcv
          width: 1
          inst_name: gpio0
          index: -1
        }
        {
          name: racl_error
          desc:
            '''
            RACL error log information of this module.

            If the `EnableRacl` synthesis parameter is false this interface is unused.
            '''
          struct: racl_error_log
          package: top_racl_pkg
          type: uni
          act: req
          width: 1
          inst_name: gpio0
          index: -1
        }
        {
          name: tl
          struct: tl
          package: tlul_pkg
          type: req_rsp
          act: rsp
          width: 1
          inst_name: gpio0
          default: ""
          end_idx: -1
          top_type: one-to-one
          top_signame: gpio0_tl
          index: -1
        }
      ]
      base_addrs:
      {
        null:
        {
          hart: 0x40040000
        }
      }
      generate_dif: true
    }
    {
      name: spi_device
      type: spi_device
      clock_srcs:
      {
        clk_i: io_div4
        scan_clk_i: io_div4
      }
      clock_group: peri
      reset_connections:
      {
        rst_ni:
        {
          name: spi_device
          domain: Main
        }
      }
      outgoing_alert: englishbreakfast
      domain: Main
      clock_connections:
      {
        clk_i: clkmgr_clocks_i.clk_io_div4_peri
        scan_clk_i: clkmgr_clocks_i.clk_io_div4_peri
      }
      param_decl: {}
      memory: {}
      param_list:
      [
        {
          name: SramType
          desc: Sram Entries. Word size is 32bit width.
          type: spi_device_pkg::sram_type_e
          default: spi_device_pkg::DefaultSramType
          local: "false"
          expose: "true"
          name_top: SpiDeviceSramType
        }
      ]
      inter_signal_list:
      [
        {
          name: ram_cfg_sys2spi
          struct: ram_1r1w_cfg
          package: prim_ram_1r1w_pkg
          type: req_rsp
          act: rsp
          width: 1
          inst_name: spi_device
          index: -1
        }
        {
          name: ram_cfg_spi2sys
          struct: ram_1r1w_cfg
          package: prim_ram_1r1w_pkg
          type: req_rsp
          act: rsp
          width: 1
          inst_name: spi_device
          index: -1
        }
        {
          name: passthrough
          struct: passthrough
          package: spi_device_pkg
          type: req_rsp
          act: req
          width: 1
          inst_name: spi_device
          default: ""
          end_idx: -1
          top_type: one-to-one
          top_signame: spi_device_passthrough
          index: -1
        }
        {
          name: mbist_en
          struct: logic
          type: uni
          act: rcv
          width: 1
          inst_name: spi_device
          index: -1
        }
        {
          name: sck_monitor
          struct: logic
          type: uni
          act: req
          width: 1
          inst_name: spi_device
          default: ""
          package: ""
          external: true
          conn_type: false
          index: -1
          top_signame: sck_monitor
        }
        {
          name: racl_policies
          desc:
            '''
            Incoming RACL policy vector from a racl_ctrl instance.
            The policy selection vector (parameter) selects the policy for each register.
            '''
          struct: racl_policy_vec
          package: top_racl_pkg
          type: uni
          act: rcv
          width: 1
          inst_name: spi_device
          index: -1
        }
        {
          name: racl_error
          desc: RACL error log information of this module.
          struct: racl_error_log
          package: top_racl_pkg
          type: uni
          act: req
          width: 1
          inst_name: spi_device
          index: -1
        }
        {
          name: tl
          struct: tl
          package: tlul_pkg
          type: req_rsp
          act: rsp
          width: 1
          inst_name: spi_device
          default: ""
          end_idx: -1
          top_type: one-to-one
          top_signame: spi_device_tl
          index: -1
        }
      ]
      base_addrs:
      {
        null:
        {
          hart: 0x40050000
        }
      }
      generate_dif: true
    }
    {
      name: spi_host0
      type: spi_host
      clock_srcs:
      {
        clk_i: io
      }
      clock_group: peri
      reset_connections:
      {
        rst_ni:
        {
          name: spi_host0
          domain: Main
        }
      }
      outgoing_alert: englishbreakfast
      domain: Main
      clock_connections:
      {
        clk_i: clkmgr_clocks_i.clk_io_peri
      }
      param_decl: {}
      memory: {}
      param_list:
      [
        {
          name: NumCS
          desc: The number of active-low chip select (cs_n) lines to create.
          type: int
          default: "1"
          local: "true"
          expose: "true"
          name_top: SpiHost0NumCS
        }
      ]
      inter_signal_list:
      [
        {
          name: passthrough
          struct: passthrough
          package: spi_device_pkg
          type: req_rsp
          act: rsp
          width: 1
          inst_name: spi_host0
          default: ""
          domain: Main
          top_signame: spi_device_passthrough
          index: -1
        }
        {
          name: lsio_trigger
          desc:
            '''
            Self-clearing status trigger for the DMA.
            Set when RX or TX FIFOs are past their configured watermarks matching watermark interrupt behaviour.
            '''
          struct: logic
          type: uni
          act: req
          width: 1
          inst_name: spi_host0
          index: -1
        }
        {
          name: racl_policies
          desc:
            '''
            Incoming RACL policy vector from a racl_ctrl instance.
            The policy selection vector (parameter) selects the policy for each register.
            '''
          struct: racl_policy_vec
          package: top_racl_pkg
          type: uni
          act: rcv
          width: 1
          inst_name: spi_host0
          index: -1
        }
        {
          name: racl_error
          desc: RACL error log information of this module.
          struct: racl_error_log
          package: top_racl_pkg
          type: uni
          act: req
          width: 1
          inst_name: spi_host0
          index: -1
        }
        {
          name: tl
          struct: tl
          package: tlul_pkg
          type: req_rsp
          act: rsp
          width: 1
          inst_name: spi_host0
          default: ""
          end_idx: -1
          top_type: one-to-one
          top_signame: spi_host0_tl
          index: -1
        }
      ]
      base_addrs:
      {
        null:
        {
          hart: 0x40060000
        }
      }
      generate_dif: true
    }
    {
      name: rv_timer
      type: rv_timer
      clock_srcs:
      {
        clk_i: io_div4
      }
      clock_group: timers
      reset_connections:
      {
        rst_ni:
        {
          name: sys_io_div4
          domain: Main
        }
      }
      outgoing_alert: englishbreakfast
      domain: Main
      clock_connections:
      {
        clk_i: clkmgr_clocks_i.clk_io_div4_timers
      }
      param_decl: {}
      memory: {}
      param_list: []
      inter_signal_list:
      [
        {
          name: racl_policies
          desc:
            '''
            Incoming RACL policy vector from a racl_ctrl instance.
            The policy selection vector (parameter) selects the policy for each register.
            '''
          struct: racl_policy_vec
          package: top_racl_pkg
          type: uni
          act: rcv
          width: 1
          inst_name: rv_timer
          index: -1
        }
        {
          name: racl_error
          desc: RACL error log information of this module.
          struct: racl_error_log
          package: top_racl_pkg
          type: uni
          act: req
          width: 1
          inst_name: rv_timer
          index: -1
        }
        {
          name: tl
          struct: tl
          package: tlul_pkg
          type: req_rsp
          act: rsp
          width: 1
          inst_name: rv_timer
          default: ""
          end_idx: -1
          top_type: one-to-one
          top_signame: rv_timer_tl
          index: -1
        }
      ]
      base_addrs:
      {
        null:
        {
          hart: 0x40100000
        }
      }
      generate_dif: true
    }
    {
      name: usbdev
      type: usbdev
      clock_srcs:
      {
        clk_i: usb
        clk_aon_i: aon
      }
      clock_group: peri
      reset_connections:
      {
        rst_ni:
        {
          name: usb
          domain: Main
        }
        rst_aon_ni:
        {
          name: sys_aon
          domain: Main
        }
      }
      outgoing_alert: englishbreakfast
      domain: Main
      clock_connections:
      {
        clk_i: clkmgr_clocks_i.clk_usb_peri
        clk_aon_i: clkmgr_clocks_i.clk_aon_gated_peri
      }
      param_decl: {}
      memory: {}
      param_list:
      [
        {
          name: Stub
          desc: Stub out the USB device logic, leaving only the register interface
          type: bit
          default: "0"
          local: "false"
          expose: "true"
          name_top: UsbdevStub
        }
        {
          name: RcvrWakeTimeUs
          desc: Maximum number of microseconds for the differential receiver to become operational
          type: int
          default: "1"
          local: "false"
          expose: "true"
          name_top: UsbdevRcvrWakeTimeUs
        }
      ]
      inter_signal_list:
      [
        {
          name: usb_rx_d
          desc: USB RX data from an external differential receiver, if available
          struct: logic
          type: uni
          act: rcv
          width: 1
          inst_name: usbdev
          default: ""
          package: ""
          external: true
          conn_type: false
          index: -1
          top_signame: usbdev_usb_rx_d
        }
        {
          name: usb_tx_d
          desc: USB transmit data value (not used if usb_tx_se0 is set)
          struct: logic
          type: uni
          act: req
          width: 1
          inst_name: usbdev
          default: ""
          package: ""
          external: true
          conn_type: false
          index: -1
          top_signame: usbdev_usb_tx_d
        }
        {
          name: usb_tx_se0
          desc: Force transmission of a USB single-ended zero (i.e. both D+ and D- are low) regardless of usb_tx_d
          struct: logic
          type: uni
          act: req
          width: 1
          inst_name: usbdev
          default: ""
          package: ""
          external: true
          conn_type: false
          index: -1
          top_signame: usbdev_usb_tx_se0
        }
        {
          name: usb_tx_use_d_se0
          desc: Use the usb_tx_d and usb_tx_se0 TX interface, instead of usb_dp_o and usb_dn_o
          struct: logic
          type: uni
          act: req
          width: 1
          inst_name: usbdev
          default: ""
          package: ""
          external: true
          conn_type: false
          index: -1
          top_signame: usbdev_usb_tx_use_d_se0
        }
        {
          name: usb_dp_pullup
          desc: USB D+ pullup control
          struct: logic
          type: uni
          act: req
          width: 1
          inst_name: usbdev
          default: ""
          package: ""
          end_idx: -1
          top_type: broadcast
          top_signame: usbdev_usb_dp_pullup
          index: -1
        }
        {
          name: usb_dn_pullup
          desc: USB D- pullup control
          struct: logic
          type: uni
          act: req
          width: 1
          inst_name: usbdev
          default: ""
          package: ""
          end_idx: -1
          top_type: broadcast
          top_signame: usbdev_usb_dn_pullup
          index: -1
        }
        {
          name: usb_rx_enable
          desc: USB differential receiver enable
          struct: logic
          type: uni
          act: req
          width: 1
          inst_name: usbdev
          default: ""
          package: ""
          external: true
          conn_type: false
          index: -1
          top_signame: usbdev_usb_rx_enable
        }
        {
          name: usb_ref_val
          desc: This indicates that USB timing reference signal 'usb_ref_pulse' is valid
          struct: logic
          type: uni
          act: req
          width: 1
          inst_name: usbdev
          default: ""
          package: ""
          external: true
          conn_type: false
          index: -1
          top_signame: usbdev_usb_ref_val
        }
        {
          name: usb_ref_pulse
          desc: USB timing reference signal. This signal pulses for a single 48MHz clock every 1ms USB frame
          struct: logic
          type: uni
          act: req
          width: 1
          inst_name: usbdev
          default: ""
          package: ""
          external: true
          conn_type: false
          index: -1
          top_signame: usbdev_usb_ref_pulse
        }
        {
          name: usb_aon_suspend_req
          desc: Request to activate the AON/Wake module and take control of the USB pullups
          struct: logic
          type: uni
          act: req
          width: 1
          inst_name: usbdev
          default: ""
          package: ""
          end_idx: -1
          top_type: broadcast
          top_signame: usbdev_usb_aon_suspend_req
          index: -1
        }
        {
          name: usb_aon_wake_ack
          desc: Acknowledge a wake signal from the AON/Wake and relinquish control of the USB pullups
          struct: logic
          type: uni
          act: req
          width: 1
          inst_name: usbdev
          default: ""
          package: ""
          end_idx: -1
          top_type: broadcast
          top_signame: usbdev_usb_aon_wake_ack
          index: -1
        }
        {
          name: usb_aon_bus_reset
          desc: Indicates that the reason for waking was that a USB Bus Reset occurred
          struct: logic
          type: uni
          act: rcv
          width: 1
          inst_name: usbdev
          default: ""
          package: ""
          end_idx: -1
          top_type: broadcast
          top_signame: usbdev_usb_aon_bus_reset
          index: -1
        }
        {
          name: usb_aon_sense_lost
          desc: Indicates that the reason for waking was that the VBUS/SENSE signal became deasserted
          struct: logic
          type: uni
          act: rcv
          width: 1
          inst_name: usbdev
          default: ""
          package: ""
          end_idx: -1
          top_type: broadcast
          top_signame: usbdev_usb_aon_sense_lost
          index: -1
        }
        {
          name: usb_aon_bus_not_idle
          desc: Indicates that the reason for waking was that the USB is in a non-idle state
          struct: logic
          type: uni
          act: rcv
          width: 1
          inst_name: usbdev
          index: -1
        }
        {
          name: usb_aon_wake_detect_active
          desc: Indicates that the external AON/Wake module is active and controlling the USB pullups
          struct: logic
          type: uni
          act: rcv
          width: 1
          inst_name: usbdev
          default: ""
          package: ""
          domain: Main
          top_signame: pinmux_usbdev_wake_detect_active
          index: -1
        }
        {
          name: ram_cfg
          struct: ram_1p_cfg
          package: prim_ram_1p_pkg
          type: req_rsp
          act: rsp
          width: 1
          inst_name: usbdev
          index: -1
        }
        {
          name: tl
          struct: tl
          package: tlul_pkg
          type: req_rsp
          act: rsp
          width: 1
          inst_name: usbdev
          default: ""
          end_idx: -1
          top_type: one-to-one
          top_signame: usbdev_tl
          index: -1
        }
      ]
      base_addrs:
      {
        null:
        {
          hart: 0x40320000
        }
      }
      generate_dif: true
    }
    {
      name: pwrmgr
      type: pwrmgr
      template_type: pwrmgr
      clock_srcs:
      {
        clk_i: io_div4
        clk_slow_i: aon
        clk_lc_i: io_div4
        clk_esc_i: io_div4
      }
      clock_group: powerup
      reset_connections:
      {
        rst_ni:
        {
          name: por_io_div4
          domain: Aon
        }
        rst_lc_ni:
        {
          name: lc_io_div4
          domain: Aon
        }
        rst_esc_ni:
        {
          name: lc_io_div4
          domain: Aon
        }
        rst_main_ni:
        {
          name: por_aon
          domain: Aon
        }
        rst_slow_ni:
        {
          name: por_aon
          domain: Aon
        }
      }
      domain: Aon
      attr: ipgen
      outgoing_alert: englishbreakfast
      clock_connections:
      {
        clk_i: clkmgr_clocks.clk_io_div4_powerup
        clk_slow_i: clkmgr_clocks_secondary.clk_aon_powerup
        clk_lc_i: clkmgr_clocks.clk_io_div4_powerup
        clk_esc_i: clkmgr_clocks.clk_io_div4_powerup
      }
      param_decl: {}
      memory: {}
      param_list:
      [
        {
          name: EscNumSeverities
          desc: Number of escalation severities
          type: int
          default: "4"
          local: "false"
          expose: "false"
          name_top: PwrmgrEscNumSeverities
        }
        {
          name: EscPingCountWidth
          desc: Width of ping count for the escalation receiver
          type: int
          default: "16"
          local: "false"
          expose: "false"
          name_top: PwrmgrEscPingCountWidth
        }
      ]
      inter_signal_list:
      [
        {
          name: pwr_ast
          struct: pwr_ast
          package: pwrmgr_pkg
          type: req_rsp
          act: req
          width: 1
          inst_name: pwrmgr
          default: ""
          external: true
          conn_type: false
          index: -1
          top_signame: pwrmgr_ast
        }
        {
          name: pwr_rst
          struct: pwr_rst
          package: pwrmgr_pkg
          type: req_rsp
          act: req
          width: 1
          inst_name: pwrmgr
          default: ""
          end_idx: -1
          top_type: one-to-one
          top_signame: pwrmgr_pwr_rst
          index: -1
        }
        {
          name: pwr_clk
          struct: pwr_clk
          package: pwrmgr_pkg
          type: req_rsp
          act: req
          width: 1
          inst_name: pwrmgr
          default: ""
          end_idx: -1
          top_type: one-to-one
          top_signame: pwrmgr_pwr_clk
          index: -1
        }
        {
          name: pwr_otp
          struct: pwr_otp
          package: pwrmgr_pkg
          type: req_rsp
          act: req
          width: 1
          inst_name: pwrmgr
          index: -1
        }
        {
          name: pwr_lc
          struct: pwr_lc
          package: lc_ctrl_pkg
          type: req_rsp
          act: req
          width: 1
          inst_name: pwrmgr
          index: -1
        }
        {
          name: pwr_nvm
          struct: pwr_nvm
          package: pwrmgr_pkg
          type: uni
          act: rcv
          width: 1
          inst_name: pwrmgr
          default: ""
          end_idx: -1
          top_type: broadcast
          top_signame: pwrmgr_pwr_nvm
          index: -1
          external: true
          conn_type: false
        }
        {
          name: esc_rst_tx
          struct: esc_tx
          package: prim_esc_pkg
          type: uni
          act: rcv
          width: 1
          inst_name: pwrmgr
          index: -1
        }
        {
          name: esc_rst_rx
          struct: esc_rx
          package: prim_esc_pkg
          type: uni
          act: req
          width: 1
          inst_name: pwrmgr
          index: -1
        }
        {
          name: pwr_cpu
          struct: cpu_pwrmgr
          package: rv_core_ibex_pkg
          type: uni
          act: rcv
          width: 1
          inst_name: pwrmgr
          default: ""
          domain: Aon
          top_signame: rv_core_ibex_pwrmgr
          index: -1
          external: true
          conn_type: false
        }
        {
          name: wakeups
          struct: logic
          type: uni
          act: rcv
          width: 3
          inst_name: pwrmgr
          default: ""
          package: ""
          end_idx: -1
          top_type: one-to-N
          top_signame: pwrmgr_wakeups
          index:
          [
            0
            1
          ]
          external: true
          conn_type: true
        }
        {
          name: rstreqs
          struct: logic
          type: uni
          act: rcv
          width: 1
          inst_name: pwrmgr
          default: ""
          package: ""
          end_idx: -1
          top_type: broadcast
          top_signame: pwrmgr_rstreqs
          index: -1
        }
        {
          name: ndmreset_req
          struct: logic
          type: uni
          act: rcv
          width: 1
          inst_name: pwrmgr
          index: -1
        }
        {
          name: strap
          struct: logic
          type: uni
          act: req
          width: 1
          inst_name: pwrmgr
          default: ""
          package: ""
          end_idx: -1
          top_type: broadcast
          top_signame: pwrmgr_strap
          index: -1
          external: true
          conn_type: false
        }
        {
          name: low_power
          struct: logic
          type: uni
          act: req
          width: 1
          inst_name: pwrmgr
          default: ""
          package: ""
          end_idx: -1
          top_type: broadcast
          top_signame: pwrmgr_low_power
          index: -1
          external: true
          conn_type: true
        }
        {
          name: main_pd_aon_clk_en
          desc:
            '''
            The clkmgr uses this signal to gate clk_aon to the Main power domain. The clock is
            passed from the Aon power domain, where it is free-running, to the Main power domain.
            To prevent glitches, the clock is enabled after the isolation (pwr_clamp) is released
            and gated before the isolation is asserted. In the slow FSM's terminal state, the
            clock is gated in the same cycle as the isolation is asserted. This signal is
            synchronous to the always-on clock (clk_slow_i/clk_aon) and is the inverse of the
            pwr_clamp_env signal.
            '''
          struct: logic
          type: uni
          act: req
          width: 1
          inst_name: pwrmgr
          default: ""
          package: ""
          end_idx: -1
          top_type: broadcast
          top_signame: pwrmgr_main_pd_aon_clk_en
          index: -1
        }
        {
          name: rom_ctrl
          struct: pwrmgr_data
          package: rom_ctrl_pkg
          type: uni
          act: rcv
          width: 1
          default: rom_ctrl_pkg::PWRMGR_DATA_DEFAULT
          inst_name: pwrmgr
          index: -1
        }
        {
          name: fetch_en
          struct: lc_tx
          package: lc_ctrl_pkg
          type: uni
          act: req
          width: 1
          inst_name: pwrmgr
          default: ""
          end_idx: -1
          top_type: broadcast
          top_signame: pwrmgr_fetch_en
          index: -1
          external: true
          conn_type: false
        }
        {
          name: lc_dft_en
          struct: lc_tx
          package: lc_ctrl_pkg
          type: uni
          act: rcv
          width: 1
          inst_name: pwrmgr
          index: -1
        }
        {
          name: lc_hw_debug_en
          struct: lc_tx
          package: lc_ctrl_pkg
          type: uni
          act: rcv
          width: 1
          inst_name: pwrmgr
          index: -1
        }
        {
          name: sw_rst_req
          struct: mubi4
          package: prim_mubi_pkg
          type: uni
          act: rcv
          width: 1
          inst_name: pwrmgr
          default: ""
          domain: Aon
          top_signame: rstmgr_sw_rst_req
          index: -1
        }
        {
          name: tl
          struct: tl
          package: tlul_pkg
          type: req_rsp
          act: rsp
          width: 1
          inst_name: pwrmgr
          default: ""
          end_idx: -1
          top_type: one-to-one
          top_signame: pwrmgr_tl
          index: -1
          external: true
          conn_type: false
        }
      ]
      base_addrs:
      {
        null:
        {
          hart: 0x40400000
        }
      }
      generate_dif: true
    }
    {
      name: rstmgr
      type: rstmgr
      template_type: rstmgr
      clock_srcs:
      {
        clk_i: io_div4
        clk_por_i: io_div4
        clk_aon_i: aon
        clk_main_i: main
        clk_io_i: io
        clk_usb_i: usb
        clk_io_div4_i: io_div4
      }
      clock_group: powerup
      reset_connections:
      {
        rst_ni:
        {
          name: lc_io_div4
          domain: Main
        }
        rst_por_ni:
        {
          name: por_io_div4
          domain: Main
        }
      }
      domain: Aon
      domain_secondary: Aon
      param_decl:
      {
        SecCheck: "0"
      }
      attr: ipgen
      outgoing_alert: englishbreakfast
      clock_srcs_secondary:
      {
        clk_aon_i: aon
      }
      clock_group_secondary: powerup
      reset_connections_secondary:
      {
        rst_aon_ni:
        {
          name: por_aon
          domain: Aon
        }
      }
      clock_connections:
      {
        clk_i: clkmgr_clocks.clk_io_div4_powerup
        clk_por_i: clkmgr_clocks.clk_io_div4_powerup
        clk_aon_i: clkmgr_clocks.clk_aon_gated_powerup
        clk_main_i: clkmgr_clocks.clk_main_powerup
        clk_io_i: clkmgr_clocks.clk_io_powerup
        clk_usb_i: clkmgr_clocks.clk_usb_powerup
        clk_io_div4_i: clkmgr_clocks.clk_io_div4_powerup
      }
      clock_connections_secondary:
      {
        clk_aon_i: clkmgr_clocks_secondary.clk_aon_powerup
      }
      is_split_ip: true
      memory: {}
      param_list:
      [
        {
          name: SecCheck
          desc:
            '''
            When 1, enable rstmgr reset consistency checks.
            When 0, there are no consistency checks.
            '''
          type: bit
          partition: both
          default: "0"
          local: "false"
          expose: "true"
          name_top: SecRstmgrCheck
        }
        {
          name: SecMaxSyncDelay
          desc: The maximum synchronization delay for parent / child reset checks.
          type: int
          partition: both
          default: "2"
          local: "false"
          expose: "true"
          name_top: SecRstmgrMaxSyncDelay
        }
      ]
      inter_signal_list:
      [
        {
          name: por_n
          desc:
            '''
            Root power on reset signals from ast.
            There is one root reset signal for each core power domain.
            '''
          struct: logic
          type: uni
          act: rcv
          width: 2
          partition: secondary
          inst_name: rstmgr
          default: ""
          package: ""
          external: true
          conn_type: false
          index: -1
          top_signame: por_n
        }
        {
          name: pwr
          desc:
            '''
            Reset request signals from power manager.
            Power manager can request for specific domains of the lc/sys reset tree to assert.
            '''
          struct: pwr_rst
          type: req_rsp
          act: rsp
          width: 1
          partition: secondary
          inst_name: rstmgr
          default: ""
          package: pwrmgr_pkg
          domain: Aon
          top_signame: pwrmgr_pwr_rst
          index: -1
        }
        {
          name: resets
          desc: Leaf resets fed to the system.
          struct: rstmgr_out_primary
          package: rstmgr_pkg
          type: uni
          act: req
          width: 1
          inst_name: rstmgr
          default: ""
          top_signame: rstmgr_resets
          index: -1
          external: true
          conn_type: true
        }
        {
          name: resets_secondary
          desc: Leaf resets fed to the system.
          struct: rstmgr_out_secondary
          package: rstmgr_pkg
          type: uni
          act: req
          width: 1
          partition: secondary
          inst_name: rstmgr
          default: ""
          top_signame: rstmgr_resets_secondary
          index: -1
          external: true
          conn_type: true
        }
        {
          name: rst_en
          desc: Low-power-group outputs used by alert handler.
          struct: rstmgr_rst_en_primary
          package: rstmgr_pkg
          type: uni
          act: req
          width: 1
          inst_name: rstmgr
          default: ""
          top_signame: rstmgr_rst_en
          index: -1
          external: true
          conn_type: true
        }
        {
          name: alert_dump
          desc: Alert handler crash dump information.
          struct: alert_crashdump
          package: alert_handler_pkg
          type: uni
          act: rcv
          width: 1
          inst_name: rstmgr
          index: -1
        }
        {
          name: cpu_dump
          desc: Main processing element crash dump information.
          struct: cpu_crash_dump
          package: rv_core_ibex_pkg
          type: uni
          act: rcv
          width: 1
          inst_name: rstmgr
          default: ""
          domain: Aon
          top_signame: rv_core_ibex_crash_dump
          index: -1
          external: true
          conn_type: false
        }
        {
          name: sw_rst_req
          desc: Software requested system reset to pwrmgr.
          struct: mubi4
          package: prim_mubi_pkg
          type: uni
          act: req
          width: 1
          partition: secondary
          inst_name: rstmgr
          default: ""
          end_idx: -1
          top_type: broadcast
          top_signame: rstmgr_sw_rst_req
          index: -1
        }
        {
          name: intraip_s2p
          desc: Secondary-to-primary partition communication
          struct: intraip_s2p
          package: rstmgr_pkg
          type: uni
          act: req
          width: 1
          partition: secondary
          inst_name: rstmgr
          default: ""
          end_idx: -1
          top_type: broadcast
          top_signame: rstmgr_intraip_s2p
          index: -1
        }
        {
          name: intraip_s2p
          desc: Secondary-to-primary partition communication
          struct: intraip_s2p
          package: rstmgr_pkg
          type: uni
          act: rcv
          width: 1
          inst_name: rstmgr
          default: ""
          domain: Aon
          top_signame: rstmgr_intraip_s2p
          index: -1
        }
        {
          name: intraip_p2s
          desc: Primary-to-secondary partition communication
          struct: intraip_p2s
          package: rstmgr_pkg
          type: uni
          act: req
          width: 1
          inst_name: rstmgr
          default: ""
          end_idx: -1
          top_type: broadcast
          top_signame: rstmgr_intraip_p2s
          index: -1
        }
        {
          name: intraip_p2s
          desc: Primary-to-secondary partition communication
          struct: intraip_p2s
          package: rstmgr_pkg
          type: uni
          act: rcv
          width: 1
          partition: secondary
          inst_name: rstmgr
          default: ""
          domain: Aon
          top_signame: rstmgr_intraip_p2s
          index: -1
        }
        {
          name: tl
          struct: tl
          package: tlul_pkg
          type: req_rsp
          act: rsp
          width: 1
          inst_name: rstmgr
          default: ""
          end_idx: -1
          top_type: one-to-one
          top_signame: rstmgr_tl
          index: -1
          external: true
          conn_type: false
        }
      ]
      base_addrs:
      {
        null:
        {
          hart: 0x40410000
        }
      }
      generate_dif: true
    }
    {
      name: clkmgr
      type: clkmgr
      template_type: clkmgr
      clock_srcs:
      {
        clk_i: io_div4
        clk_main_i:
        {
          group: ast
          clock: main
        }
        clk_io_i:
        {
          group: ast
          clock: io
        }
        clk_usb_i:
        {
          group: ast
          clock: usb
        }
      }
      clock_group: powerup
      reset_connections:
      {
        rst_ni:
        {
          name: por_io_div4
          domain: Main
        }
        rst_aon_ni:
        {
          name: por_aon
          domain: Main
        }
        rst_io_ni:
        {
          name: por_io
          domain: Main
        }
        rst_io_div4_ni:
        {
          name: por_io_div4
          domain: Main
        }
        rst_main_ni:
        {
          name: por
          domain: Main
        }
        rst_usb_ni:
        {
          name: por_usb
          domain: Main
        }
        rst_root_ni:
        {
          name: por_io_div4
          domain: Main
        }
        rst_root_io_ni:
        {
          name: por_io
          domain: Main
        }
        rst_root_io_div4_ni:
        {
          name: por_io_div4
          domain: Main
        }
        rst_root_main_ni:
        {
          name: por
          domain: Main
        }
        rst_root_usb_ni:
        {
          name: por_usb
          domain: Main
        }
      }
      domain: Aon
      domain_secondary: Aon
      attr: ipgen
      outgoing_alert: englishbreakfast
      clock_srcs_secondary:
      {
        clk_aon_i:
        {
          group: ast
          clock: aon
        }
      }
      clock_group_secondary: powerup
      reset_connections_secondary:
      {
        rst_aon_ni:
        {
          name: por_aon
          domain: Aon
        }
      }
      clock_connections:
      {
        clk_i: clkmgr_clocks.clk_io_div4_powerup
        clk_main_i: clk_main_i
        clk_io_i: clk_io_i
        clk_usb_i: clk_usb_i
      }
      clock_connections_secondary:
      {
        clk_aon_i: clk_aon_i
      }
      param_decl: {}
      is_split_ip: true
      memory: {}
      param_list: []
      inter_signal_list:
      [
        {
          name: clocks
          desc: Clocks hosted in the primary partition.
          struct: clkmgr_out_primary
          package: clkmgr_pkg
          type: uni
          act: req
          width: 1
          inst_name: clkmgr
          default: ""
          top_signame: clkmgr_clocks
          index: -1
          external: true
          conn_type: true
        }
        {
          name: clocks_secondary
          desc: Clocks hosted in the secondary partition.
          struct: clkmgr_out_secondary
          package: clkmgr_pkg
          type: uni
          act: req
          width: 1
          partition: secondary
          inst_name: clkmgr
          default: ""
          top_signame: clkmgr_clocks_secondary
          index: -1
        }
        {
          name: cg_en
          desc: Clock gating indications for all the clocks (output by the primary partition).
          struct: clkmgr_cg_en_primary
          package: clkmgr_pkg
          type: uni
          act: req
          width: 1
          inst_name: clkmgr
          default: ""
          top_signame: clkmgr_cg_en
          index: -1
          external: true
          conn_type: true
        }
        {
          name: main_pd_aon_clk_en
          desc:
            '''
            The clkmgr uses this signal to gate clk_aon to the Main power domain during a
            power-down. The gate prevents glitches on the clock. See the pwrmgr interface
            definition for more details of main_pd_aon_clk_en_o.
            '''
          struct: logic
          type: uni
          act: rcv
          width: 1
          partition: secondary
          inst_name: clkmgr
          default: ""
          package: ""
          domain: Aon
          top_signame: pwrmgr_main_pd_aon_clk_en
          index: -1
        }
        {
          name: intraip_s2p
          desc: Secondary-to-primary partition communication.
          struct: intraip_s2p
          package: clkmgr_pkg
          type: uni
          act: req
          width: 1
          partition: secondary
          inst_name: clkmgr
          default: ""
          end_idx: -1
          top_type: broadcast
          top_signame: clkmgr_intraip_s2p
          index: -1
        }
        {
          name: intraip_s2p
          desc: Secondary-to-primary partition communication.
          struct: intraip_s2p
          package: clkmgr_pkg
          type: uni
          act: rcv
          width: 1
          inst_name: clkmgr
          default: ""
          domain: Aon
          top_signame: clkmgr_intraip_s2p
          index: -1
        }
        {
          name: intraip_p2s
          desc: Primary-to-secondary partition communication.
          struct: intraip_p2s
          package: clkmgr_pkg
          type: uni
          act: req
          width: 1
          inst_name: clkmgr
          default: ""
          end_idx: -1
          top_type: broadcast
          top_signame: clkmgr_intraip_p2s
          index: -1
        }
        {
          name: intraip_p2s
          desc: Primary-to-secondary partition communication.
          struct: intraip_p2s
          package: clkmgr_pkg
          type: uni
          act: rcv
          width: 1
          partition: secondary
          inst_name: clkmgr
          default: ""
          domain: Aon
          top_signame: clkmgr_intraip_p2s
          index: -1
        }
        {
          name: lc_hw_debug_en
          struct: lc_tx
          package: lc_ctrl_pkg
          type: uni
          act: rcv
          width: 1
          inst_name: clkmgr
          index: -1
        }
        {
          name: io_clk_byp_req
          struct: mubi4
          package: prim_mubi_pkg
          type: uni
          act: req
          width: 1
          inst_name: clkmgr
          default: ""
          external: true
          conn_type: false
          index: -1
          top_signame: io_clk_byp_req
        }
        {
          name: io_clk_byp_ack
          struct: mubi4
          package: prim_mubi_pkg
          type: uni
          act: rcv
          width: 1
          inst_name: clkmgr
          default: ""
          external: true
          conn_type: false
          index: -1
          top_signame: io_clk_byp_ack
        }
        {
          name: all_clk_byp_req
          struct: mubi4
          package: prim_mubi_pkg
          type: uni
          act: req
          width: 1
          inst_name: clkmgr
          default: ""
          external: true
          conn_type: false
          index: -1
          top_signame: all_clk_byp_req
        }
        {
          name: all_clk_byp_ack
          struct: mubi4
          package: prim_mubi_pkg
          type: uni
          act: rcv
          width: 1
          inst_name: clkmgr
          default: ""
          external: true
          conn_type: false
          index: -1
          top_signame: all_clk_byp_ack
        }
        {
          name: hi_speed_sel
          struct: mubi4
          package: prim_mubi_pkg
          type: uni
          act: req
          width: 1
          inst_name: clkmgr
          default: ""
          external: true
          conn_type: false
          index: -1
          top_signame: hi_speed_sel
        }
        {
          name: div_step_down_req
          struct: mubi4
          package: prim_mubi_pkg
          type: uni
          act: rcv
          width: 1
          inst_name: clkmgr
          default: ""
          external: true
          conn_type: false
          index: -1
          top_signame: div_step_down_req
        }
        {
          name: lc_clk_byp_req
          struct: lc_tx
          package: lc_ctrl_pkg
          type: uni
          act: rcv
          width: 1
          inst_name: clkmgr
          index: -1
        }
        {
          name: lc_clk_byp_ack
          struct: lc_tx
          package: lc_ctrl_pkg
          type: uni
          act: req
          width: 1
          inst_name: clkmgr
          index: -1
        }
        {
          name: jitter_en
          struct: mubi4
          package: prim_mubi_pkg
          type: uni
          act: req
          width: 1
          inst_name: clkmgr
          default: ""
          external: true
          conn_type: false
          index: -1
          top_signame: clk_main_jitter_en
        }
        {
          name: pwr
          struct: pwr_clk
          type: req_rsp
          act: rsp
          width: 1
          partition: secondary
          inst_name: clkmgr
          default: ""
          package: pwrmgr_pkg
          domain: Aon
          top_signame: pwrmgr_pwr_clk
          index: -1
        }
        {
          name: idle
          struct: mubi4
          package: prim_mubi_pkg
          type: uni
          act: rcv
          width: 1
          inst_name: clkmgr
          default: ""
          end_idx: -1
          top_type: broadcast
          top_signame: clkmgr_idle
          index: -1
          external: true
          conn_type: false
        }
        {
          name: calib_rdy
          desc: Indicates clocks are calibrated and frequencies accurate
          struct: mubi4
          package: prim_mubi_pkg
          type: uni
          act: rcv
          width: 1
          default: prim_mubi_pkg::MuBi4True
          inst_name: clkmgr
          index: -1
        }
        {
          name: tl
          struct: tl
          package: tlul_pkg
          type: req_rsp
          act: rsp
          width: 1
          inst_name: clkmgr
          default: ""
          end_idx: -1
          top_type: one-to-one
          top_signame: clkmgr_tl
          index: -1
          external: true
          conn_type: false
        }
      ]
      base_addrs:
      {
        null:
        {
          hart: 0x40420000
        }
      }
      generate_dif: true
    }
    {
      name: pinmux
      type: pinmux
      template_type: pinmux
      clock_srcs:
      {
        clk_i: io_div4
        clk_aon_i: aon
      }
      clock_group: powerup
      reset_connections:
      {
        rst_ni:
        {
          name: lc_io_div4
          domain: Main
        }
        rst_aon_ni:
        {
          name: sys_aon
          domain: Main
        }
        rst_sys_ni:
        {
          name: sys_io_div4
          domain: Main
        }
      }
      domain: Main
      attr: ipgen
      outgoing_alert: englishbreakfast
      clock_connections:
      {
        clk_i: clkmgr_clocks_i.clk_io_div4_powerup
        clk_aon_i: clkmgr_clocks_i.clk_aon_gated_powerup
      }
      param_decl: {}
      memory: {}
      param_list:
      [
        {
          name: SecVolatileRawUnlockEn
          desc:
            '''
            Disable (0) or enable (1) volatile RAW UNLOCK capability.
            If enabled, the strap_en_override_i input can be used to re-sample the straps at runtime.

            IMPORTANT NOTE: This should only be used in test chips. The parameter must be set
            to 0 in production tapeouts since this weakens the security posture of the RAW
            UNLOCK mechanism.
            '''
          type: bit
          default: 1'b0
          local: "false"
          expose: "true"
          name_top: SecPinmuxVolatileRawUnlockEn
        }
        {
          name: TargetCfg
          desc: Target specific pinmux configuration.
          type: pinmux_pkg::target_cfg_t
          default: pinmux_pkg::DefaultTargetCfg
          local: "false"
          expose: "true"
          name_top: PinmuxTargetCfg
        }
      ]
      inter_signal_list:
      [
        {
          name: lc_hw_debug_clr
          desc: Debug clear signal coming from life cycle controller, used for HW strap qualification.
          struct: lc_tx
          package: lc_ctrl_pkg
          type: uni
          act: rcv
          width: 1
          default: lc_ctrl_pkg::Off
          inst_name: pinmux
          index: -1
        }
        {
          name: lc_hw_debug_en
          desc: Debug enable qualifier coming from life cycle controller, used for HW strap qualification.
          struct: lc_tx
          package: lc_ctrl_pkg
          type: uni
          act: rcv
          width: 1
          default: lc_ctrl_pkg::Off
          inst_name: pinmux
          index: -1
        }
        {
          name: lc_dft_en
          desc: Test enable qualifier coming from life cycle controller, used for HW strap qualification.
          struct: lc_tx
          package: lc_ctrl_pkg
          type: uni
          act: rcv
          width: 1
          default: lc_ctrl_pkg::Off
          inst_name: pinmux
          index: -1
        }
        {
          name: lc_escalate_en
          desc:
            '''
            Escalation enable signal coming from life cycle controller, used for invalidating
            the latched lc_hw_debug_en state inside the strap sampling logic.
            '''
          struct: lc_tx
          package: lc_ctrl_pkg
          type: uni
          act: rcv
          width: 1
          default: lc_ctrl_pkg::Off
          inst_name: pinmux
          index: -1
        }
        {
          name: lc_check_byp_en
          desc:
            '''
            Check bypass enable signal coming from life cycle controller, used for invalidating
            the latched lc_hw_debug_en state inside the strap sampling logic. This signal is asserted
            whenever the life cycle controller performs a life cycle transition. Its main use is
            to skip any background checks inside the life cycle partition of the OTP controller while
            a life cycle transition is in progress.
            '''
          struct: lc_tx
          package: lc_ctrl_pkg
          type: uni
          act: rcv
          width: 1
          default: lc_ctrl_pkg::Off
          inst_name: pinmux
          index: -1
        }
        {
          name: pinmux_hw_debug_en
          desc:
            '''
            This is the latched version of lc_hw_debug_en_i. We use it exclusively to gate the JTAG
            signals and TAP side of the RV_DM so that RV_DM can remain live during an NDM reset cycle.
            '''
          struct: lc_tx
          package: lc_ctrl_pkg
          type: uni
          act: req
          width: 1
          default: lc_ctrl_pkg::Off
          inst_name: pinmux
          index: -1
        }
        {
          name: lc_jtag
          desc: Qualified JTAG signals for life cycle controller TAP.
          struct: jtag
          package: jtag_pkg
          type: req_rsp
          act: req
          width: 1
          inst_name: pinmux
          index: -1
        }
        {
          name: rv_jtag
          desc: Qualified JTAG signals for RISC-V processor TAP.
          struct: jtag
          package: jtag_pkg
          type: req_rsp
          act: req
          width: 1
          inst_name: pinmux
          index: -1
        }
        {
          name: dft_jtag
          desc: Qualified JTAG signals for DFT TAP.
          struct: jtag
          package: jtag_pkg
          type: req_rsp
          act: req
          width: 1
          inst_name: pinmux
          default: ""
          top_signame: pinmux_dft_jtag
          index: -1
        }
        {
          name: dft_strap_test
          desc: Sampled DFT strap values, going to the DFT TAP.
          struct: dft_strap_test_req
          package: pinmux_pkg
          type: uni
          act: req
          width: 1
          default: "'0"
          inst_name: pinmux
          external: true
          conn_type: false
          index: -1
          top_signame: dft_strap_test
        }
        {
          name: dft_hold_tap_sel
          desc: TAP selection hold indication, asserted by the DFT TAP during boundary scan.
          struct: logic
          type: uni
          act: rcv
          width: 1
          default: "'0"
          inst_name: pinmux
          package: ""
          external: true
          conn_type: false
          index: -1
          top_signame: dft_hold_tap_sel
        }
        {
          name: sleep_en
          desc: Level signal that is asserted when the power manager enters sleep.
          struct: logic
          type: uni
          act: rcv
          width: 1
          default: 1'b0
          inst_name: pinmux
          package: ""
          domain: Main
          top_signame: pwrmgr_low_power
          index: -1
          external: true
          conn_type: false
        }
        {
          name: strap_en
          desc: This signal is pulsed high by the power manager after reset in order to sample the HW straps.
          struct: logic
          type: uni
          act: rcv
          width: 1
          default: 1'b0
          inst_name: pinmux
          package: ""
          domain: Main
          top_signame: pwrmgr_strap
          index: -1
          external: true
          conn_type: false
        }
        {
          name: strap_en_override
          desc:
            '''
            This signal transitions from 0 -> 1 by the lc_ctrl manager after volatile RAW_UNLOCK in order to re-sample the HW straps.
            The signal must stay at 1 until reset.
            Note that this is only used in test chips when SecVolatileRawUnlockEn = 1.
            Otherwise this signal is unused.
            '''
          struct: logic
          type: uni
          act: rcv
          width: 1
          default: 1'b0
          inst_name: pinmux
          index: -1
        }
        {
          name: pin_wkup_req
          desc: Wakeup request from wakeup detectors, to the power manager, running on the AON clock.
          struct: logic
          type: uni
          act: req
          width: 1
          default: 1'b0
          inst_name: pinmux
          package: ""
          domain: Main
          top_signame: pwrmgr_wakeups
          index: 0
          external: true
          conn_type: false
        }
        {
          name: usbdev_dppullup_en
          desc: Pullup enable signal coming from the USB IP.
          struct: logic
          type: uni
          act: rcv
          width: 1
          inst_name: pinmux
          default: ""
          package: ""
          domain: Main
          top_signame: usbdev_usb_dp_pullup
          index: -1
        }
        {
          name: usbdev_dnpullup_en
          desc: Pullup enable signal coming from the USB IP.
          struct: logic
          type: uni
          act: rcv
          width: 1
          inst_name: pinmux
          default: ""
          package: ""
          domain: Main
          top_signame: usbdev_usb_dn_pullup
          index: -1
        }
        {
          name: usb_dppullup_en
          desc: " Pullup enable signal going to USB PHY, needs to be maintained in low-power mode."
          struct: logic
          type: uni
          act: req
          width: 1
          default: 1'b0
          inst_name: pinmux
          package: ""
          external: true
          conn_type: false
          index: -1
          top_signame: usb_dp_pullup_en
        }
        {
          name: usb_dnpullup_en
          desc: Pullup enable signal going to USB PHY, needs to be maintained in low-power mode.
          struct: logic
          type: uni
          act: req
          width: 1
          default: 1'b0
          inst_name: pinmux
          package: ""
          external: true
          conn_type: false
          index: -1
          top_signame: usb_dn_pullup_en
        }
        {
          name: usb_wkup_req
          desc: Wakeup request from USB wakeup detector, going to the power manager, running on the AON clock.
          struct: logic
          type: uni
          act: req
          width: 1
          default: 1'b0
          inst_name: pinmux
          package: ""
          domain: Main
          top_signame: pwrmgr_wakeups
          index: 1
          external: true
          conn_type: false
        }
        {
          name: usbdev_suspend_req
          desc: Indicates whether USB is in suspended state, coming from the USB device.
          struct: logic
          type: uni
          act: rcv
          width: 1
          inst_name: pinmux
          default: ""
          package: ""
          domain: Main
          top_signame: usbdev_usb_aon_suspend_req
          index: -1
        }
        {
          name: usbdev_wake_ack
          desc: Acknowledges the USB wakeup request, coming from the USB device.
          struct: logic
          type: uni
          act: rcv
          width: 1
          inst_name: pinmux
          default: ""
          package: ""
          domain: Main
          top_signame: usbdev_usb_aon_wake_ack
          index: -1
        }
        {
          name: usbdev_bus_not_idle
          desc: Event signal that indicates that the USB was not idle while monitoring.
          struct: logic
          type: uni
          act: req
          width: 1
          default: 1'b0
          inst_name: pinmux
          index: -1
        }
        {
          name: usbdev_bus_reset
          desc: Event signal that indicates that the USB issued a Bus Reset while monitoring.
          struct: logic
          type: uni
          act: req
          width: 1
          default: 1'b0
          inst_name: pinmux
          package: ""
          domain: Main
          top_signame: usbdev_usb_aon_bus_reset
          index: -1
        }
        {
          name: usbdev_sense_lost
          desc: Event signal that indicates that USB SENSE signal was lost while monitoring.
          struct: logic
          type: uni
          act: req
          width: 1
          default: 1'b0
          inst_name: pinmux
          package: ""
          domain: Main
          top_signame: usbdev_usb_aon_sense_lost
          index: -1
        }
        {
          name: usbdev_wake_detect_active
          desc: State debug information.
          struct: logic
          type: uni
          act: req
          width: 1
          default: 1'b0
          inst_name: pinmux
          package: ""
          end_idx: -1
          top_type: broadcast
          top_signame: pinmux_usbdev_wake_detect_active
          index: -1
        }
        {
          name: tl
          struct: tl
          package: tlul_pkg
          type: req_rsp
          act: rsp
          width: 1
          inst_name: pinmux
          default: ""
          end_idx: -1
          top_type: one-to-one
          top_signame: pinmux_tl
          index: -1
        }
      ]
      base_addrs:
      {
        null:
        {
          hart: 0x40460000
        }
      }
      generate_dif: true
    }
    {
      name: aon_timer
      type: aon_timer
      clock_srcs:
      {
        clk_i: io_div4
        clk_aon_i: aon
      }
      clock_group: timers
      reset_connections:
      {
        rst_ni:
        {
          name: sys_io_div4
          domain: Aon
        }
        rst_aon_ni:
        {
          name: sys_aon
          domain: Aon
        }
      }
      domain: Aon
      outgoing_alert: englishbreakfast
      clock_connections:
      {
        clk_i: clkmgr_clocks.clk_io_div4_timers
        clk_aon_i: clkmgr_clocks_secondary.clk_aon_timers
      }
      param_decl: {}
      memory: {}
      param_list: []
      inter_signal_list:
      [
        {
          name: nmi_wdog_timer_bark
          struct: logic
          type: uni
          act: req
          width: 1
          default: 1'b0
          inst_name: aon_timer
          index: -1
        }
        {
          name: wkup_req
          struct: logic
          type: uni
          act: req
          width: 1
          default: 1'b0
          inst_name: aon_timer
          package: ""
          domain: Aon
          top_signame: pwrmgr_wakeups
          index: 2
        }
        {
          name: aon_timer_rst_req
          struct: logic
          type: uni
          act: req
          width: 1
          default: 1'b0
          inst_name: aon_timer
          package: ""
          domain: Aon
          top_signame: pwrmgr_rstreqs
          index: -1
        }
        {
          name: lc_escalate_en
          struct: lc_tx
          package: lc_ctrl_pkg
          type: uni
          act: rcv
          width: 1
          default: lc_ctrl_pkg::Off
          inst_name: aon_timer
          index: -1
        }
        {
          name: sleep_mode
          struct: logic
          type: uni
          act: rcv
          width: 1
          inst_name: aon_timer
          default: ""
          package: ""
          domain: Aon
          top_signame: pwrmgr_low_power
          index: -1
        }
        {
          name: racl_policies
          desc:
            '''
            Incoming RACL policy vector from a racl_ctrl instance.
            The policy selection vector (parameter) selects the policy for each register.
            '''
          struct: racl_policy_vec
          package: top_racl_pkg
          type: uni
          act: rcv
          width: 1
          inst_name: aon_timer
          index: -1
        }
        {
          name: racl_error
          desc: RACL error log information of this module.
          struct: racl_error_log
          package: top_racl_pkg
          type: uni
          act: req
          width: 1
          inst_name: aon_timer
          index: -1
        }
        {
          name: tl
          struct: tl
          package: tlul_pkg
          type: req_rsp
          act: rsp
          width: 1
          inst_name: aon_timer
          index: -1
        }
      ]
      base_addrs:
      {
        null:
        {
          hart: 0x40470000
        }
      }
      generate_dif: true
    }
    {
      name: ast
      type: ast
      clock_srcs:
      {
        clk_ast_tlul_i:
        {
          clock: io_div4
          group: secure
        }
        clk_ast_adc_i:
        {
          clock: aon
          group: secure
        }
        clk_ast_alert_i:
        {
          clock: io_div4
          group: secure
        }
        clk_ast_es_i:
        {
          clock: main
          group: secure
        }
        clk_ast_rng_i:
        {
          clock: main
          group: secure
        }
        clk_ast_usb_i:
        {
          clock: usb
          group: peri
        }
      }
      clock_group: secure
      reset_connections:
      {
        rst_ast_tlul_ni:
        {
          name: lc_io_div4
          domain: Main
        }
        rst_ast_adc_ni:
        {
          name: sys_aon
          domain: Main
        }
        rst_ast_alert_ni:
        {
          name: lc_io_div4
          domain: Main
        }
        rst_ast_es_ni:
        {
          name: sys
          domain: Main
        }
        rst_ast_rng_ni:
        {
          name: sys
          domain: Main
        }
        rst_ast_usb_ni:
        {
          name: usb
          domain: Main
        }
      }
      attr: reggen_only
      domain: Main
      clock_connections:
      {
        clk_ast_tlul_i: clkmgr_clocks_i.clk_io_div4_secure
        clk_ast_adc_i: clkmgr_clocks_i.clk_aon_gated_secure
        clk_ast_alert_i: clkmgr_clocks_i.clk_io_div4_secure
        clk_ast_es_i: clkmgr_clocks_i.clk_main_secure
        clk_ast_rng_i: clkmgr_clocks_i.clk_main_secure
        clk_ast_usb_i: clkmgr_clocks_i.clk_usb_peri
      }
      param_decl: {}
      memory: {}
      param_list: []
      inter_signal_list:
      [
        {
          name: tl
          struct: tl
          package: tlul_pkg
          type: req_rsp
          act: rsp
          width: 1
          inst_name: ast
          index: -1
        }
      ]
      base_addrs:
      {
        null:
        {
          hart: 0x40480000
        }
      }
      generate_dif: true
    }
    {
      name: flash_ctrl
      type: flash_ctrl
      template_type: flash_ctrl
      clock_srcs:
      {
        clk_i: main
        clk_otp_i: io_div4
      }
      clock_group: infra
      reset_connections:
      {
        rst_ni:
        {
          name: lc
          domain: Main
        }
        rst_otp_ni:
        {
          name: lc_io_div4
          domain: Main
        }
      }
      base_addrs:
      {
        core:
        {
          hart: 0x41000000
        }
        prim:
        {
          hart: 0x41008000
        }
        mem:
        {
          hart: 0x20000000
        }
      }
      param_decl:
      {
        SecScrambleEn: "0"
      }
      memory:
      {
        mem:
        {
          label: eflash
          swaccess: ro
          exec: True
          byte_write: False
          config:
          {
            banks: 2
            pages_per_bank: 16
            program_resolution: 8
            pgm_resolution_bytes: 64
            bytes_per_page: 2048
            bytes_per_bank: 32768
            size: 0x10000
          }
          size: 0x10000
        }
      }
      attr: ipgen
      outgoing_alert: englishbreakfast
      domain: Main
      clock_connections:
      {
        clk_i: clkmgr_clocks_i.clk_main_infra
        clk_otp_i: clkmgr_clocks_i.clk_io_div4_infra
      }
      param_list:
      [
        {
          name: SecScrambleEn
          desc: Compile-time option to enable flash scrambling
          type: bit
          default: "0"
          local: "false"
          expose: "true"
          name_top: SecFlashCtrlScrambleEn
        }
        {
          name: ProgFifoDepth
          desc: Depth of program fifo
          type: int
          default: "16"
          local: "false"
          expose: "true"
          name_top: FlashCtrlProgFifoDepth
        }
        {
          name: RdFifoDepth
          desc: Depth of read fifo
          type: int
          default: "16"
          local: "false"
          expose: "true"
          name_top: FlashCtrlRdFifoDepth
        }
      ]
      inter_signal_list:
      [
        {
          name: otp
          struct: nvm_otp_key
          package: otp_ctrl_pkg
          type: req_rsp
          act: req
          width: 1
          inst_name: flash_ctrl
          index: -1
        }
        {
          name: lc_nvm_debug_en
          struct: lc_tx
          package: lc_ctrl_pkg
          type: uni
          act: rcv
          width: 1
          inst_name: flash_ctrl
          index: -1
        }
        {
          name: flash_bist_enable
          struct: mubi4
          package: prim_mubi_pkg
          type: uni
          act: rcv
          width: 1
          inst_name: flash_ctrl
          default: ""
          external: true
          conn_type: false
          index: -1
          top_signame: flash_bist_enable
        }
        {
          name: flash_power_down_h
          struct: logic
          type: uni
          act: rcv
          width: 1
          inst_name: flash_ctrl
          default: ""
          package: ""
          external: true
          conn_type: false
          index: -1
          top_signame: flash_power_down_h
        }
        {
          name: flash_power_ready_h
          struct: logic
          type: uni
          act: rcv
          width: 1
          inst_name: flash_ctrl
          default: ""
          package: ""
          external: true
          conn_type: false
          index: -1
          top_signame: flash_power_ready_h
        }
        {
          name: flash_test_mode_a
          struct: ""
          type: io
          act: none
          width: 2
          inst_name: flash_ctrl
          index: -1
        }
        {
          name: flash_test_voltage_h
          struct: ""
          type: io
          act: none
          width: 1
          inst_name: flash_ctrl
          index: -1
        }
        {
          name: lc_creator_seed_sw_rw_en
          struct: lc_tx
          package: lc_ctrl_pkg
          type: uni
          act: rcv
          width: 1
          inst_name: flash_ctrl
          index: -1
        }
        {
          name: lc_owner_seed_sw_rw_en
          struct: lc_tx
          package: lc_ctrl_pkg
          type: uni
          act: rcv
          width: 1
          inst_name: flash_ctrl
          index: -1
        }
        {
          name: lc_iso_part_sw_rd_en
          struct: lc_tx
          package: lc_ctrl_pkg
          type: uni
          act: rcv
          width: 1
          inst_name: flash_ctrl
          index: -1
        }
        {
          name: lc_iso_part_sw_wr_en
          struct: lc_tx
          package: lc_ctrl_pkg
          type: uni
          act: rcv
          width: 1
          inst_name: flash_ctrl
          index: -1
        }
        {
          name: lc_seed_hw_rd_en
          struct: lc_tx
          package: lc_ctrl_pkg
          type: uni
          act: rcv
          width: 1
          inst_name: flash_ctrl
          index: -1
        }
        {
          name: lc_escalate_en
          struct: lc_tx
          package: lc_ctrl_pkg
          type: uni
          act: rcv
          width: 1
          inst_name: flash_ctrl
          index: -1
        }
        {
          name: rma_req
          struct: lc_tx
          package: lc_ctrl_pkg
          type: uni
          act: rcv
          width: 1
          inst_name: flash_ctrl
          index: -1
        }
        {
          name: rma_ack
          struct: lc_tx
          package: lc_ctrl_pkg
          type: uni
          act: req
          width: 1
          inst_name: flash_ctrl
          index: -1
        }
        {
          name: rma_seed
          struct: lc_nvm_rma_seed
          package: lc_ctrl_pkg
          type: uni
          act: rcv
          width: 1
          inst_name: flash_ctrl
          index: -1
        }
        {
          name: pwrmgr
          struct: pwr_nvm
          package: pwrmgr_pkg
          type: uni
          act: req
          width: 1
          inst_name: flash_ctrl
          default: ""
          domain: Main
          top_signame: pwrmgr_pwr_nvm
          index: -1
          external: true
          conn_type: false
        }
        {
          name: keymgr
          struct: keymgr_flash
          package: flash_ctrl_pkg
          type: uni
          act: req
          width: 1
          inst_name: flash_ctrl
          index: -1
        }
        {
          name: obs_ctrl
          struct: ast_obs_ctrl
          package: ast_pkg
          type: uni
          act: rcv
          width: 1
          inst_name: flash_ctrl
          default: ""
          external: true
          conn_type: false
          index: -1
          top_signame: obs_ctrl
        }
        {
          name: fla_obs
          struct: logic
          type: uni
          act: req
          width: 8
          inst_name: flash_ctrl
          default: ""
          package: ""
          external: true
          conn_type: false
          index: -1
          top_signame: flash_obs
        }
        {
          name: core_tl
          struct: tl
          package: tlul_pkg
          type: req_rsp
          act: rsp
          width: 1
          inst_name: flash_ctrl
          default: ""
          end_idx: -1
          top_type: one-to-one
          top_signame: flash_ctrl_core_tl
          index: -1
        }
        {
          name: prim_tl
          struct: tl
          package: tlul_pkg
          type: req_rsp
          act: rsp
          width: 1
          inst_name: flash_ctrl
          default: ""
          end_idx: -1
          top_type: one-to-one
          top_signame: flash_ctrl_prim_tl
          index: -1
        }
        {
          name: mem_tl
          struct: tl
          package: tlul_pkg
          type: req_rsp
          act: rsp
          width: 1
          inst_name: flash_ctrl
          default: ""
          end_idx: -1
          top_type: one-to-one
          top_signame: flash_ctrl_mem_tl
          index: -1
        }
      ]
      generate_dif: true
    }
    {
      name: rv_plic
      type: rv_plic
      template_type: rv_plic
      clock_srcs:
      {
        clk_i: main
      }
      clock_group: secure
      reset_connections:
      {
        rst_ni:
        {
          name: sys
          domain: Main
        }
      }
      attr: ipgen
      targets:
      [
        rv_core_ibex
      ]
      outgoing_alert: englishbreakfast
      domain: Main
      clock_connections:
      {
        clk_i: clkmgr_clocks_i.clk_main_secure
      }
      param_decl: {}
      memory: {}
      param_list: []
      inter_signal_list:
      [
        {
          name: irq
          struct: logic
          type: uni
          act: req
          width: 1
          inst_name: rv_plic
          default: ""
          package: ""
          end_idx: -1
          top_type: broadcast
          top_signame: rv_plic_irq
          index: -1
        }
        {
          name: irq_id
          struct: logic
          type: uni
          act: req
          width: 1
          inst_name: rv_plic
          index: -1
        }
        {
          name: msip
          struct: logic
          type: uni
          act: req
          width: 1
          inst_name: rv_plic
          default: ""
          package: ""
          end_idx: -1
          top_type: broadcast
          top_signame: rv_plic_msip
          index: -1
        }
        {
          name: tl
          struct: tl
          package: tlul_pkg
          type: req_rsp
          act: rsp
          width: 1
          inst_name: rv_plic
          default: ""
          end_idx: -1
          top_type: one-to-one
          top_signame: rv_plic_tl
          index: -1
        }
      ]
      base_addrs:
      {
        null:
        {
          hart: 0x48000000
        }
      }
      generate_dif: true
    }
    {
      name: aes
      type: aes
      clock_srcs:
      {
        clk_i: main
        clk_edn_i: main
      }
      clock_group: trans
      reset_connections:
      {
        rst_ni:
        {
          name: sys
          domain: Main
        }
        rst_edn_ni:
        {
          name: sys
          domain: Main
        }
      }
      param_decl:
      {
        AESGCMEnable: "1"
        SecMasking: "1"
        SecSBoxImpl: aes_pkg::SBoxImplDom
      }
      outgoing_alert: englishbreakfast
      domain: Main
      clock_connections:
      {
        clk_i: clkmgr_clocks_i.clk_main_aes
        clk_edn_i: clkmgr_clocks_i.clk_main_aes
      }
      memory: {}
      param_list:
      [
        {
          name: AES192Enable
          desc: Disable (0) or enable (1) support for 192-bit key lengths (AES-192).
          type: bit
          default: 1'b1
          local: "false"
          expose: "false"
          name_top: AesAES192Enable
        }
        {
          name: AESGCMEnable
          desc: Disable (0) or enable (1) support for Galois/Counter Mode (GCM) in hardware.
          type: bit
          default: "1"
          local: "false"
          expose: "true"
          name_top: AesAESGCMEnable
        }
        {
          name: SecMasking
          desc:
            '''
            Disable (0) or enable (1) first-order masking of the AES cipher core and the GHASH operation of GCM.
            Masking requires the use of a masked S-Box, see SecSBoxImpl parameter.
            '''
          type: bit
          default: "1"
          local: "false"
          expose: "true"
          name_top: SecAesMasking
        }
        {
          name: SecSBoxImpl
          desc: Selection of the S-Box implementation. See aes_pkg.sv.
          type: aes_pkg::sbox_impl_e
          default: aes_pkg::SBoxImplDom
          local: "false"
          expose: "true"
          name_top: SecAesSBoxImpl
        }
        {
          name: SecStartTriggerDelay
          desc:
            '''
            Manual start trigger delay, useful for SCA measurements.
            A value of e.g. 40 allows the processor to go into sleep before AES starts operation.
            '''
          type: int unsigned
          default: "0"
          local: "false"
          expose: "true"
          name_top: SecAesStartTriggerDelay
        }
        {
          name: SecAllowForcingMasks
          desc:
            '''
            Forbid (0) or allow (1) forcing the masking PRNG output to a constant value via FORCE_MASKS bit in the Auxiliary Control Register.
            Useful for SCA measurements.
            Meaningful only if masking is enabled.
            '''
          type: bit
          default: 1'b0
          local: "false"
          expose: "true"
          name_top: SecAesAllowForcingMasks
        }
        {
          name: SecSkipPRNGReseeding
          desc:
            '''
            Perform (0) or skip (1) PRNG reseeding requests, useful for SCA measurements only.
            The current SCA setup doesn't provide sufficient resources to implement the infrastructure required for PRNG reseeding (CSRNG, EDN).
            To enable SCA resistance evaluations, we need to skip reseeding requests on the SCA platform.
            '''
          type: bit
          default: 1'b0
          local: "false"
          expose: "true"
          name_top: SecAesSkipPRNGReseeding
        }
      ]
      inter_signal_list:
      [
        {
          name: idle
          struct: mubi4
          package: prim_mubi_pkg
          type: uni
          act: req
          width: 1
          inst_name: aes
          default: ""
          domain: Main
          top_signame: clkmgr_idle
          index: -1
          external: true
          conn_type: false
        }
        {
          name: output_valid
          struct: logic
          type: uni
          act: req
          width: 1
          inst_name: aes
          index: -1
        }
        {
          name: input_ready
          struct: logic
          type: uni
          act: req
          width: 1
          inst_name: aes
          index: -1
        }
        {
          name: lc_escalate_en
          struct: lc_tx
          package: lc_ctrl_pkg
          type: uni
          act: rcv
          width: 1
          default: lc_ctrl_pkg::Off
          inst_name: aes
          index: -1
        }
        {
          name: edn
          struct: edn
          package: edn_pkg
          type: req_rsp
          act: req
          width: 1
          inst_name: aes
          index: -1
        }
        {
          name: keymgr_key
          struct: hw_key_req
          package: keymgr_dpe_pkg
          type: uni
          act: rcv
          width: 1
          inst_name: aes
          index: -1
        }
        {
          name: tl
          struct: tl
          package: tlul_pkg
          type: req_rsp
          act: rsp
          width: 1
          inst_name: aes
          default: ""
          end_idx: -1
          top_type: one-to-one
          top_signame: aes_tl
          index: -1
        }
      ]
      base_addrs:
      {
        null:
        {
          hart: 0x41100000
        }
      }
      generate_dif: true
    }
    {
      name: sram_ctrl_main
      type: sram_ctrl
      clock_srcs:
      {
        clk_i: main
        clk_otp_i: io_div4
      }
      clock_group: secure
      reset_connections:
      {
        rst_ni:
        {
          name: sys
          domain: Main
        }
        rst_otp_ni:
        {
          name: lc_io_div4
          domain: Main
        }
      }
      param_decl:
      {
        InstrExec: "1"
      }
      base_addrs:
      {
        regs:
        {
          hart: 0x411C0000
        }
        ram:
        {
          hart: 0x10000000
        }
      }
      memory:
      {
        ram:
        {
          label: ram_main
          swaccess: rw
          exec: True
          byte_write: True
          size: 0x20000
        }
      }
      outgoing_alert: englishbreakfast
      domain: Main
      clock_connections:
      {
        clk_i: clkmgr_clocks_i.clk_main_secure
        clk_otp_i: clkmgr_clocks_i.clk_io_div4_secure
      }
      param_list:
      [
        {
          name: MemSizeRam
          desc:
            '''
            Memory size of the RAM (in bytes).
            If address scrambling is enabled, this must be a power of 2 or a multiple of
            2 KiB, and non-power-of-2 sizes that are not a multiple of 16 KiB trigger a lint
            error.
            For details, check the SRAM scrambling primitive (prim_ram_1p_scr).
            '''
          type: int
          name_top: MemSizeSramCtrlMainRam
          default: 131072
        }
        {
          name: InstSize
          desc: Memory size of a single RAM tile (in bytes).
          type: int
          default: "4096"
          local: "false"
          expose: "true"
          name_top: SramCtrlMainInstSize
        }
        {
          name: NumRamInst
          desc: Number of internal RAM instances. Must be the same as ceil(MemSizeRam / InstSize) .
          type: int
          default: 1
          local: "false"
          expose: "true"
          name_top: SramCtrlMainNumRamInst
        }
        {
          name: InstrExec
          desc: Support execution from SRAM
          type: bit
          default: "1"
          local: "false"
          expose: "true"
          name_top: SramCtrlMainInstrExec
        }
        {
          name: NumPrinceRoundsHalf
          desc: Number of PRINCE half rounds for the SRAM scrambling feature
          type: int
          default: "3"
          local: "false"
          expose: "true"
          name_top: SramCtrlMainNumPrinceRoundsHalf
        }
        {
          name: NumAddrScrRounds
          desc: Number of address scrambling rounds. 0 disables address scrambling.
          type: int
          default: "2"
          local: "false"
          expose: "true"
          name_top: SramCtrlMainNumAddrScrRounds
        }
        {
          name: Outstanding
          desc: Number of outstanding TLUL transactions
          type: int
          default: "2"
          local: "true"
          expose: "true"
          name_top: SramCtrlMainOutstanding
        }
        {
          name: EccCorrection
          desc: Enable single-bit error correction and error logging
          type: bit
          default: "0"
          local: "false"
          expose: "true"
          name_top: SramCtrlMainEccCorrection
        }
        {
          name: SecZeroInit
          desc: Initialize the memory with zeros instead of pseudo-random data.
          type: bit
          default: "0"
          local: "false"
          expose: "true"
          name_top: SecSramCtrlMainZeroInit
        }
      ]
      inter_signal_list:
      [
        {
          name: sram_otp_key
          struct: sram_otp_key
          package: otp_ctrl_pkg
          type: req_rsp
          act: req
          width: 1
          inst_name: sram_ctrl_main
          index: -1
        }
        {
          name: ram_cfg
          struct: ram_1p_cfg
          package: prim_ram_1p_pkg
          type: req_rsp
          act: rsp
          width:
          {
            name: NumRamInst
            desc: Number of internal RAM instances. Must be the same as ceil(MemSizeRam / InstSize) .
            param_type: int
            unpacked_dimensions: null
            default: 1
            local: false
            expose: true
            name_top: SramCtrlMainNumRamInst
          }
          inst_name: sram_ctrl_main
          index: -1
        }
        {
          name: lc_escalate_en
          struct: lc_tx
          package: lc_ctrl_pkg
          type: uni
          act: rcv
          width: 1
          default: lc_ctrl_pkg::Off
          inst_name: sram_ctrl_main
          index: -1
        }
        {
          name: lc_hw_debug_en
          struct: lc_tx
          package: lc_ctrl_pkg
          type: uni
          act: rcv
          width: 1
          default: lc_ctrl_pkg::Off
          inst_name: sram_ctrl_main
          index: -1
        }
        {
          name: otp_en_sram_ifetch
          struct: mubi8
          package: prim_mubi_pkg
          type: uni
          act: rcv
          width: 1
          default: prim_mubi_pkg::MuBi8False
          inst_name: sram_ctrl_main
          index: -1
        }
        {
          name: racl_policies
          desc:
            '''
            Incoming RACL policy vector from a racl_ctrl instance.
            The policy selection vector (parameter) selects the policy for each register.
            '''
          struct: racl_policy_vec
          package: top_racl_pkg
          type: uni
          act: rcv
          width: 1
          inst_name: sram_ctrl_main
          index: -1
        }
        {
          name: racl_error
          desc: RACL error log information of this module.
          struct: racl_error_log
          package: top_racl_pkg
          type: uni
          act: req
          width: 1
          inst_name: sram_ctrl_main
          index: -1
        }
        {
          name: sram_rerror
          desc: SRAM read error indicating correctable and uncorrectable ECC errors.
          struct: sram_error_t
          package: sram_ctrl_pkg
          type: uni
          act: req
          width: 1
          inst_name: sram_ctrl_main
          index: -1
        }
        {
          name: regs_tl
          struct: tl
          package: tlul_pkg
          type: req_rsp
          act: rsp
          width: 1
          inst_name: sram_ctrl_main
          default: ""
          end_idx: -1
          top_type: one-to-one
          top_signame: sram_ctrl_main_regs_tl
          index: -1
        }
        {
          name: ram_tl
          struct: tl
          package: tlul_pkg
          type: req_rsp
          act: rsp
          width: 1
          inst_name: sram_ctrl_main
          default: ""
          end_idx: -1
          top_type: one-to-one
          top_signame: sram_ctrl_main_ram_tl
          index: -1
        }
      ]
      generate_dif: true
    }
    {
      name: rom_ctrl
      type: rom_ctrl
      clock_srcs:
      {
        clk_i: main
      }
      clock_group: infra
      reset_connections:
      {
        rst_ni:
        {
          name: sys
          domain: Main
        }
      }
      base_addrs:
      {
        rom:
        {
          hart: 0x00008000
        }
        regs:
        {
          hart: 0x411e0000
        }
      }
      memory:
      {
        rom:
        {
          label: rom
          swaccess: ro
          exec: True
          byte_write: False
          size: 0x8000
        }
      }
      param_decl:
      {
        SecDisableScrambling: 1'b1
      }
      outgoing_alert: englishbreakfast
      domain: Main
      clock_connections:
      {
        clk_i: clkmgr_clocks_i.clk_main_infra
      }
      param_list:
      [
        {
          name: BootRomInitFile
          desc: Contents of ROM
          type: ""
          default: '''""'''
          local: "false"
          expose: "true"
          name_top: RomCtrlBootRomInitFile
        }
        {
          name: FlopToKmac
          desc:
            '''
            Add a flop stage between the output of the ROM and the data that gets
            sent to KMAC. This may break long paths in a target chip, at the cost of
            adding chip area.
            '''
          type: bit
          default: 1'b0
          local: "true"
          expose: "true"
          name_top: RomCtrlFlopToKmac
        }
        {
          name: SecDisableScrambling
          desc:
            '''
            Disable scrambling and checking in rom_ctrl, turning the block into a
            simple ROM wrapper. This isn't intended for real chips, but is useful
            for small FPGA targets where there's not space for the PRINCE
            primitives.
            '''
          type: bit
          default: 1'b1
          local: "false"
          expose: "true"
          name_top: SecRomCtrlDisableScrambling
        }
        {
          name: MemSizeRom
          desc: Memory size of the ROM (in bytes).
          type: int
          name_top: MemSizeRomCtrlRom
          default: 32768
        }
      ]
      inter_signal_list:
      [
        {
          name: rom_cfg
          struct: rom_cfg
          package: prim_rom_pkg
          type: req_rsp
          act: rsp
          width: 1
          inst_name: rom_ctrl
          index: -1
        }
        {
          name: pwrmgr_data
          struct: pwrmgr_data
          package: rom_ctrl_pkg
          type: uni
          act: req
          width: 1
          inst_name: rom_ctrl
          index: -1
        }
        {
          name: keymgr_data
          struct: keymgr_data
          package: rom_ctrl_pkg
          type: uni
          act: req
          width: 1
          inst_name: rom_ctrl
          index: -1
        }
        {
          name: kmac_data
          struct: app
          package: kmac_pkg
          type: req_rsp
          act: req
          width: 1
          inst_name: rom_ctrl
          index: -1
        }
        {
          name: regs_tl
          struct: tl
          package: tlul_pkg
          type: req_rsp
          act: rsp
          width: 1
          inst_name: rom_ctrl
          default: ""
          end_idx: -1
          top_type: one-to-one
          top_signame: rom_ctrl_regs_tl
          index: -1
        }
        {
          name: rom_tl
          struct: tl
          package: tlul_pkg
          type: req_rsp
          act: rsp
          width: 1
          inst_name: rom_ctrl
          default: ""
          end_idx: -1
          top_type: one-to-one
          top_signame: rom_ctrl_rom_tl
          index: -1
        }
      ]
      generate_dif: true
    }
    {
      name: rv_core_ibex
      type: rv_core_ibex
      template_type: rv_core_ibex
      attr: ipgen
      ipgen_params:
      {
        num_regions: 2
      }
      param_decl:
      {
        PMPEnable: "0"
        PMPGranularity: "0"
        PMPNumRegions: "16"
        MHPMCounterNum: "0"
        MHPMCounterWidth: "32"
        RV32E: "0"
        RV32M: ibex_pkg::RV32MSingleCycle
        RV32B: ibex_pkg::RV32BNone
        RV32ZC: ibex_pkg::RV32ZcaZcbZcmp
        RegFile: ibex_pkg::RegFileFF
        BranchTargetALU: "1"
        WritebackStage: "1"
        ICache: "0"
        ICacheECC: "0"
        BranchPredictor: "0"
        DbgTriggerEn: "1"
        SecureIbex: "0"
        DmHaltAddr: "0"
        DmExceptionAddr: "0"
        PipeLine: "0"
      }
      clock_srcs:
      {
        clk_i: main
        clk_edn_i: main
        clk_esc_i: io_div4
        clk_otp_i: io_div4
      }
      clock_group: infra
      reset_connections:
      {
        rst_ni:
        {
          name: sys
          domain: Main
        }
        rst_edn_ni:
        {
          name: sys
          domain: Main
        }
        rst_esc_ni:
        {
          name: lc_io_div4
          domain: Main
        }
        rst_otp_ni:
        {
          name: lc_io_div4
          domain: Main
        }
      }
      outgoing_alert: englishbreakfast
      domain: Main
      clock_connections:
      {
        clk_i: clkmgr_clocks_i.clk_main_infra
        clk_edn_i: clkmgr_clocks_i.clk_main_infra
        clk_esc_i: clkmgr_clocks_i.clk_io_div4_infra
        clk_otp_i: clkmgr_clocks_i.clk_io_div4_infra
      }
      memory: {}
      param_list:
      [
        {
          name: NEscalationSeverities
          desc: Number of escalation severities
          type: int unsigned
          default: "4"
          local: "false"
          expose: "false"
          name_top: RvCoreIbexNEscalationSeverities
        }
        {
          name: WidthPingCounter
          desc: Width of the ping counter
          type: int unsigned
          default: "16"
          local: "false"
          expose: "false"
          name_top: RvCoreIbexWidthPingCounter
        }
        {
          name: PMPEnable
          desc: Enable PMP
          type: bit
          default: "0"
          local: "false"
          expose: "true"
          name_top: RvCoreIbexPMPEnable
        }
        {
          name: PMPGranularity
          desc: PMP Granularity
          type: int unsigned
          default: "0"
          local: "false"
          expose: "true"
          name_top: RvCoreIbexPMPGranularity
        }
        {
          name: PMPNumRegions
          desc: PMP number of regions
          type: int unsigned
          default: "16"
          local: "false"
          expose: "true"
          name_top: RvCoreIbexPMPNumRegions
        }
        {
          name: MHPMCounterNum
          desc: "Number of the MHPM counter "
          type: int unsigned
          default: "0"
          local: "false"
          expose: "true"
          name_top: RvCoreIbexMHPMCounterNum
        }
        {
          name: MHPMCounterWidth
          desc: "Width of the MHPM Counter "
          type: int unsigned
          default: "32"
          local: "false"
          expose: "true"
          name_top: RvCoreIbexMHPMCounterWidth
        }
        {
          name: PMPRstCfg
          desc: Reset value of PMP config CSRs
          type: ibex_pkg::pmp_cfg_t
          unpacked_dimensions: "[16]"
          default: ibex_pkg::PmpCfgRst
          local: "false"
          expose: "true"
          name_top: RvCoreIbexPMPRstCfg
        }
        {
          name: PMPRstAddr
          desc: Reset value of PMP address CSRs
          type: logic [33:0]
          unpacked_dimensions: "[16]"
          default: ibex_pkg::PmpAddrRst
          local: "false"
          expose: "true"
          name_top: RvCoreIbexPMPRstAddr
        }
        {
          name: PMPRstMsecCfg
          desc: Reset value of MSECCFG CSR
          type: ibex_pkg::pmp_mseccfg_t
          default: ibex_pkg::PmpMseccfgRst
          local: "false"
          expose: "true"
          name_top: RvCoreIbexPMPRstMsecCfg
        }
        {
          name: RV32E
          desc: RV32E
          type: bit
          default: "0"
          local: "false"
          expose: "true"
          name_top: RvCoreIbexRV32E
        }
        {
          name: RV32M
          desc: RV32M
          type: ibex_pkg::rv32m_e
          default: ibex_pkg::RV32MSingleCycle
          local: "false"
          expose: "true"
          name_top: RvCoreIbexRV32M
        }
        {
          name: RV32B
          desc: RV32B
          type: ibex_pkg::rv32b_e
          default: ibex_pkg::RV32BNone
          local: "false"
          expose: "true"
          name_top: RvCoreIbexRV32B
        }
        {
          name: RV32ZC
          desc: RV32ZC
          type: ibex_pkg::rv32zc_e
          default: ibex_pkg::RV32ZcaZcbZcmp
          local: "false"
          expose: "true"
          name_top: RvCoreIbexRV32ZC
        }
        {
          name: RegFile
          desc: Reg file
          type: ibex_pkg::regfile_e
          default: ibex_pkg::RegFileFF
          local: "false"
          expose: "true"
          name_top: RvCoreIbexRegFile
        }
        {
          name: BranchTargetALU
          desc: Branch target ALU
          type: bit
          default: "1"
          local: "false"
          expose: "true"
          name_top: RvCoreIbexBranchTargetALU
        }
        {
          name: WritebackStage
          desc: Write back stage
          type: bit
          default: "1"
          local: "false"
          expose: "true"
          name_top: RvCoreIbexWritebackStage
        }
        {
          name: ICache
          desc: Instruction cache
          type: bit
          default: "0"
          local: "false"
          expose: "true"
          name_top: RvCoreIbexICache
        }
        {
          name: ICacheECC
          desc: Instruction cache ECC
          type: bit
          default: "0"
          local: "false"
          expose: "true"
          name_top: RvCoreIbexICacheECC
        }
        {
          name: ICacheScramble
          desc: Scramble instruction cach
          type: bit
          default: "0"
          local: "false"
          expose: "true"
          name_top: RvCoreIbexICacheScramble
        }
        {
          name: ICacheNWays
          desc: Number of instruction cache ways
          type: int unsigned
          default: 2
          local: "false"
          expose: "true"
          name_top: RvCoreIbexICacheNWays
        }
        {
          name: BranchPredictor
          desc: Branch predictor
          type: bit
          default: "0"
          local: "false"
          expose: "true"
          name_top: RvCoreIbexBranchPredictor
        }
        {
          name: DbgTriggerEn
          desc: Enable degug trigger
          type: bit
          default: "1"
          local: "false"
          expose: "true"
          name_top: RvCoreIbexDbgTriggerEn
        }
        {
          name: DbgHwBreakNum
          desc: Number of debug hardware break
          type: int
          default: "1"
          local: "false"
          expose: "true"
          name_top: RvCoreIbexDbgHwBreakNum
        }
        {
          name: SecureIbex
          desc: "Width of the MHPM Counter "
          type: bit
          default: "0"
          local: "false"
          expose: "true"
          name_top: RvCoreIbexSecureIbex
        }
        {
          name: DmBaseAddr
          desc: Base address of Debug Module
          type: int unsigned
          default: "437321728"
          local: "false"
          expose: "true"
          name_top: RvCoreIbexDmBaseAddr
        }
        {
          name: DmAddrMask
          desc: Adress mask of Debug Module
          type: int unsigned
          default: "4095"
          local: "false"
          expose: "true"
          name_top: RvCoreIbexDmAddrMask
        }
        {
          name: DmHaltAddr
          desc: Halt address
          type: int unsigned
          default: "0"
          local: "false"
          expose: "true"
          name_top: RvCoreIbexDmHaltAddr
        }
        {
          name: DmExceptionAddr
          desc: Exception address
          type: int unsigned
          default: "0"
          local: "false"
          expose: "true"
          name_top: RvCoreIbexDmExceptionAddr
        }
        {
          name: PipeLine
          desc: Pipe line
          type: bit
          default: "0"
          local: "false"
          expose: "true"
          name_top: RvCoreIbexPipeLine
        }
        {
          name: TlulHostUserRsvdBits
          desc: TLUL user bits sent on outgoing transfers.
          type: logic [tlul_pkg::RsvdWidth-1:0]
          default: "'0"
          local: "false"
          expose: "true"
          name_top: RvCoreIbexTlulHostUserRsvdBits
        }
        {
          name: CsrMvendorId
          desc:
            '''
            mvendorid: encoding of manufacturer/provider
            0 indicates this field is not implemented.
            Ibex implementors may wish to set their own JEDEC ID here.
            '''
          type: logic [31:0]
          default: "'0"
          local: "false"
          expose: "true"
          name_top: RvCoreIbexCsrMvendorId
        }
        {
          name: CsrMimpId
          desc:
            '''
            mimpid: encoding of processor implementation version
            0 indicates this field is not implemented.
            Ibex implementors may wish to indicate an RTL/netlist version here using their own unique encoding (e.g. 32 bits of the git hash of the implemented commit).
            '''
          type: logic [31:0]
          default: "'0"
          local: "false"
          expose: "true"
          name_top: RvCoreIbexCsrMimpId
        }
        {
          name: InstructionPipeline
          desc: Add a pipeline stage in the instruction interface between Ibex and the address translation
          type: bit
          default: 1'b0
          local: "true"
          expose: "true"
          name_top: RvCoreIbexInstructionPipeline
        }
      ]
      inter_signal_list:
      [
        {
          name: rst_cpu_n
          struct: logic
          type: uni
          act: req
          width: 1
          inst_name: rv_core_ibex
          index: -1
        }
        {
          name: ram_cfg_icache_tag
          struct: ram_1p_cfg
          package: prim_ram_1p_pkg
          type: req_rsp
          act: rsp
          width:
          {
            name: ICacheNWays
            desc: Number of instruction cache ways
            param_type: int unsigned
            unpacked_dimensions: null
            default: 2
            local: false
            expose: true
            name_top: RvCoreIbexICacheNWays
          }
          inst_name: rv_core_ibex
          index: -1
        }
        {
          name: ram_cfg_icache_data
          struct: ram_1p_cfg
          package: prim_ram_1p_pkg
          type: req_rsp
          act: rsp
          width:
          {
            name: ICacheNWays
            desc: Number of instruction cache ways
            param_type: int unsigned
            unpacked_dimensions: null
            default: 2
            local: false
            expose: true
            name_top: RvCoreIbexICacheNWays
          }
          inst_name: rv_core_ibex
          index: -1
        }
        {
          name: hart_id
          struct: logic
          type: uni
          act: rcv
          width: 32
          inst_name: rv_core_ibex
          default: ""
          package: ""
          top_signame: rv_core_ibex_hart_id
          index: -1
        }
        {
          name: boot_addr
          struct: logic
          type: uni
          act: rcv
          width: 32
          inst_name: rv_core_ibex
          default: ""
          package: ""
          top_signame: rv_core_ibex_boot_addr
          index: -1
        }
        {
          name: irq_software
          struct: logic
          type: uni
          act: rcv
          width: 1
          inst_name: rv_core_ibex
          default: ""
          package: ""
          domain: Main
          top_signame: rv_plic_msip
          index: -1
        }
        {
          name: irq_timer
          struct: logic
          type: uni
          act: rcv
          width: 1
          inst_name: rv_core_ibex
          default: ""
          package: ""
          top_signame: rv_core_ibex_irq_timer
          index: -1
        }
        {
          name: irq_external
          struct: logic
          type: uni
          act: rcv
          width: 1
          inst_name: rv_core_ibex
          default: ""
          package: ""
          domain: Main
          top_signame: rv_plic_irq
          index: -1
        }
        {
          name: esc_tx
          struct: esc_tx
          package: prim_esc_pkg
          type: uni
          act: rcv
          width: 1
          inst_name: rv_core_ibex
          index: -1
        }
        {
          name: esc_rx
          struct: esc_rx
          package: prim_esc_pkg
          type: uni
          act: req
          width: 1
          inst_name: rv_core_ibex
          index: -1
        }
        {
          name: debug_req
          struct: logic
          type: uni
          act: rcv
          width: 1
          inst_name: rv_core_ibex
          index: -1
        }
        {
          name: crash_dump
          struct: cpu_crash_dump
          package: rv_core_ibex_pkg
          type: uni
          act: req
          width: 1
          inst_name: rv_core_ibex
          default: ""
          end_idx: -1
          top_type: broadcast
          top_signame: rv_core_ibex_crash_dump
          index: -1
          external: true
          conn_type: false
        }
        {
          name: lc_cpu_en
          struct: lc_tx
          package: lc_ctrl_pkg
          type: uni
          act: rcv
          width: 1
          default: lc_ctrl_pkg::On
          inst_name: rv_core_ibex
          index: -1
        }
        {
          name: pwrmgr_cpu_en
          struct: lc_tx
          package: lc_ctrl_pkg
          type: uni
          act: rcv
          width: 1
          inst_name: rv_core_ibex
          default: ""
          domain: Main
          top_signame: pwrmgr_fetch_en
          index: -1
          external: true
          conn_type: false
        }
        {
          name: pwrmgr
          struct: cpu_pwrmgr
          package: rv_core_ibex_pkg
          type: uni
          act: req
          width: 1
          inst_name: rv_core_ibex
          default: ""
          end_idx: -1
          top_type: broadcast
          top_signame: rv_core_ibex_pwrmgr
          index: -1
          external: true
          conn_type: false
        }
        {
          name: nmi_wdog
          struct: logic
          type: uni
          act: rcv
          width: 1
          inst_name: rv_core_ibex
          index: -1
        }
        {
          name: edn
          struct: edn
          package: edn_pkg
          type: req_rsp
          act: req
          width: 1
          inst_name: rv_core_ibex
          index: -1
        }
        {
          name: icache_otp_key
          struct: sram_otp_key
          package: otp_ctrl_pkg
          type: req_rsp
          act: req
          width: 1
          inst_name: rv_core_ibex
          index: -1
        }
        {
          name: corei_tl_h
          struct: tl
          package: tlul_pkg
          type: req_rsp
          act: req
          width: 1
          inst_name: rv_core_ibex
          default: ""
          domain: Main
          top_signame: main_tl_rv_core_ibex__corei
          index: -1
        }
        {
          name: cored_tl_h
          struct: tl
          package: tlul_pkg
          type: req_rsp
          act: req
          width: 1
          inst_name: rv_core_ibex
          default: ""
          domain: Main
          top_signame: main_tl_rv_core_ibex__cored
          index: -1
        }
        {
          name: cfg_tl_d
          struct: tl
          package: tlul_pkg
          type: req_rsp
          act: rsp
          width: 1
          inst_name: rv_core_ibex
          default: ""
          end_idx: -1
          top_type: one-to-one
          top_signame: rv_core_ibex_cfg_tl_d
          index: -1
        }
      ]
      base_addrs:
      {
        cfg:
        {
          hart: 0x411F0000
        }
      }
      generate_dif: true
    }
  ]
  port:
  [
    {
      name: ast
      inter_signal_list:
      [
        {
          struct: edn
          type: req_rsp
          name: edn
          act: rsp
          package: edn_pkg
          inst_name: ast
          index: -1
        }
        {
          struct: lc_tx
          type: uni
          name: lc_dft_en
          act: req
          package: lc_ctrl_pkg
          inst_name: ast
          index: -1
        }
        {
          struct: ram_1p_cfg_req
          package: prim_ram_1p_pkg
          type: uni
          name: ram_1p_cfg
          act: rcv
          inst_name: ast
          index: -1
        }
        {
          struct: ram_1r1w_cfg_req
          package: prim_ram_1r1w_pkg
          type: uni
          name: ram_1r1w_cfg
          act: rcv
          inst_name: ast
          index: -1
        }
        {
          struct: rom_cfg_req
          package: prim_rom_pkg
          type: uni
          name: rom_cfg
          act: rcv
          inst_name: ast
          index: -1
        }
      ]
    }
  ]
  inter_module:
  {
    connect:
    {
      pwrmgr.pwr_nvm:
      [
        flash_ctrl.pwrmgr
      ]
      pwrmgr.pwr_rst:
      [
        rstmgr.pwr
      ]
      pwrmgr.pwr_clk:
      [
        clkmgr.pwr
      ]
      pwrmgr.main_pd_aon_clk_en:
      [
        clkmgr.main_pd_aon_clk_en
      ]
      pwrmgr.strap:
      [
        pinmux.strap_en
      ]
      pwrmgr.low_power:
      [
        pinmux.sleep_en
        aon_timer.sleep_mode
      ]
      pwrmgr.fetch_en:
      [
        rv_core_ibex.pwrmgr_cpu_en
      ]
      usbdev.usb_dp_pullup:
      [
        pinmux.usbdev_dppullup_en
      ]
      usbdev.usb_dn_pullup:
      [
        pinmux.usbdev_dnpullup_en
      ]
      usbdev.usb_aon_suspend_req:
      [
        pinmux.usbdev_suspend_req
      ]
      usbdev.usb_aon_wake_ack:
      [
        pinmux.usbdev_wake_ack
      ]
      usbdev.usb_aon_bus_reset:
      [
        pinmux.usbdev_bus_reset
      ]
      usbdev.usb_aon_sense_lost:
      [
        pinmux.usbdev_sense_lost
      ]
      pinmux.usbdev_wake_detect_active:
      [
        usbdev.usb_aon_wake_detect_active
      ]
      clkmgr.idle:
      [
        aes.idle
      ]
      rv_plic.msip:
      [
        rv_core_ibex.irq_software
      ]
      rv_plic.irq:
      [
        rv_core_ibex.irq_external
      ]
      rv_core_ibex.crash_dump:
      [
        rstmgr.cpu_dump
      ]
      rv_core_ibex.pwrmgr:
      [
        pwrmgr.pwr_cpu
      ]
      spi_device.passthrough:
      [
        spi_host0.passthrough
      ]
      rstmgr.sw_rst_req:
      [
        pwrmgr.sw_rst_req
      ]
      pwrmgr.wakeups:
      [
        pinmux.pin_wkup_req
        pinmux.usb_wkup_req
        aon_timer.wkup_req
      ]
      pwrmgr.rstreqs:
      [
        aon_timer.aon_timer_rst_req
      ]
      rstmgr.intraip_s2p.secondary:
      [
        rstmgr.intraip_s2p.primary
      ]
      rstmgr.intraip_p2s.primary:
      [
        rstmgr.intraip_p2s.secondary
      ]
      clkmgr.intraip_s2p.secondary:
      [
        clkmgr.intraip_s2p.primary
      ]
      clkmgr.intraip_p2s.primary:
      [
        clkmgr.intraip_p2s.secondary
      ]
      main.tl_rv_core_ibex__corei:
      [
        rv_core_ibex.corei_tl_h
      ]
      main.tl_rv_core_ibex__cored:
      [
        rv_core_ibex.cored_tl_h
      ]
      rom_ctrl.rom_tl:
      [
        main.tl_rom_ctrl__rom
      ]
      rom_ctrl.regs_tl:
      [
        main.tl_rom_ctrl__regs
      ]
      main.tl_peri:
      [
        peri.tl_main
      ]
      flash_ctrl.core_tl:
      [
        main.tl_flash_ctrl__core
      ]
      flash_ctrl.prim_tl:
      [
        main.tl_flash_ctrl__prim
      ]
      flash_ctrl.mem_tl:
      [
        main.tl_flash_ctrl__mem
      ]
      aes.tl:
      [
        main.tl_aes
      ]
      rv_plic.tl:
      [
        main.tl_rv_plic
      ]
      rv_core_ibex.cfg_tl_d:
      [
        main.tl_rv_core_ibex__cfg
      ]
      sram_ctrl_main.regs_tl:
      [
        main.tl_sram_ctrl_main__regs
      ]
      sram_ctrl_main.ram_tl:
      [
        main.tl_sram_ctrl_main__ram
      ]
      uart0.tl:
      [
        peri.tl_uart0
      ]
      uart1.tl:
      [
        peri.tl_uart1
      ]
      gpio0.tl:
      [
        peri.tl_gpio0
      ]
      spi_device.tl:
      [
        peri.tl_spi_device
      ]
      spi_host0.tl:
      [
        peri.tl_spi_host0
      ]
      rv_timer.tl:
      [
        peri.tl_rv_timer
      ]
      usbdev.tl:
      [
        peri.tl_usbdev
      ]
      pwrmgr.tl:
      [
        peri.tl_pwrmgr
      ]
      rstmgr.tl:
      [
        peri.tl_rstmgr
      ]
      clkmgr.tl:
      [
        peri.tl_clkmgr
      ]
      pinmux.tl:
      [
        peri.tl_pinmux
      ]
    }
    top:
    [
      clkmgr.clocks
      clkmgr.clocks_secondary
      clkmgr.cg_en
      rstmgr.resets
      rstmgr.resets_secondary
      rstmgr.rst_en
      rv_core_ibex.irq_timer
      rv_core_ibex.hart_id
      rv_core_ibex.boot_addr
      pinmux.dft_jtag
    ]
    external:
    {
      clkmgr.clocks: ""
      clkmgr.cg_en: ""
      clkmgr.jitter_en: clk_main_jitter_en
      clkmgr.hi_speed_sel: hi_speed_sel
      clkmgr.div_step_down_req: div_step_down_req
      clkmgr.all_clk_byp_req: all_clk_byp_req
      clkmgr.all_clk_byp_ack: all_clk_byp_ack
      clkmgr.io_clk_byp_req: io_clk_byp_req
      clkmgr.io_clk_byp_ack: io_clk_byp_ack
      flash_ctrl.flash_bist_enable: flash_bist_enable
      flash_ctrl.flash_power_down_h: flash_power_down_h
      flash_ctrl.flash_power_ready_h: flash_power_ready_h
      flash_ctrl.obs_ctrl: obs_ctrl
      flash_ctrl.fla_obs: flash_obs
      peri.tl_ast: ast_tl
      pinmux.dft_strap_test: dft_strap_test
      pinmux.dft_hold_tap_sel: dft_hold_tap_sel
      pinmux.usb_dppullup_en: usb_dp_pullup_en
      pinmux.usb_dnpullup_en: usb_dn_pullup_en
      pwrmgr.pwr_ast: pwrmgr_ast
      rstmgr.por_n: por_n
      rstmgr.resets: ""
      rstmgr.resets_secondary: ""
      rstmgr.rst_en: ""
      usbdev.usb_rx_d: ""
      usbdev.usb_tx_d: ""
      usbdev.usb_tx_se0: ""
      usbdev.usb_tx_use_d_se0: ""
      usbdev.usb_rx_enable: ""
      usbdev.usb_ref_val: ""
      usbdev.usb_ref_pulse: ""
      spi_device.sck_monitor: sck_monitor
    }
  }
  xbar:
  [
    {
      name: main
      clock_srcs:
      {
        clk_main_i: main
        clk_fixed_i: io_div4
      }
      clock_group: infra
      reset: rst_main_ni
      reset_connections:
      {
        rst_main_ni:
        {
          name: sys
          domain: Main
        }
        rst_fixed_ni:
        {
          name: sys_io_div4
          domain: Main
        }
      }
      domain: Main
      clock_connections:
      {
        clk_main_i: clkmgr_clocks_i.clk_main_infra
        clk_fixed_i: clkmgr_clocks_i.clk_io_div4_infra
      }
      connections:
      {
        rv_core_ibex.corei:
        [
          rom_ctrl.rom
          sram_ctrl_main.ram
          flash_ctrl.mem
        ]
        rv_core_ibex.cored:
        [
          rom_ctrl.rom
          rom_ctrl.regs
          sram_ctrl_main.ram
          flash_ctrl.mem
          peri
          flash_ctrl.core
          flash_ctrl.prim
          aes
          rv_plic
          sram_ctrl_main.ram
          sram_ctrl_main.regs
          rv_core_ibex.cfg
        ]
      }
      nodes:
      [
        {
          name: rv_core_ibex.corei
          type: host
          addr_space: hart
          clock: clk_main_i
          reset: rst_main_ni
          pipeline: false
          xbar: false
          stub: false
          inst_type: ""
          req_fifo_pass: true
          rsp_fifo_pass: true
        }
        {
          name: rv_core_ibex.cored
          type: host
          addr_space: hart
          clock: clk_main_i
          reset: rst_main_ni
          pipeline: false
          xbar: false
          stub: false
          inst_type: ""
          req_fifo_pass: true
          rsp_fifo_pass: true
        }
        {
          name: rom_ctrl.rom
          type: device
          clock: clk_main_i
          reset: rst_main_ni
          pipeline: false
          inst_type: rom_ctrl
          addr_range:
          [
            {
              base_addrs:
              {
                hart: 0x8000
              }
              size_byte: 0x8000
            }
          ]
          xbar: false
          stub: false
          req_fifo_pass: true
        }
        {
          name: rom_ctrl.regs
          type: device
          clock: clk_main_i
          reset: rst_main_ni
          pipeline: false
          inst_type: rom_ctrl
          addr_range:
          [
            {
              base_addrs:
              {
                hart: 0x411e0000
              }
              size_byte: 0x80
            }
          ]
          xbar: false
          stub: false
          req_fifo_pass: true
        }
        {
          name: peri
          type: device
          clock: clk_fixed_i
          reset: rst_fixed_ni
          pipeline: false
          xbar: true
          stub: false
          req_fifo_pass: true
          addr_space: hart
          addr_range:
          [
            {
              base_addrs:
              {
                hart: 0x40000000
              }
              size_byte: 0x800000
            }
          ]
        }
        {
          name: flash_ctrl.core
          type: device
          clock: clk_main_i
          reset: rst_main_ni
          req_fifo_pass: true
          rsp_fifo_pass: false
          inst_type: flash_ctrl
          addr_range:
          [
            {
              base_addrs:
              {
                hart: 0x41000000
              }
              size_byte: 0x200
            }
          ]
          xbar: false
          stub: false
          pipeline: true
        }
        {
          name: flash_ctrl.prim
          type: device
          clock: clk_main_i
          reset: rst_main_ni
          req_fifo_pass: true
          rsp_fifo_pass: false
          inst_type: flash_ctrl
          addr_range:
          [
            {
              base_addrs:
              {
                hart: 0x41008000
              }
              size_byte: 0x80
            }
          ]
          xbar: false
          stub: false
          pipeline: true
        }
        {
          name: flash_ctrl.mem
          type: device
          clock: clk_main_i
          reset: rst_main_ni
          req_fifo_pass: true
          rsp_fifo_pass: false
          inst_type: flash_ctrl
          addr_range:
          [
            {
              base_addrs:
              {
                hart: 0x20000000
              }
              size_byte: 0x10000
            }
          ]
          xbar: false
          stub: false
          pipeline: true
        }
        {
          name: aes
          type: device
          clock: clk_main_i
          reset: rst_main_ni
          pipeline: false
          inst_type: aes
          addr_range:
          [
            {
              base_addrs:
              {
                hart: 0x41100000
              }
              size_byte: 0x100
            }
          ]
          xbar: false
          stub: false
          req_fifo_pass: true
        }
        {
          name: rv_plic
          type: device
          clock: clk_main_i
          reset: rst_main_ni
          inst_type: rv_plic
          pipeline: false
          addr_range:
          [
            {
              base_addrs:
              {
                hart: 0x48000000
              }
              size_byte: 0x8000000
            }
          ]
          xbar: false
          stub: false
          req_fifo_pass: true
        }
        {
          name: rv_core_ibex.cfg
          type: device
          clock: clk_main_i
          reset: rst_main_ni
          pipeline: false
          inst_type: rv_core_ibex
          addr_range:
          [
            {
              base_addrs:
              {
                hart: 0x411f0000
              }
              size_byte: 0x100
            }
          ]
          xbar: false
          stub: false
          req_fifo_pass: true
        }
        {
          name: sram_ctrl_main.regs
          type: device
          clock: clk_main_i
          reset: rst_main_ni
          pipeline: false
          inst_type: sram_ctrl
          addr_range:
          [
            {
              base_addrs:
              {
                hart: 0x411c0000
              }
              size_byte: 0x40
            }
          ]
          xbar: false
          stub: false
          req_fifo_pass: true
        }
        {
          name: sram_ctrl_main.ram
          type: device
          clock: clk_main_i
          reset: rst_main_ni
          pipeline: false
          inst_type: sram_ctrl
          addr_range:
          [
            {
              base_addrs:
              {
                hart: 0x10000000
              }
              size_byte: 0x20000
            }
          ]
          xbar: false
          stub: false
          req_fifo_pass: true
        }
      ]
      addr_spaces:
      [
        hart
      ]
      clock: clk_main_i
      type: xbar
      inter_signal_list:
      [
        {
          name: tl_rv_core_ibex__corei
          struct: tl
          package: tlul_pkg
          type: req_rsp
          act: rsp
          inst_name: main
          width: 1
          default: ""
          end_idx: -1
          top_type: one-to-one
          top_signame: main_tl_rv_core_ibex__corei
          index: -1
        }
        {
          name: tl_rv_core_ibex__cored
          struct: tl
          package: tlul_pkg
          type: req_rsp
          act: rsp
          inst_name: main
          width: 1
          default: ""
          end_idx: -1
          top_type: one-to-one
          top_signame: main_tl_rv_core_ibex__cored
          index: -1
        }
        {
          name: tl_rom_ctrl__rom
          struct: tl
          package: tlul_pkg
          type: req_rsp
          act: req
          inst_name: main
          width: 1
          default: ""
          domain: Main
          top_signame: rom_ctrl_rom_tl
          index: -1
        }
        {
          name: tl_rom_ctrl__regs
          struct: tl
          package: tlul_pkg
          type: req_rsp
          act: req
          inst_name: main
          width: 1
          default: ""
          domain: Main
          top_signame: rom_ctrl_regs_tl
          index: -1
        }
        {
          name: tl_peri
          struct: tl
          package: tlul_pkg
          type: req_rsp
          act: req
          inst_name: main
          width: 1
          default: ""
          end_idx: -1
          top_type: one-to-one
          top_signame: main_tl_peri
          index: -1
        }
        {
          name: tl_flash_ctrl__core
          struct: tl
          package: tlul_pkg
          type: req_rsp
          act: req
          inst_name: main
          width: 1
          default: ""
          domain: Main
          top_signame: flash_ctrl_core_tl
          index: -1
        }
        {
          name: tl_flash_ctrl__prim
          struct: tl
          package: tlul_pkg
          type: req_rsp
          act: req
          inst_name: main
          width: 1
          default: ""
          domain: Main
          top_signame: flash_ctrl_prim_tl
          index: -1
        }
        {
          name: tl_flash_ctrl__mem
          struct: tl
          package: tlul_pkg
          type: req_rsp
          act: req
          inst_name: main
          width: 1
          default: ""
          domain: Main
          top_signame: flash_ctrl_mem_tl
          index: -1
        }
        {
          name: tl_aes
          struct: tl
          package: tlul_pkg
          type: req_rsp
          act: req
          inst_name: main
          width: 1
          default: ""
          domain: Main
          top_signame: aes_tl
          index: -1
        }
        {
          name: tl_rv_plic
          struct: tl
          package: tlul_pkg
          type: req_rsp
          act: req
          inst_name: main
          width: 1
          default: ""
          domain: Main
          top_signame: rv_plic_tl
          index: -1
        }
        {
          name: tl_rv_core_ibex__cfg
          struct: tl
          package: tlul_pkg
          type: req_rsp
          act: req
          inst_name: main
          width: 1
          default: ""
          domain: Main
          top_signame: rv_core_ibex_cfg_tl_d
          index: -1
        }
        {
          name: tl_sram_ctrl_main__regs
          struct: tl
          package: tlul_pkg
          type: req_rsp
          act: req
          inst_name: main
          width: 1
          default: ""
          domain: Main
          top_signame: sram_ctrl_main_regs_tl
          index: -1
        }
        {
          name: tl_sram_ctrl_main__ram
          struct: tl
          package: tlul_pkg
          type: req_rsp
          act: req
          inst_name: main
          width: 1
          default: ""
          domain: Main
          top_signame: sram_ctrl_main_ram_tl
          index: -1
        }
      ]
    }
    {
      name: peri
      clock_srcs:
      {
        clk_peri_i: io_div4
        clk_spi_host0_i: io
        clk_usb_i: usb
      }
      clock_group: infra
      reset: rst_peri_ni
      reset_connections:
      {
        rst_peri_ni:
        {
          name: sys_io_div4
          domain: Main
        }
        rst_spi_host0_ni:
        {
          name: spi_host0
          domain: Main
        }
        rst_usb_ni:
        {
          name: usb
          domain: Main
        }
      }
      domain: Main
      clock_connections:
      {
        clk_peri_i: clkmgr_clocks_i.clk_io_div4_infra
        clk_spi_host0_i: clkmgr_clocks_i.clk_io_infra
        clk_usb_i: clkmgr_clocks_i.clk_usb_infra
      }
      connections:
      {
        main:
        [
          uart0
          uart1
          gpio0
          spi_device
          spi_host0
          rv_timer
          usbdev
          pwrmgr
          rstmgr
          clkmgr
          pinmux
          ast
        ]
      }
      nodes:
      [
        {
          name: main
          type: host
          addr_space: hart
          clock: clk_peri_i
          reset: rst_peri_ni
          xbar: true
          pipeline: false
          stub: false
          inst_type: ""
          req_fifo_pass: true
          rsp_fifo_pass: true
        }
        {
          name: uart0
          type: device
          clock: clk_peri_i
          reset: rst_peri_ni
          pipeline: false
          inst_type: uart
          addr_range:
          [
            {
              base_addrs:
              {
                hart: 0x40000000
              }
              size_byte: 0x40
            }
          ]
          xbar: false
          stub: false
          req_fifo_pass: true
        }
        {
          name: uart1
          type: device
          clock: clk_peri_i
          reset: rst_peri_ni
          pipeline: false
          inst_type: uart
          addr_range:
          [
            {
              base_addrs:
              {
                hart: 0x40010000
              }
              size_byte: 0x40
            }
          ]
          xbar: false
          stub: false
          req_fifo_pass: true
        }
        {
          name: gpio0
          type: device
          clock: clk_peri_i
          reset: rst_peri_ni
          pipeline: false
          inst_type: gpio
          addr_range:
          [
            {
              base_addrs:
              {
                hart: 0x40040000
              }
              size_byte: 0x80
            }
          ]
          xbar: false
          stub: false
          req_fifo_pass: true
        }
        {
          name: spi_device
          type: device
          clock: clk_peri_i
          reset: rst_peri_ni
          pipeline: false
          inst_type: spi_device
          addr_range:
          [
            {
              base_addrs:
              {
                hart: 0x40050000
              }
              size_byte: 0x2000
            }
          ]
          xbar: false
          stub: false
          req_fifo_pass: true
        }
        {
          name: spi_host0
          type: device
          clock: clk_spi_host0_i
          reset: rst_spi_host0_ni
          pipeline: false
          inst_type: spi_host
          addr_range:
          [
            {
              base_addrs:
              {
                hart: 0x40060000
              }
              size_byte: 0x40
            }
          ]
          xbar: false
          stub: false
          req_fifo_pass: true
        }
        {
          name: rv_timer
          type: device
          clock: clk_peri_i
          reset: rst_peri_ni
          pipeline: false
          inst_type: rv_timer
          addr_range:
          [
            {
              base_addrs:
              {
                hart: 0x40100000
              }
              size_byte: 0x200
            }
          ]
          xbar: false
          stub: false
          req_fifo_pass: true
        }
        {
          name: usbdev
          type: device
          clock: clk_usb_i
          reset: rst_usb_ni
          pipeline: false
          inst_type: usbdev
          addr_range:
          [
            {
              base_addrs:
              {
                hart: 0x40320000
              }
              size_byte: 0x1000
            }
          ]
          xbar: false
          stub: false
          req_fifo_pass: true
        }
        {
          name: pwrmgr
          type: device
          clock: clk_peri_i
          reset: rst_peri_ni
          pipeline: false
          inst_type: pwrmgr
          addr_range:
          [
            {
              base_addrs:
              {
                hart: 0x40400000
              }
              size_byte: 0x80
            }
          ]
          xbar: false
          stub: false
          req_fifo_pass: true
        }
        {
          name: rstmgr
          type: device
          clock: clk_peri_i
          reset: rst_peri_ni
          pipeline: false
          inst_type: rstmgr
          addr_range:
          [
            {
              base_addrs:
              {
                hart: 0x40410000
              }
              size_byte: 0x80
            }
          ]
          xbar: false
          stub: false
          req_fifo_pass: true
        }
        {
          name: clkmgr
          type: device
          clock: clk_peri_i
          reset: rst_peri_ni
          pipeline: false
          inst_type: clkmgr
          addr_range:
          [
            {
              base_addrs:
              {
                hart: 0x40420000
              }
              size_byte: 0x80
            }
          ]
          xbar: false
          stub: false
          req_fifo_pass: true
        }
        {
          name: pinmux
          type: device
          clock: clk_peri_i
          reset: rst_peri_ni
          pipeline: false
          inst_type: pinmux
          addr_range:
          [
            {
              base_addrs:
              {
                hart: 0x40460000
              }
              size_byte: 0x1000
            }
          ]
          xbar: false
          stub: false
          req_fifo_pass: true
        }
        {
          name: ast
          type: device
          clock: clk_peri_i
          reset: rst_peri_ni
          pipeline: false
          inst_type: ast
          addr_range:
          [
            {
              base_addrs:
              {
                hart: 0x40480000
              }
              size_byte: 0x400
            }
          ]
          xbar: false
          stub: true
          req_fifo_pass: true
        }
      ]
      addr_spaces:
      [
        hart
      ]
      clock: clk_peri_i
      type: xbar
      inter_signal_list:
      [
        {
          name: tl_main
          struct: tl
          package: tlul_pkg
          type: req_rsp
          act: rsp
          inst_name: peri
          width: 1
          default: ""
          domain: Main
          top_signame: main_tl_peri
          index: -1
        }
        {
          name: tl_uart0
          struct: tl
          package: tlul_pkg
          type: req_rsp
          act: req
          inst_name: peri
          width: 1
          default: ""
          domain: Main
          top_signame: uart0_tl
          index: -1
        }
        {
          name: tl_uart1
          struct: tl
          package: tlul_pkg
          type: req_rsp
          act: req
          inst_name: peri
          width: 1
          default: ""
          domain: Main
          top_signame: uart1_tl
          index: -1
        }
        {
          name: tl_gpio0
          struct: tl
          package: tlul_pkg
          type: req_rsp
          act: req
          inst_name: peri
          width: 1
          default: ""
          domain: Main
          top_signame: gpio0_tl
          index: -1
        }
        {
          name: tl_spi_device
          struct: tl
          package: tlul_pkg
          type: req_rsp
          act: req
          inst_name: peri
          width: 1
          default: ""
          domain: Main
          top_signame: spi_device_tl
          index: -1
        }
        {
          name: tl_spi_host0
          struct: tl
          package: tlul_pkg
          type: req_rsp
          act: req
          inst_name: peri
          width: 1
          default: ""
          domain: Main
          top_signame: spi_host0_tl
          index: -1
        }
        {
          name: tl_rv_timer
          struct: tl
          package: tlul_pkg
          type: req_rsp
          act: req
          inst_name: peri
          width: 1
          default: ""
          domain: Main
          top_signame: rv_timer_tl
          index: -1
        }
        {
          name: tl_usbdev
          struct: tl
          package: tlul_pkg
          type: req_rsp
          act: req
          inst_name: peri
          width: 1
          default: ""
          domain: Main
          top_signame: usbdev_tl
          index: -1
        }
        {
          name: tl_pwrmgr
          struct: tl
          package: tlul_pkg
          type: req_rsp
          act: req
          inst_name: peri
          width: 1
          default: ""
          domain: Main
          top_signame: pwrmgr_tl
          index: -1
          external: true
          conn_type: false
        }
        {
          name: tl_rstmgr
          struct: tl
          package: tlul_pkg
          type: req_rsp
          act: req
          inst_name: peri
          width: 1
          default: ""
          domain: Main
          top_signame: rstmgr_tl
          index: -1
          external: true
          conn_type: false
        }
        {
          name: tl_clkmgr
          struct: tl
          package: tlul_pkg
          type: req_rsp
          act: req
          inst_name: peri
          width: 1
          default: ""
          domain: Main
          top_signame: clkmgr_tl
          index: -1
          external: true
          conn_type: false
        }
        {
          name: tl_pinmux
          struct: tl
          package: tlul_pkg
          type: req_rsp
          act: req
          inst_name: peri
          width: 1
          default: ""
          domain: Main
          top_signame: pinmux_tl
          index: -1
        }
        {
          name: tl_ast
          struct: tl
          package: tlul_pkg
          type: req_rsp
          act: req
          inst_name: peri
          width: 1
          default: ""
          external: true
          conn_type: false
          index: -1
          top_signame: ast_tl
        }
      ]
    }
  ]
  interrupt_module:
  [
    uart0
    uart1
    gpio0
    spi_device
    spi_host0
    usbdev
    pwrmgr
    aon_timer
    flash_ctrl
  ]
  pinout:
  {
    banks:
    [
      VCC
      AVCC
      VIOA
      VIOB
    ]
    pads:
    [
      {
        name: POR_N
        type: InputStd
        bank: VCC
        connection: manual
        desc: System reset
        idx: 0
        port_type: inout
      }
      {
        name: USB_P
        type: BidirTol
        bank: VCC
        connection: manual
        desc: USB P signal
        idx: 1
        port_type: inout
      }
      {
        name: USB_N
        type: BidirTol
        bank: VCC
        connection: manual
        desc: USB N signal
        idx: 2
        port_type: inout
      }
      {
        name: CC1
        type: InputStd
        bank: AVCC
        connection: manual
        desc: ADC input 1
        idx: 3
        port_type: inout
      }
      {
        name: CC2
        type: InputStd
        bank: AVCC
        connection: manual
        desc: ADC input 2
        idx: 4
        port_type: inout
      }
      {
        name: FLASH_TEST_VOLT
        type: AnalogIn0
        bank: VCC
        connection: manual
        desc: Flash test voltage input
        idx: 5
        port_type: inout
      }
      {
        name: FLASH_TEST_MODE0
        type: InputStd
        bank: VCC
        connection: manual
        desc: Flash test mode signal
        idx: 6
        port_type: inout
      }
      {
        name: FLASH_TEST_MODE1
        type: InputStd
        bank: VCC
        connection: manual
        desc: Flash test mode signal
        idx: 7
        port_type: inout
      }
      {
        name: SPI_HOST_D0
        type: BidirStd
        bank: VIOA
        connection: direct
        desc: SPI host data
        idx: 8
        port_type: inout
      }
      {
        name: SPI_HOST_D1
        type: BidirStd
        bank: VIOA
        connection: direct
        desc: SPI host data
        idx: 9
        port_type: inout
      }
      {
        name: SPI_HOST_D2
        type: BidirStd
        bank: VIOA
        connection: direct
        desc: SPI host data
        idx: 10
        port_type: inout
      }
      {
        name: SPI_HOST_D3
        type: BidirStd
        bank: VIOA
        connection: direct
        desc: SPI host data
        idx: 11
        port_type: inout
      }
      {
        name: SPI_HOST_CLK
        type: BidirStd
        bank: VIOA
        connection: direct
        desc: SPI host clock
        idx: 12
        port_type: inout
      }
      {
        name: SPI_HOST_CS_L
        type: BidirStd
        bank: VIOA
        connection: direct
        desc: SPI host chip select
        idx: 13
        port_type: inout
      }
      {
        name: SPI_DEV_D0
        type: BidirStd
        bank: VIOA
        connection: direct
        desc: SPI device data
        idx: 14
        port_type: inout
      }
      {
        name: SPI_DEV_D1
        type: BidirStd
        bank: VIOA
        connection: direct
        desc: SPI device data
        idx: 15
        port_type: inout
      }
      {
        name: SPI_DEV_D2
        type: BidirStd
        bank: VIOA
        connection: direct
        desc: SPI device data
        idx: 16
        port_type: inout
      }
      {
        name: SPI_DEV_D3
        type: BidirStd
        bank: VIOA
        connection: direct
        desc: SPI device data
        idx: 17
        port_type: inout
      }
      {
        name: SPI_DEV_CLK
        type: InputStd
        bank: VIOA
        connection: direct
        desc: SPI device clock
        idx: 18
        port_type: inout
      }
      {
        name: SPI_DEV_CS_L
        type: InputStd
        bank: VIOA
        connection: direct
        desc: SPI device chip select
        idx: 19
        port_type: inout
      }
      {
        name: IOA0
        type: BidirStd
        bank: VIOA
        connection: muxed
        desc: Muxed IO pad
        idx: 0
        port_type: inout
      }
      {
        name: IOA1
        type: BidirStd
        bank: VIOA
        connection: muxed
        desc: Muxed IO pad
        idx: 1
        port_type: inout
      }
      {
        name: IOA2
        type: BidirStd
        bank: VIOA
        connection: muxed
        desc: Muxed IO pad
        idx: 2
        port_type: inout
      }
      {
        name: IOA3
        type: BidirStd
        bank: VIOA
        connection: muxed
        desc: Muxed IO pad
        idx: 3
        port_type: inout
      }
      {
        name: IOA4
        type: BidirStd
        bank: VIOA
        connection: muxed
        desc: Muxed IO pad
        idx: 4
        port_type: inout
      }
      {
        name: IOA5
        type: BidirStd
        bank: VIOA
        connection: muxed
        desc: Muxed IO pad
        idx: 5
        port_type: inout
      }
      {
        name: IOA6
        type: BidirOd
        bank: VIOA
        connection: muxed
        desc: Muxed IO pad
        idx: 6
        port_type: inout
      }
      {
        name: IOA7
        type: BidirOd
        bank: VIOA
        connection: muxed
        desc: Muxed IO pad
        idx: 7
        port_type: inout
      }
      {
        name: IOA8
        type: BidirOd
        bank: VIOA
        connection: muxed
        desc: Muxed IO pad
        idx: 8
        port_type: inout
      }
      {
        name: IOB0
        type: BidirStd
        bank: VIOB
        connection: muxed
        desc: Muxed IO pad
        idx: 9
        port_type: inout
      }
      {
        name: IOB1
        type: BidirStd
        bank: VIOB
        connection: muxed
        desc: Muxed IO pad
        idx: 10
        port_type: inout
      }
      {
        name: IOB2
        type: BidirStd
        bank: VIOB
        connection: muxed
        desc: Muxed IO pad
        idx: 11
        port_type: inout
      }
      {
        name: IOB3
        type: BidirStd
        bank: VIOB
        connection: muxed
        desc: Muxed IO pad
        idx: 12
        port_type: inout
      }
      {
        name: IOB4
        type: BidirStd
        bank: VIOB
        connection: muxed
        desc: Muxed IO pad
        idx: 13
        port_type: inout
      }
      {
        name: IOB5
        type: BidirStd
        bank: VIOB
        connection: muxed
        desc: Muxed IO pad
        idx: 14
        port_type: inout
      }
      {
        name: IOB6
        type: BidirStd
        bank: VIOB
        connection: muxed
        desc: Muxed IO pad
        idx: 15
        port_type: inout
      }
      {
        name: IOB7
        type: BidirStd
        bank: VIOB
        connection: muxed
        desc: Muxed IO pad
        idx: 16
        port_type: inout
      }
      {
        name: IOB8
        type: BidirStd
        bank: VIOB
        connection: muxed
        desc: Muxed IO pad
        idx: 17
        port_type: inout
      }
      {
        name: IOB9
        type: BidirOd
        bank: VIOB
        connection: muxed
        desc: Muxed IO pad
        idx: 18
        port_type: inout
      }
      {
        name: IOB10
        type: BidirOd
        bank: VIOB
        connection: muxed
        desc: Muxed IO pad
        idx: 19
        port_type: inout
      }
      {
        name: IOB11
        type: BidirOd
        bank: VIOB
        connection: muxed
        desc: Muxed IO pad
        idx: 20
        port_type: inout
      }
      {
        name: IOB12
        type: BidirOd
        bank: VIOB
        connection: muxed
        desc: Muxed IO pad
        idx: 21
        port_type: inout
      }
      {
        name: IOC0
        type: BidirStd
        bank: VCC
        connection: muxed
        desc: Muxed IO pad
        idx: 22
        port_type: inout
      }
      {
        name: IOC1
        type: BidirStd
        bank: VCC
        connection: muxed
        desc: Muxed IO pad
        idx: 23
        port_type: inout
      }
      {
        name: IOC2
        type: BidirStd
        bank: VCC
        connection: muxed
        desc: Muxed IO pad
        idx: 24
        port_type: inout
      }
      {
        name: IOC3
        type: BidirStd
        bank: VCC
        connection: muxed
        desc: Muxed IO pad
        idx: 25
        port_type: inout
      }
      {
        name: IOC4
        type: BidirStd
        bank: VCC
        connection: muxed
        desc: Muxed IO pad
        idx: 26
        port_type: inout
      }
      {
        name: IOC5
        type: BidirStd
        bank: VCC
        connection: muxed
        desc: Muxed IO pad
        idx: 27
        port_type: inout
      }
      {
        name: IOC6
        type: BidirStd
        bank: VCC
        connection: muxed
        desc: Muxed IO pad
        idx: 28
        port_type: inout
      }
      {
        name: IOC7
        type: BidirStd
        bank: VCC
        connection: muxed
        desc: Muxed IO pad
        idx: 29
        port_type: inout
      }
      {
        name: IOC8
        type: BidirStd
        bank: VCC
        connection: muxed
        desc: Muxed IO pad
        attrs:
        {
          pull_en: 1
        }
        idx: 30
        port_type: inout
      }
      {
        name: IOC9
        type: BidirStd
        bank: VCC
        connection: muxed
        desc: Muxed IO pad
        idx: 31
        port_type: inout
      }
      {
        name: IOC10
        type: BidirOd
        bank: VCC
        connection: muxed
        desc: Muxed IO pad
        idx: 32
        port_type: inout
      }
      {
        name: IOC11
        type: BidirOd
        bank: VCC
        connection: muxed
        desc: Muxed IO pad
        idx: 33
        port_type: inout
      }
      {
        name: IOC12
        type: BidirOd
        bank: VCC
        connection: muxed
        desc: Muxed IO pad
        idx: 34
        port_type: inout
      }
      {
        name: IOR0
        type: BidirStd
        bank: VCC
        connection: muxed
        desc: Muxed IO pad
        idx: 35
        port_type: inout
      }
      {
        name: IOR1
        type: BidirStd
        bank: VCC
        connection: muxed
        desc: Muxed IO pad
        idx: 36
        port_type: inout
      }
      {
        name: IOR2
        type: BidirStd
        bank: VCC
        connection: muxed
        desc: Muxed IO pad
        idx: 37
        port_type: inout
      }
      {
        name: IOR3
        type: BidirStd
        bank: VCC
        connection: muxed
        desc: Muxed IO pad
        idx: 38
        port_type: inout
      }
      {
        name: IOR4
        type: BidirStd
        bank: VCC
        connection: muxed
        desc: Muxed IO pad
        idx: 39
        port_type: inout
      }
      {
        name: IOR5
        type: BidirStd
        bank: VCC
        connection: muxed
        desc: Muxed IO pad
        idx: 40
        port_type: inout
      }
      {
        name: IOR6
        type: BidirStd
        bank: VCC
        connection: muxed
        desc: Muxed IO pad
        idx: 41
        port_type: inout
      }
      {
        name: IOR7
        type: BidirStd
        bank: VCC
        connection: muxed
        desc: Muxed IO pad
        idx: 42
        port_type: inout
      }
      {
        name: IOR10
        type: BidirOd
        bank: VCC
        connection: muxed
        desc: Muxed IO pad
        idx: 43
        port_type: inout
      }
      {
        name: IOR11
        type: BidirOd
        bank: VCC
        connection: muxed
        desc: Muxed IO pad
        idx: 44
        port_type: inout
      }
      {
        name: IOR12
        type: BidirOd
        bank: VCC
        connection: muxed
        desc: Muxed IO pad
        idx: 45
        port_type: inout
      }
      {
        name: IOR13
        type: BidirOd
        bank: VCC
        connection: muxed
        desc: Muxed IO pad
        idx: 46
        port_type: inout
      }
    ]
  }
  pinmux:
  {
    signals:
    [
      {
        instance: spi_host0
        port: sck
        connection: direct
        pads:
        [
          SPI_HOST_CLK
        ]
        desc: ""
        attr: BidirStd
      }
      {
        instance: spi_host0
        port: csb
        connection: direct
        pads:
        [
          SPI_HOST_CS_L
        ]
        desc: ""
        attr: BidirStd
      }
      {
        instance: spi_host0
        port: sd[0]
        connection: direct
        pads:
        [
          SPI_HOST_D0
        ]
        desc: ""
        attr: BidirStd
      }
      {
        instance: spi_host0
        port: sd[1]
        connection: direct
        pads:
        [
          SPI_HOST_D1
        ]
        desc: ""
        attr: BidirStd
      }
      {
        instance: spi_host0
        port: sd[2]
        connection: direct
        pads:
        [
          SPI_HOST_D2
        ]
        desc: ""
        attr: BidirStd
      }
      {
        instance: spi_host0
        port: sd[3]
        connection: direct
        pads:
        [
          SPI_HOST_D3
        ]
        desc: ""
        attr: BidirStd
      }
      {
        instance: spi_device
        port: sck
        connection: direct
        pads:
        [
          SPI_DEV_CLK
        ]
        desc: ""
        attr: InputStd
      }
      {
        instance: spi_device
        port: csb
        connection: direct
        pads:
        [
          SPI_DEV_CS_L
        ]
        desc: ""
        attr: InputStd
      }
      {
        instance: spi_device
        port: sd[0]
        connection: direct
        pads:
        [
          SPI_DEV_D0
        ]
        desc: ""
        attr: BidirStd
      }
      {
        instance: spi_device
        port: sd[1]
        connection: direct
        pads:
        [
          SPI_DEV_D1
        ]
        desc: ""
        attr: BidirStd
      }
      {
        instance: spi_device
        port: sd[2]
        connection: direct
        pads:
        [
          SPI_DEV_D2
        ]
        desc: ""
        attr: BidirStd
      }
      {
        instance: spi_device
        port: sd[3]
        connection: direct
        pads:
        [
          SPI_DEV_D3
        ]
        desc: ""
        attr: BidirStd
      }
      {
        instance: usbdev
        port: usb_dp
        connection: manual
        pads: []
        desc: ""
        attr: BidirStd
      }
      {
        instance: usbdev
        port: usb_dn
        connection: manual
        pads: []
        desc: ""
        attr: BidirStd
      }
      {
        instance: gpio0
        port: ""
        connection: muxed
        pads: []
        desc: ""
        attr: ""
      }
      {
        instance: uart0
        port: ""
        connection: muxed
        pads: []
        desc: ""
        attr: ""
      }
      {
        instance: uart1
        port: ""
        connection: muxed
        pads: []
        desc: ""
        attr: ""
      }
      {
        instance: flash_ctrl
        port: ""
        connection: muxed
        pads: []
        desc: ""
        attr: ""
      }
      {
        instance: usbdev
        port: sense
        connection: muxed
        pads: []
        desc: ""
        attr: ""
      }
    ]
    num_wkup_detect: 8
    wkup_cnt_width: 8
    enable_usb_wakeup: true
    enable_strap_sampling: true
    ios:
    [
      {
        name: spi_host0_sd
        width: 4
        type: inout
        idx: 0
        pads:
        [
          SPI_HOST_D0
        ]
        attr: BidirStd
        connection: direct
        desc: ""
        domain: Main
        glob_idx: 0
      }
      {
        name: spi_host0_sd
        width: 4
        type: inout
        idx: 1
        pads:
        [
          SPI_HOST_D1
        ]
        attr: BidirStd
        connection: direct
        desc: ""
        domain: Main
        glob_idx: 1
      }
      {
        name: spi_host0_sd
        width: 4
        type: inout
        idx: 2
        pads:
        [
          SPI_HOST_D2
        ]
        attr: BidirStd
        connection: direct
        desc: ""
        domain: Main
        glob_idx: 2
      }
      {
        name: spi_host0_sd
        width: 4
        type: inout
        idx: 3
        pads:
        [
          SPI_HOST_D3
        ]
        attr: BidirStd
        connection: direct
        desc: ""
        domain: Main
        glob_idx: 3
      }
      {
        name: spi_device_sd
        width: 4
        type: inout
        idx: 0
        pads:
        [
          SPI_DEV_D0
        ]
        attr: BidirStd
        connection: direct
        desc: ""
        domain: Main
        glob_idx: 4
      }
      {
        name: spi_device_sd
        width: 4
        type: inout
        idx: 1
        pads:
        [
          SPI_DEV_D1
        ]
        attr: BidirStd
        connection: direct
        desc: ""
        domain: Main
        glob_idx: 5
      }
      {
        name: spi_device_sd
        width: 4
        type: inout
        idx: 2
        pads:
        [
          SPI_DEV_D2
        ]
        attr: BidirStd
        connection: direct
        desc: ""
        domain: Main
        glob_idx: 6
      }
      {
        name: spi_device_sd
        width: 4
        type: inout
        idx: 3
        pads:
        [
          SPI_DEV_D3
        ]
        attr: BidirStd
        connection: direct
        desc: ""
        domain: Main
        glob_idx: 7
      }
      {
        name: usbdev_usb_dp
        width: 1
        type: inout
        idx: -1
        pads: []
        attr: BidirStd
        connection: manual
        desc: ""
        domain: Main
        glob_idx: 8
      }
      {
        name: usbdev_usb_dn
        width: 1
        type: inout
        idx: -1
        pads: []
        attr: BidirStd
        connection: manual
        desc: ""
        domain: Main
        glob_idx: 9
      }
      {
        name: gpio0_gpio
        width: 32
        type: inout
        idx: 0
        pads: []
        attr: ""
        connection: muxed
        desc: ""
        domain: Main
        glob_idx: 0
      }
      {
        name: gpio0_gpio
        width: 32
        type: inout
        idx: 1
        pads: []
        attr: ""
        connection: muxed
        desc: ""
        domain: Main
        glob_idx: 1
      }
      {
        name: gpio0_gpio
        width: 32
        type: inout
        idx: 2
        pads: []
        attr: ""
        connection: muxed
        desc: ""
        domain: Main
        glob_idx: 2
      }
      {
        name: gpio0_gpio
        width: 32
        type: inout
        idx: 3
        pads: []
        attr: ""
        connection: muxed
        desc: ""
        domain: Main
        glob_idx: 3
      }
      {
        name: gpio0_gpio
        width: 32
        type: inout
        idx: 4
        pads: []
        attr: ""
        connection: muxed
        desc: ""
        domain: Main
        glob_idx: 4
      }
      {
        name: gpio0_gpio
        width: 32
        type: inout
        idx: 5
        pads: []
        attr: ""
        connection: muxed
        desc: ""
        domain: Main
        glob_idx: 5
      }
      {
        name: gpio0_gpio
        width: 32
        type: inout
        idx: 6
        pads: []
        attr: ""
        connection: muxed
        desc: ""
        domain: Main
        glob_idx: 6
      }
      {
        name: gpio0_gpio
        width: 32
        type: inout
        idx: 7
        pads: []
        attr: ""
        connection: muxed
        desc: ""
        domain: Main
        glob_idx: 7
      }
      {
        name: gpio0_gpio
        width: 32
        type: inout
        idx: 8
        pads: []
        attr: ""
        connection: muxed
        desc: ""
        domain: Main
        glob_idx: 8
      }
      {
        name: gpio0_gpio
        width: 32
        type: inout
        idx: 9
        pads: []
        attr: ""
        connection: muxed
        desc: ""
        domain: Main
        glob_idx: 9
      }
      {
        name: gpio0_gpio
        width: 32
        type: inout
        idx: 10
        pads: []
        attr: ""
        connection: muxed
        desc: ""
        domain: Main
        glob_idx: 10
      }
      {
        name: gpio0_gpio
        width: 32
        type: inout
        idx: 11
        pads: []
        attr: ""
        connection: muxed
        desc: ""
        domain: Main
        glob_idx: 11
      }
      {
        name: gpio0_gpio
        width: 32
        type: inout
        idx: 12
        pads: []
        attr: ""
        connection: muxed
        desc: ""
        domain: Main
        glob_idx: 12
      }
      {
        name: gpio0_gpio
        width: 32
        type: inout
        idx: 13
        pads: []
        attr: ""
        connection: muxed
        desc: ""
        domain: Main
        glob_idx: 13
      }
      {
        name: gpio0_gpio
        width: 32
        type: inout
        idx: 14
        pads: []
        attr: ""
        connection: muxed
        desc: ""
        domain: Main
        glob_idx: 14
      }
      {
        name: gpio0_gpio
        width: 32
        type: inout
        idx: 15
        pads: []
        attr: ""
        connection: muxed
        desc: ""
        domain: Main
        glob_idx: 15
      }
      {
        name: gpio0_gpio
        width: 32
        type: inout
        idx: 16
        pads: []
        attr: ""
        connection: muxed
        desc: ""
        domain: Main
        glob_idx: 16
      }
      {
        name: gpio0_gpio
        width: 32
        type: inout
        idx: 17
        pads: []
        attr: ""
        connection: muxed
        desc: ""
        domain: Main
        glob_idx: 17
      }
      {
        name: gpio0_gpio
        width: 32
        type: inout
        idx: 18
        pads: []
        attr: ""
        connection: muxed
        desc: ""
        domain: Main
        glob_idx: 18
      }
      {
        name: gpio0_gpio
        width: 32
        type: inout
        idx: 19
        pads: []
        attr: ""
        connection: muxed
        desc: ""
        domain: Main
        glob_idx: 19
      }
      {
        name: gpio0_gpio
        width: 32
        type: inout
        idx: 20
        pads: []
        attr: ""
        connection: muxed
        desc: ""
        domain: Main
        glob_idx: 20
      }
      {
        name: gpio0_gpio
        width: 32
        type: inout
        idx: 21
        pads: []
        attr: ""
        connection: muxed
        desc: ""
        domain: Main
        glob_idx: 21
      }
      {
        name: gpio0_gpio
        width: 32
        type: inout
        idx: 22
        pads: []
        attr: ""
        connection: muxed
        desc: ""
        domain: Main
        glob_idx: 22
      }
      {
        name: gpio0_gpio
        width: 32
        type: inout
        idx: 23
        pads: []
        attr: ""
        connection: muxed
        desc: ""
        domain: Main
        glob_idx: 23
      }
      {
        name: gpio0_gpio
        width: 32
        type: inout
        idx: 24
        pads: []
        attr: ""
        connection: muxed
        desc: ""
        domain: Main
        glob_idx: 24
      }
      {
        name: gpio0_gpio
        width: 32
        type: inout
        idx: 25
        pads: []
        attr: ""
        connection: muxed
        desc: ""
        domain: Main
        glob_idx: 25
      }
      {
        name: gpio0_gpio
        width: 32
        type: inout
        idx: 26
        pads: []
        attr: ""
        connection: muxed
        desc: ""
        domain: Main
        glob_idx: 26
      }
      {
        name: gpio0_gpio
        width: 32
        type: inout
        idx: 27
        pads: []
        attr: ""
        connection: muxed
        desc: ""
        domain: Main
        glob_idx: 27
      }
      {
        name: gpio0_gpio
        width: 32
        type: inout
        idx: 28
        pads: []
        attr: ""
        connection: muxed
        desc: ""
        domain: Main
        glob_idx: 28
      }
      {
        name: gpio0_gpio
        width: 32
        type: inout
        idx: 29
        pads: []
        attr: ""
        connection: muxed
        desc: ""
        domain: Main
        glob_idx: 29
      }
      {
        name: gpio0_gpio
        width: 32
        type: inout
        idx: 30
        pads: []
        attr: ""
        connection: muxed
        desc: ""
        domain: Main
        glob_idx: 30
      }
      {
        name: gpio0_gpio
        width: 32
        type: inout
        idx: 31
        pads: []
        attr: ""
        connection: muxed
        desc: ""
        domain: Main
        glob_idx: 31
      }
      {
        name: spi_device_sck
        width: 1
        type: input
        idx: -1
        pads:
        [
          SPI_DEV_CLK
        ]
        attr: InputStd
        connection: direct
        desc: ""
        domain: Main
        glob_idx: 10
      }
      {
        name: spi_device_csb
        width: 1
        type: input
        idx: -1
        pads:
        [
          SPI_DEV_CS_L
        ]
        attr: InputStd
        connection: direct
        desc: ""
        domain: Main
        glob_idx: 11
      }
      {
        name: uart0_rx
        width: 1
        type: input
        idx: -1
        pads: []
        attr: ""
        connection: muxed
        desc: ""
        domain: Main
        glob_idx: 32
      }
      {
        name: uart1_rx
        width: 1
        type: input
        idx: -1
        pads: []
        attr: ""
        connection: muxed
        desc: ""
        domain: Main
        glob_idx: 33
      }
      {
        name: flash_ctrl_tck
        width: 1
        type: input
        idx: -1
        pads: []
        attr: ""
        connection: muxed
        desc: ""
        domain: Main
        glob_idx: 34
      }
      {
        name: flash_ctrl_tms
        width: 1
        type: input
        idx: -1
        pads: []
        attr: ""
        connection: muxed
        desc: ""
        domain: Main
        glob_idx: 35
      }
      {
        name: flash_ctrl_tdi
        width: 1
        type: input
        idx: -1
        pads: []
        attr: ""
        connection: muxed
        desc: ""
        domain: Main
        glob_idx: 36
      }
      {
        name: usbdev_sense
        width: 1
        type: input
        idx: -1
        pads: []
        attr: ""
        connection: muxed
        desc: ""
        domain: Main
        glob_idx: 37
      }
      {
        name: spi_host0_sck
        width: 1
        type: output
        idx: -1
        pads:
        [
          SPI_HOST_CLK
        ]
        attr: BidirStd
        connection: direct
        desc: ""
        domain: Main
        glob_idx: 12
      }
      {
        name: spi_host0_csb
        width: 1
        type: output
        idx: -1
        pads:
        [
          SPI_HOST_CS_L
        ]
        attr: BidirStd
        connection: direct
        desc: ""
        domain: Main
        glob_idx: 13
      }
      {
        name: uart0_tx
        width: 1
        type: output
        idx: -1
        pads: []
        attr: ""
        connection: muxed
        desc: ""
        domain: Main
        glob_idx: 32
      }
      {
        name: uart1_tx
        width: 1
        type: output
        idx: -1
        pads: []
        attr: ""
        connection: muxed
        desc: ""
        domain: Main
        glob_idx: 33
      }
      {
        name: flash_ctrl_tdo
        width: 1
        type: output
        idx: -1
        pads: []
        attr: ""
        connection: muxed
        desc: ""
        domain: Main
        glob_idx: 34
      }
    ]
    io_counts:
    {
      dedicated:
      {
        inouts: 10
        inputs: 2
        outputs: 2
        pads: 20
      }
      muxed:
      {
        inouts: 32
        inputs: 6
        outputs: 3
        pads: 47
      }
    }
  }
  targets:
  [
    {
      name: cw305
      chiplevel:
      {
        port_overrides:
        {
          pinmux.dft_hold_tap_sel:
          {
            unused: true
          }
          pinmux.dft_strap_test:
          {
            unused: true
          }
          pinmux.usb_dppullup_en:
          {
            signal: usb_dp_pullup_en
          }
          pinmux.usb_dnpullup_en:
          {
            signal: usb_dn_pullup_en
          }
          clkmgr.cg_en:
          {
            unused: true
          }
          rstmgr.resets_secondary:
          {
            unused: true
          }
          rstmgr.rst_en:
          {
            unused: true
          }
          usbdev.usb_tx_d:
          {
            unused: true
          }
          usbdev.usb_tx_se0:
          {
            unused: true
          }
          usbdev.usb_tx_use_d_se0:
          {
            unused: true
          }
          usbdev.usb_rx_d:
          {
            unused: true
          }
          usbdev.usb_rx_enable:
          {
            unused: true
          }
          usbdev.usb_ref_val:
          {
            signal: usb_ref_val
          }
          usbdev.usb_ref_pulse:
          {
            signal: usb_ref_pulse
          }
          flash_ctrl.flash_power_down_h:
          {
            unused: true
          }
          flash_ctrl.flash_power_ready_h:
          {
            unused: true
            tie_value: 1'b1
          }
        }
      }
      pinout:
      {
        remove_ports: []
        remove_pads:
        [
          CC1
          CC2
          SPI_DEV_D2
          SPI_DEV_D3
          SPI_HOST_CLK
          SPI_HOST_CS_L
          SPI_HOST_D0
          SPI_HOST_D1
          SPI_HOST_D2
          SPI_HOST_D3
          FLASH_TEST_VOLT
          FLASH_TEST_MODE0
          FLASH_TEST_MODE1
          IOB7
          IOB8
          IOB9
          IOB10
          IOB11
          IOB12
          IOC6
          IOC7
          IOC9
          IOC10
          IOC11
          IOC12
          IOR0
          IOR1
          IOR2
          IOR3
          IOR5
          IOR6
          IOR7
          IOR10
          IOR11
          IOR12
          IOR13
        ]
        add_pads:
        [
          {
            name: IO_CLK
            type: InputStd
            bank: VCC
            connection: manual
            desc: Extra clock input for FPGA target
            port_type: inout
          }
          {
            name: POR_BUTTON_N
            type: InputStd
            bank: VCC
            connection: manual
            desc: POR from the push-button
            port_type: inout
          }
          {
            name: IO_USB_SENSE0
            type: BidirStd
            bank: VCC
            connection: manual
            desc: Manual USB signal for FPGA target
            port_type: inout
          }
          {
            name: IO_USB_DNPULLUP0
            type: BidirStd
            bank: VCC
            connection: manual
            desc: Manual USB signal for FPGA target
            port_type: inout
          }
          {
            name: IO_USB_DPPULLUP0
            type: BidirStd
            bank: VCC
            connection: manual
            desc: Manual USB signal for FPGA target
            port_type: inout
          }
          {
            name: IO_CLKOUT
            type: BidirStd
            bank: VCC
            connection: manual
            desc: Manual clock output for SCA setup
            port_type: inout
          }
          {
            name: IO_TRIGGER
            type: BidirStd
            bank: VCC
            connection: manual
            desc: Manual trigger output for SCA setup
            port_type: inout
          }
        ]
      }
      pinmux:
      {
        special_signals:
        [
          {
            name: tap0
            pad: IOC8
            desc: TAP strap signal.
            idx: 30
          }
          {
            name: tap1
            pad: IOC5
            desc: TAP strap signal.
            idx: 27
          }
          {
            name: dft0
            pad: IOR5
            desc: DFT strap signal.
            idx: 40
          }
          {
            name: dft1
            pad: IOR7
            desc: DFT strap signal.
            idx: 42
          }
          {
            name: tck
            pad: SPI_DEV_CLK
            desc: JTAG tck signal, overlaid on SPI_DEV.
            idx: 57
          }
          {
            name: tms
            pad: SPI_DEV_CS_L
            desc: JTAG tms signal, overlaid on SPI_DEV.
            idx: 58
          }
          {
            name: trst_n
            pad: IOR4
            desc: JTAG trst_n signal.
            idx: 39
          }
          {
            name: tdi
            pad: SPI_DEV_D0
            desc: JTAG tdi signal, overlaid on SPI_DEV.
            idx: 51
          }
          {
            name: tdo
            pad: SPI_DEV_D1
            desc: JTAG tdo signal, overlaid on SPI_DEV.
            idx: 52
          }
        ]
      }
    }
    {
      name: verilator
      chiplevel:
      {
        port_overrides:
        {
          pinmux.dft_hold_tap_sel:
          {
            unused: true
          }
          pinmux.usb_dppullup_en:
          {
            signal: usb_dp_pullup_en
          }
          pinmux.usb_dnpullup_en:
          {
            signal: usb_dn_pullup_en
          }
          clkmgr.cg_en:
          {
            unused: true
          }
          rstmgr.resets_secondary:
          {
            unused: true
          }
          rstmgr.rst_en:
          {
            unused: true
          }
          usbdev.usb_rx_d:
          {
            signal: usb_rx_d
          }
          usbdev.usb_rx_enable:
          {
            signal: usb_rx_enable
          }
          usbdev.usb_tx_d:
          {
            signal: usb_tx_d
          }
          usbdev.usb_tx_se0:
          {
            signal: usb_tx_se0
          }
          usbdev.usb_tx_use_d_se0:
          {
            signal: usb_tx_use_d_se0
          }
          usbdev.usb_ref_val:
          {
            signal: usb_ref_val
          }
          usbdev.usb_ref_pulse:
          {
            signal: usb_ref_pulse
          }
        }
      }
      pinout:
      {
        remove_ports: []
        remove_pads: []
        add_pads: []
      }
      pinmux:
      {
        special_signals:
        [
          {
            name: tap0
            pad: IOC8
            desc: TAP strap signal.
            idx: 30
          }
          {
            name: tap1
            pad: IOC5
            desc: TAP strap signal.
            idx: 27
          }
          {
            name: dft0
            pad: IOR5
            desc: DFT strap signal.
            idx: 40
          }
          {
            name: dft1
            pad: IOR7
            desc: DFT strap signal.
            idx: 42
          }
          {
            name: tck
            pad: SPI_DEV_CLK
            desc: JTAG tck signal, overlaid on SPI_DEV.
            idx: 57
          }
          {
            name: tms
            pad: SPI_DEV_CS_L
            desc: JTAG tms signal, overlaid on SPI_DEV.
            idx: 58
          }
          {
            name: trst_n
            pad: IOR4
            desc: JTAG trst_n signal.
            idx: 39
          }
          {
            name: tdi
            pad: SPI_DEV_D0
            desc: JTAG tdi signal, overlaid on SPI_DEV.
            idx: 51
          }
          {
            name: tdo
            pad: SPI_DEV_D1
            desc: JTAG tdo signal, overlaid on SPI_DEV.
            idx: 52
          }
        ]
      }
    }
  ]
  incoming_alert: {}
  incoming_interrupt: {}
  exported_clks: {}
  wakeups:
  [
    {
      name: pin_wkup_req
      width: "1"
      module: pinmux
    }
    {
      name: usb_wkup_req
      width: "1"
      module: pinmux
    }
    {
      name: wkup_req
      width: "1"
      module: aon_timer
    }
  ]
  exported_rsts: {}
  alert: []
  outgoing_alert:
  {
    englishbreakfast:
    [
      {
        name: uart0_fatal_fault
        width: 1
        type: alert
        async: "1"
        handler: null
        module_name: uart0
        desc: uart0 fatal_fault alert
        lpg_name: peri_lc_io_div4_Main
        lpg_idx: 0
      }
      {
        name: uart1_fatal_fault
        width: 1
        type: alert
        async: "1"
        handler: null
        module_name: uart1
        desc: uart1 fatal_fault alert
        lpg_name: peri_lc_io_div4_Main
        lpg_idx: 0
      }
      {
        name: gpio0_fatal_fault
        width: 1
        type: alert
        async: "1"
        handler: null
        module_name: gpio0
        desc: gpio0 fatal_fault alert
        lpg_name: peri_sys_io_div4_Main
        lpg_idx: 1
      }
      {
        name: spi_device_fatal_fault
        width: 1
        type: alert
        async: "1"
        handler: null
        module_name: spi_device
        desc: spi_device fatal_fault alert
        lpg_name: peri_spi_device_Main
        lpg_idx: 2
      }
      {
        name: spi_host0_fatal_fault
        width: 1
        type: alert
        async: "1"
        handler: null
        module_name: spi_host0
        desc: spi_host0 fatal_fault alert
        lpg_name: peri_spi_host0_Main
        lpg_idx: 3
      }
      {
        name: rv_timer_fatal_fault
        width: 1
        type: alert
        async: "1"
        handler: null
        module_name: rv_timer
        desc: rv_timer fatal_fault alert
        lpg_name: timers_sys_io_div4_Main
        lpg_idx: 4
      }
      {
        name: usbdev_fatal_fault
        width: 1
        type: alert
        async: "1"
        handler: null
        module_name: usbdev
        desc: usbdev fatal_fault alert
        lpg_name: peri_usb_Main
        lpg_idx: 5
      }
      {
        name: pwrmgr_fatal_fault
        width: 1
        type: alert
        async: "1"
        handler: null
        module_name: pwrmgr
        desc: pwrmgr fatal_fault alert
        lpg_name: powerup_por_io_div4_Aon
        lpg_idx: 6
      }
      {
        name: rstmgr_fatal_fault
        width: 1
        type: alert
        async: "1"
        handler: null
        module_name: rstmgr
        desc: rstmgr fatal_fault alert
        lpg_name: powerup_lc_io_div4_Main
        lpg_idx: 7
      }
      {
        name: rstmgr_fatal_cnsty_fault
        width: 1
        type: alert
        async: "1"
        handler: null
        module_name: rstmgr
        desc: rstmgr fatal_cnsty_fault alert
        lpg_name: powerup_lc_io_div4_Main
        lpg_idx: 7
      }
      {
        name: clkmgr_recov_fault
        width: 1
        type: alert
        async: "1"
        handler: null
        module_name: clkmgr
        desc: clkmgr recov_fault alert
        lpg_name: powerup_por_io_div4_Main
        lpg_idx: 9
      }
      {
        name: clkmgr_fatal_fault
        width: 1
        type: alert
        async: "1"
        handler: null
        module_name: clkmgr
        desc: clkmgr fatal_fault alert
        lpg_name: powerup_por_io_div4_Main
        lpg_idx: 9
      }
      {
        name: pinmux_fatal_fault
        width: 1
        type: alert
        async: "1"
        handler: null
        module_name: pinmux
        desc: pinmux fatal_fault alert
        lpg_name: powerup_lc_io_div4_Main
        lpg_idx: 7
      }
      {
        name: aon_timer_fatal_fault
        width: 1
        type: alert
        async: "1"
        handler: null
        module_name: aon_timer
        desc: aon_timer fatal_fault alert
        lpg_name: timers_sys_io_div4_Aon
        lpg_idx: 10
      }
      {
        name: flash_ctrl_recov_err
        width: 1
        type: alert
        async: "1"
        handler: null
        module_name: flash_ctrl
        desc: flash_ctrl recov_err alert
        lpg_name: infra_lc_Main
        lpg_idx: 11
      }
      {
        name: flash_ctrl_fatal_std_err
        width: 1
        type: alert
        async: "1"
        handler: null
        module_name: flash_ctrl
        desc: flash_ctrl fatal_std_err alert
        lpg_name: infra_lc_Main
        lpg_idx: 11
      }
      {
        name: flash_ctrl_fatal_err
        width: 1
        type: alert
        async: "1"
        handler: null
        module_name: flash_ctrl
        desc: flash_ctrl fatal_err alert
        lpg_name: infra_lc_Main
        lpg_idx: 11
      }
      {
        name: flash_ctrl_fatal_prim_flash_alert
        width: 1
        type: alert
        async: "1"
        handler: null
        module_name: flash_ctrl
        desc: flash_ctrl fatal_prim_flash_alert alert
        lpg_name: infra_lc_Main
        lpg_idx: 11
      }
      {
        name: flash_ctrl_recov_prim_flash_alert
        width: 1
        type: alert
        async: "1"
        handler: null
        module_name: flash_ctrl
        desc: flash_ctrl recov_prim_flash_alert alert
        lpg_name: infra_lc_Main
        lpg_idx: 11
      }
      {
        name: rv_plic_fatal_fault
        width: 1
        type: alert
        async: "1"
        handler: null
        module_name: rv_plic
        desc: rv_plic fatal_fault alert
        lpg_name: secure_sys_Main
        lpg_idx: 12
      }
      {
        name: aes_recov_ctrl_update_err
        width: 1
        type: alert
        async: "1"
        handler: null
        module_name: aes
        desc: aes recov_ctrl_update_err alert
        lpg_name: aes_trans_sys_Main
        lpg_idx: 13
      }
      {
        name: aes_fatal_fault
        width: 1
        type: alert
        async: "1"
        handler: null
        module_name: aes
        desc: aes fatal_fault alert
        lpg_name: aes_trans_sys_Main
        lpg_idx: 13
      }
      {
        name: sram_ctrl_main_fatal_error
        width: 1
        type: alert
        async: "1"
        handler: null
        module_name: sram_ctrl_main
        desc: sram_ctrl_main fatal_error alert
        lpg_name: secure_sys_Main
        lpg_idx: 12
      }
      {
        name: rom_ctrl_fatal
        width: 1
        type: alert
        async: "1"
        handler: null
        module_name: rom_ctrl
        desc: rom_ctrl fatal alert
        lpg_name: infra_sys_Main
        lpg_idx: 14
      }
      {
        name: rv_core_ibex_fatal_sw_err
        width: 1
        type: alert
        async: "1"
        handler: null
        module_name: rv_core_ibex
        desc: rv_core_ibex fatal_sw_err alert
        lpg_name: infra_sys_Main
        lpg_idx: 14
      }
      {
        name: rv_core_ibex_recov_sw_err
        width: 1
        type: alert
        async: "1"
        handler: null
        module_name: rv_core_ibex
        desc: rv_core_ibex recov_sw_err alert
        lpg_name: infra_sys_Main
        lpg_idx: 14
      }
      {
        name: rv_core_ibex_fatal_hw_err
        width: 1
        type: alert
        async: "1"
        handler: null
        module_name: rv_core_ibex
        desc: rv_core_ibex fatal_hw_err alert
        lpg_name: infra_sys_Main
        lpg_idx: 14
      }
      {
        name: rv_core_ibex_recov_hw_err
        width: 1
        type: alert
        async: "1"
        handler: null
        module_name: rv_core_ibex
        desc: rv_core_ibex recov_hw_err alert
        lpg_name: infra_sys_Main
        lpg_idx: 14
      }
    ]
  }
  interrupt:
  [
    {
      name: uart0_tx_watermark
      width: 1
      type: interrupt
      module_name: uart0
      desc: uart0 tx_watermark interrupt
      intr_type: IntrType.Status
      default_val: true
      incoming: false
      domain: Main
      plic: rv_plic
      outgoing: false
    }
    {
      name: uart0_rx_watermark
      width: 1
      type: interrupt
      module_name: uart0
      desc: uart0 rx_watermark interrupt
      intr_type: IntrType.Status
      default_val: false
      incoming: false
      domain: Main
      plic: rv_plic
      outgoing: false
    }
    {
      name: uart0_tx_done
      width: 1
      type: interrupt
      module_name: uart0
      desc: uart0 tx_done interrupt
      intr_type: IntrType.Event
      default_val: false
      incoming: false
      domain: Main
      plic: rv_plic
      outgoing: false
    }
    {
      name: uart0_rx_overflow
      width: 1
      type: interrupt
      module_name: uart0
      desc: uart0 rx_overflow interrupt
      intr_type: IntrType.Event
      default_val: false
      incoming: false
      domain: Main
      plic: rv_plic
      outgoing: false
    }
    {
      name: uart0_rx_frame_err
      width: 1
      type: interrupt
      module_name: uart0
      desc: uart0 rx_frame_err interrupt
      intr_type: IntrType.Event
      default_val: false
      incoming: false
      domain: Main
      plic: rv_plic
      outgoing: false
    }
    {
      name: uart0_rx_break_err
      width: 1
      type: interrupt
      module_name: uart0
      desc: uart0 rx_break_err interrupt
      intr_type: IntrType.Event
      default_val: false
      incoming: false
      domain: Main
      plic: rv_plic
      outgoing: false
    }
    {
      name: uart0_rx_timeout
      width: 1
      type: interrupt
      module_name: uart0
      desc: uart0 rx_timeout interrupt
      intr_type: IntrType.Event
      default_val: false
      incoming: false
      domain: Main
      plic: rv_plic
      outgoing: false
    }
    {
      name: uart0_rx_parity_err
      width: 1
      type: interrupt
      module_name: uart0
      desc: uart0 rx_parity_err interrupt
      intr_type: IntrType.Event
      default_val: false
      incoming: false
      domain: Main
      plic: rv_plic
      outgoing: false
    }
    {
      name: uart0_tx_empty
      width: 1
      type: interrupt
      module_name: uart0
      desc: uart0 tx_empty interrupt
      intr_type: IntrType.Status
      default_val: true
      incoming: false
      domain: Main
      plic: rv_plic
      outgoing: false
    }
    {
      name: uart1_tx_watermark
      width: 1
      type: interrupt
      module_name: uart1
      desc: uart1 tx_watermark interrupt
      intr_type: IntrType.Status
      default_val: true
      incoming: false
      domain: Main
      plic: rv_plic
      outgoing: false
    }
    {
      name: uart1_rx_watermark
      width: 1
      type: interrupt
      module_name: uart1
      desc: uart1 rx_watermark interrupt
      intr_type: IntrType.Status
      default_val: false
      incoming: false
      domain: Main
      plic: rv_plic
      outgoing: false
    }
    {
      name: uart1_tx_done
      width: 1
      type: interrupt
      module_name: uart1
      desc: uart1 tx_done interrupt
      intr_type: IntrType.Event
      default_val: false
      incoming: false
      domain: Main
      plic: rv_plic
      outgoing: false
    }
    {
      name: uart1_rx_overflow
      width: 1
      type: interrupt
      module_name: uart1
      desc: uart1 rx_overflow interrupt
      intr_type: IntrType.Event
      default_val: false
      incoming: false
      domain: Main
      plic: rv_plic
      outgoing: false
    }
    {
      name: uart1_rx_frame_err
      width: 1
      type: interrupt
      module_name: uart1
      desc: uart1 rx_frame_err interrupt
      intr_type: IntrType.Event
      default_val: false
      incoming: false
      domain: Main
      plic: rv_plic
      outgoing: false
    }
    {
      name: uart1_rx_break_err
      width: 1
      type: interrupt
      module_name: uart1
      desc: uart1 rx_break_err interrupt
      intr_type: IntrType.Event
      default_val: false
      incoming: false
      domain: Main
      plic: rv_plic
      outgoing: false
    }
    {
      name: uart1_rx_timeout
      width: 1
      type: interrupt
      module_name: uart1
      desc: uart1 rx_timeout interrupt
      intr_type: IntrType.Event
      default_val: false
      incoming: false
      domain: Main
      plic: rv_plic
      outgoing: false
    }
    {
      name: uart1_rx_parity_err
      width: 1
      type: interrupt
      module_name: uart1
      desc: uart1 rx_parity_err interrupt
      intr_type: IntrType.Event
      default_val: false
      incoming: false
      domain: Main
      plic: rv_plic
      outgoing: false
    }
    {
      name: uart1_tx_empty
      width: 1
      type: interrupt
      module_name: uart1
      desc: uart1 tx_empty interrupt
      intr_type: IntrType.Status
      default_val: true
      incoming: false
      domain: Main
      plic: rv_plic
      outgoing: false
    }
    {
      name: gpio0_gpio
      width: 32
      type: interrupt
      module_name: gpio0
      desc: gpio0 gpio interrupt
      intr_type: IntrType.Event
      default_val: false
      incoming: false
      domain: Main
      plic: rv_plic
      outgoing: false
    }
    {
      name: spi_device_upload_cmdfifo_not_empty
      width: 1
      type: interrupt
      module_name: spi_device
      desc: spi_device upload_cmdfifo_not_empty interrupt
      intr_type: IntrType.Event
      default_val: false
      incoming: false
      domain: Main
      plic: rv_plic
      outgoing: false
    }
    {
      name: spi_device_upload_payload_not_empty
      width: 1
      type: interrupt
      module_name: spi_device
      desc: spi_device upload_payload_not_empty interrupt
      intr_type: IntrType.Event
      default_val: false
      incoming: false
      domain: Main
      plic: rv_plic
      outgoing: false
    }
    {
      name: spi_device_upload_payload_overflow
      width: 1
      type: interrupt
      module_name: spi_device
      desc: spi_device upload_payload_overflow interrupt
      intr_type: IntrType.Event
      default_val: false
      incoming: false
      domain: Main
      plic: rv_plic
      outgoing: false
    }
    {
      name: spi_device_readbuf_watermark
      width: 1
      type: interrupt
      module_name: spi_device
      desc: spi_device readbuf_watermark interrupt
      intr_type: IntrType.Event
      default_val: false
      incoming: false
      domain: Main
      plic: rv_plic
      outgoing: false
    }
    {
      name: spi_device_readbuf_flip
      width: 1
      type: interrupt
      module_name: spi_device
      desc: spi_device readbuf_flip interrupt
      intr_type: IntrType.Event
      default_val: false
      incoming: false
      domain: Main
      plic: rv_plic
      outgoing: false
    }
    {
      name: spi_device_tpm_header_not_empty
      width: 1
      type: interrupt
      module_name: spi_device
      desc: spi_device tpm_header_not_empty interrupt
      intr_type: IntrType.Status
      default_val: false
      incoming: false
      domain: Main
      plic: rv_plic
      outgoing: false
    }
    {
      name: spi_device_tpm_rdfifo_cmd_end
      width: 1
      type: interrupt
      module_name: spi_device
      desc: spi_device tpm_rdfifo_cmd_end interrupt
      intr_type: IntrType.Event
      default_val: false
      incoming: false
      domain: Main
      plic: rv_plic
      outgoing: false
    }
    {
      name: spi_device_tpm_rdfifo_drop
      width: 1
      type: interrupt
      module_name: spi_device
      desc: spi_device tpm_rdfifo_drop interrupt
      intr_type: IntrType.Event
      default_val: false
      incoming: false
      domain: Main
      plic: rv_plic
      outgoing: false
    }
    {
      name: spi_host0_error
      width: 1
      type: interrupt
      module_name: spi_host0
      desc: spi_host0 error interrupt
      intr_type: IntrType.Event
      default_val: false
      incoming: false
      domain: Main
      plic: rv_plic
      outgoing: false
    }
    {
      name: spi_host0_spi_event
      width: 1
      type: interrupt
      module_name: spi_host0
      desc: spi_host0 spi_event interrupt
      intr_type: IntrType.Status
      default_val: false
      incoming: false
      domain: Main
      plic: rv_plic
      outgoing: false
    }
    {
      name: usbdev_pkt_received
      width: 1
      type: interrupt
      module_name: usbdev
      desc: usbdev pkt_received interrupt
      intr_type: IntrType.Status
      default_val: false
      incoming: false
      domain: Main
      plic: rv_plic
      outgoing: false
    }
    {
      name: usbdev_pkt_sent
      width: 1
      type: interrupt
      module_name: usbdev
      desc: usbdev pkt_sent interrupt
      intr_type: IntrType.Status
      default_val: false
      incoming: false
      domain: Main
      plic: rv_plic
      outgoing: false
    }
    {
      name: usbdev_disconnected
      width: 1
      type: interrupt
      module_name: usbdev
      desc: usbdev disconnected interrupt
      intr_type: IntrType.Event
      default_val: false
      incoming: false
      domain: Main
      plic: rv_plic
      outgoing: false
    }
    {
      name: usbdev_host_lost
      width: 1
      type: interrupt
      module_name: usbdev
      desc: usbdev host_lost interrupt
      intr_type: IntrType.Event
      default_val: false
      incoming: false
      domain: Main
      plic: rv_plic
      outgoing: false
    }
    {
      name: usbdev_link_reset
      width: 1
      type: interrupt
      module_name: usbdev
      desc: usbdev link_reset interrupt
      intr_type: IntrType.Event
      default_val: false
      incoming: false
      domain: Main
      plic: rv_plic
      outgoing: false
    }
    {
      name: usbdev_link_suspend
      width: 1
      type: interrupt
      module_name: usbdev
      desc: usbdev link_suspend interrupt
      intr_type: IntrType.Event
      default_val: false
      incoming: false
      domain: Main
      plic: rv_plic
      outgoing: false
    }
    {
      name: usbdev_link_resume
      width: 1
      type: interrupt
      module_name: usbdev
      desc: usbdev link_resume interrupt
      intr_type: IntrType.Event
      default_val: false
      incoming: false
      domain: Main
      plic: rv_plic
      outgoing: false
    }
    {
      name: usbdev_av_out_empty
      width: 1
      type: interrupt
      module_name: usbdev
      desc: usbdev av_out_empty interrupt
      intr_type: IntrType.Status
      default_val: false
      incoming: false
      domain: Main
      plic: rv_plic
      outgoing: false
    }
    {
      name: usbdev_rx_full
      width: 1
      type: interrupt
      module_name: usbdev
      desc: usbdev rx_full interrupt
      intr_type: IntrType.Status
      default_val: false
      incoming: false
      domain: Main
      plic: rv_plic
      outgoing: false
    }
    {
      name: usbdev_av_overflow
      width: 1
      type: interrupt
      module_name: usbdev
      desc: usbdev av_overflow interrupt
      intr_type: IntrType.Event
      default_val: false
      incoming: false
      domain: Main
      plic: rv_plic
      outgoing: false
    }
    {
      name: usbdev_link_in_err
      width: 1
      type: interrupt
      module_name: usbdev
      desc: usbdev link_in_err interrupt
      intr_type: IntrType.Event
      default_val: false
      incoming: false
      domain: Main
      plic: rv_plic
      outgoing: false
    }
    {
      name: usbdev_rx_crc_err
      width: 1
      type: interrupt
      module_name: usbdev
      desc: usbdev rx_crc_err interrupt
      intr_type: IntrType.Event
      default_val: false
      incoming: false
      domain: Main
      plic: rv_plic
      outgoing: false
    }
    {
      name: usbdev_rx_pid_err
      width: 1
      type: interrupt
      module_name: usbdev
      desc: usbdev rx_pid_err interrupt
      intr_type: IntrType.Event
      default_val: false
      incoming: false
      domain: Main
      plic: rv_plic
      outgoing: false
    }
    {
      name: usbdev_rx_bitstuff_err
      width: 1
      type: interrupt
      module_name: usbdev
      desc: usbdev rx_bitstuff_err interrupt
      intr_type: IntrType.Event
      default_val: false
      incoming: false
      domain: Main
      plic: rv_plic
      outgoing: false
    }
    {
      name: usbdev_frame
      width: 1
      type: interrupt
      module_name: usbdev
      desc: usbdev frame interrupt
      intr_type: IntrType.Event
      default_val: false
      incoming: false
      domain: Main
      plic: rv_plic
      outgoing: false
    }
    {
      name: usbdev_powered
      width: 1
      type: interrupt
      module_name: usbdev
      desc: usbdev powered interrupt
      intr_type: IntrType.Event
      default_val: false
      incoming: false
      domain: Main
      plic: rv_plic
      outgoing: false
    }
    {
      name: usbdev_link_out_err
      width: 1
      type: interrupt
      module_name: usbdev
      desc: usbdev link_out_err interrupt
      intr_type: IntrType.Event
      default_val: false
      incoming: false
      domain: Main
      plic: rv_plic
      outgoing: false
    }
    {
      name: usbdev_av_setup_empty
      width: 1
      type: interrupt
      module_name: usbdev
      desc: usbdev av_setup_empty interrupt
      intr_type: IntrType.Status
      default_val: false
      incoming: false
      domain: Main
      plic: rv_plic
      outgoing: false
    }
    {
      name: pwrmgr_wakeup
      width: 1
      type: interrupt
      module_name: pwrmgr
      desc: pwrmgr wakeup interrupt
      intr_type: IntrType.Event
      default_val: false
      incoming: false
      domain: Aon
      plic: rv_plic
      outgoing: false
    }
    {
      name: aon_timer_wkup_timer_expired
      width: 1
      type: interrupt
      module_name: aon_timer
      desc: aon_timer wkup_timer_expired interrupt
      intr_type: IntrType.Event
      default_val: false
      incoming: false
      domain: Aon
      plic: rv_plic
      outgoing: false
    }
    {
      name: aon_timer_wdog_timer_bark
      width: 1
      type: interrupt
      module_name: aon_timer
      desc: aon_timer wdog_timer_bark interrupt
      intr_type: IntrType.Event
      default_val: false
      incoming: false
      domain: Aon
      plic: rv_plic
      outgoing: false
    }
    {
      name: flash_ctrl_prog_empty
      width: 1
      type: interrupt
      module_name: flash_ctrl
      desc: flash_ctrl prog_empty interrupt
      intr_type: IntrType.Status
      default_val: true
      incoming: false
      domain: Main
      plic: rv_plic
      outgoing: false
    }
    {
      name: flash_ctrl_prog_lvl
      width: 1
      type: interrupt
      module_name: flash_ctrl
      desc: flash_ctrl prog_lvl interrupt
      intr_type: IntrType.Status
      default_val: true
      incoming: false
      domain: Main
      plic: rv_plic
      outgoing: false
    }
    {
      name: flash_ctrl_rd_full
      width: 1
      type: interrupt
      module_name: flash_ctrl
      desc: flash_ctrl rd_full interrupt
      intr_type: IntrType.Status
      default_val: false
      incoming: false
      domain: Main
      plic: rv_plic
      outgoing: false
    }
    {
      name: flash_ctrl_rd_lvl
      width: 1
      type: interrupt
      module_name: flash_ctrl
      desc: flash_ctrl rd_lvl interrupt
      intr_type: IntrType.Status
      default_val: false
      incoming: false
      domain: Main
      plic: rv_plic
      outgoing: false
    }
    {
      name: flash_ctrl_op_done
      width: 1
      type: interrupt
      module_name: flash_ctrl
      desc: flash_ctrl op_done interrupt
      intr_type: IntrType.Event
      default_val: false
      incoming: false
      domain: Main
      plic: rv_plic
      outgoing: false
    }
    {
      name: flash_ctrl_corr_err
      width: 1
      type: interrupt
      module_name: flash_ctrl
      desc: flash_ctrl corr_err interrupt
      intr_type: IntrType.Event
      default_val: false
      incoming: false
      domain: Main
      plic: rv_plic
      outgoing: false
    }
  ]
  outgoing_interrupt: {}
  plic_info:
  {
    rv_plic:
    {
      domain: Main
      count_tot: 88
      count_pd:
      {
        Aon: 3
        Main: 84
      }
    }
  }
  inter_pd:
  {
    definitions:
    [
      {
        package: ""
        struct: logic
        domain: chip
        signame: intr_vector_pd_aon
        width: 3
        type: uni
        special: interrupt
        end_idx: -1
        act: req
        suffix: ""
        default: "'0"
      }
      {
        package: prim_alert_pkg
        struct: alert_tx
        domain: chip
        signame: alertenglishbreakfast_tx_pd_aon
        width: 6
        type: uni
        special: alert
        end_idx: -1
        act: req
        suffix: ""
        default: "'0"
      }
      {
        package: prim_alert_pkg
        struct: alert_rx
        domain: chip
        signame: alertenglishbreakfast_rx_pd_aon
        width: 6
        type: uni
        special: alert
        end_idx: -1
        act: req
        suffix: ""
        default: "'0"
      }
      {
        package: prim_alert_pkg
        struct: alert_tx
        domain: chip
        signame: alertenglishbreakfast_tx_pd_main
        width: 22
        type: uni
        special: alert
        end_idx: -1
        act: req
        suffix: ""
        default: "'0"
      }
      {
        package: prim_alert_pkg
        struct: alert_rx
        domain: chip
        signame: alertenglishbreakfast_rx_pd_main
        width: 22
        type: uni
        special: alert
        end_idx: -1
        act: req
        suffix: ""
        default: "'0"
      }
      {
        package: prim_mubi_pkg
        struct: mubi4
        domain: chip
        signame: outgoing_lpg_cg_en_englishbreakfast
        width: 15
        type: uni
        special: alert
        end_idx: -1
        act: req
        suffix: ""
        default: prim_mubi_pkg::MuBi4True
      }
      {
        package: prim_mubi_pkg
        struct: mubi4
        domain: chip
        signame: outgoing_lpg_rst_en_englishbreakfast
        width: 15
        type: uni
        special: alert
        end_idx: -1
        act: req
        suffix: ""
        default: prim_mubi_pkg::MuBi4True
      }
      {
        package: pwrmgr_pkg
        struct: pwr_nvm
        domain: chip
        signame: pwrmgr_pwr_nvm
        width: 1
        type: uni
        end_idx: -1
        act: rcv
        suffix: ""
        default: pwrmgr_pkg::PWR_NVM_DEFAULT
      }
      {
        package: ""
        struct: logic
        domain: chip
        signame: pwrmgr_strap
        width: 1
        type: uni
        end_idx: -1
        act: req
        suffix: ""
        default: 1'b0
      }
      {
        package: ""
        struct: logic
        domain: chip
        signame: pwrmgr_low_power
        width: 1
        type: uni
        end_idx: -1
        act: req
        suffix: ""
        default: 1'b0
      }
      {
        package: lc_ctrl_pkg
        struct: lc_tx
        domain: chip
        signame: pwrmgr_fetch_en
        width: 1
        type: uni
        end_idx: -1
        act: req
        suffix: ""
        default: lc_ctrl_pkg::LC_TX_DEFAULT
      }
      {
        package: prim_mubi_pkg
        struct: mubi4
        domain: chip
        signame: clkmgr_idle
        width: 1
        type: uni
        end_idx: -1
        act: rcv
        suffix: ""
        default: prim_mubi_pkg::MUBI4_DEFAULT
      }
      {
        package: rv_core_ibex_pkg
        struct: cpu_crash_dump
        domain: chip
        signame: rv_core_ibex_crash_dump
        width: 1
        type: uni
        end_idx: -1
        act: req
        suffix: ""
        default: rv_core_ibex_pkg::CPU_CRASH_DUMP_DEFAULT
      }
      {
        package: rv_core_ibex_pkg
        struct: cpu_pwrmgr
        domain: chip
        signame: rv_core_ibex_pwrmgr
        width: 1
        type: uni
        end_idx: -1
        act: req
        suffix: ""
        default: rv_core_ibex_pkg::CPU_PWRMGR_DEFAULT
      }
      {
        package: ""
        struct: logic
        domain: chip
        signame: pwrmgr_wakeups
        width: 2
        type: uni
        end_idx: -1
        act: rcv
        suffix: ""
        default: "'0"
      }
      {
        package: tlul_pkg
        struct: tl_h2d
        domain: chip
        signame: pwrmgr_tl_req
        width: 1
        type: req_rsp
        end_idx: -1
        act: rsp
        suffix: req
        default: tlul_pkg::TL_H2D_DEFAULT
      }
      {
        package: tlul_pkg
        struct: tl_d2h
        domain: chip
        signame: pwrmgr_tl_rsp
        width: 1
        type: req_rsp
        end_idx: -1
        act: rsp
        suffix: rsp
        default: tlul_pkg::TL_D2H_DEFAULT
      }
      {
        package: tlul_pkg
        struct: tl_h2d
        domain: chip
        signame: rstmgr_tl_req
        width: 1
        type: req_rsp
        end_idx: -1
        act: rsp
        suffix: req
        default: tlul_pkg::TL_H2D_DEFAULT
      }
      {
        package: tlul_pkg
        struct: tl_d2h
        domain: chip
        signame: rstmgr_tl_rsp
        width: 1
        type: req_rsp
        end_idx: -1
        act: rsp
        suffix: rsp
        default: tlul_pkg::TL_D2H_DEFAULT
      }
      {
        package: tlul_pkg
        struct: tl_h2d
        domain: chip
        signame: clkmgr_tl_req
        width: 1
        type: req_rsp
        end_idx: -1
        act: rsp
        suffix: req
        default: tlul_pkg::TL_H2D_DEFAULT
      }
      {
        package: tlul_pkg
        struct: tl_d2h
        domain: chip
        signame: clkmgr_tl_rsp
        width: 1
        type: req_rsp
        end_idx: -1
        act: rsp
        suffix: rsp
        default: tlul_pkg::TL_D2H_DEFAULT
      }
    ]
  }
  alert_module: []
  alert_connections:
  {
    module_uart0:
    {
      tx_expr: outgoing_alert_englishbreakfast_tx_o[0]
      rx_expr: outgoing_alert_englishbreakfast_rx_i[0]
      async_expr: AsyncOnOutgoingAlertEnglishbreakfast[0]
      comments:
      [
        External alert group "englishbreakfast" [0]: fatal_fault
      ]
    }
    module_uart1:
    {
      tx_expr: outgoing_alert_englishbreakfast_tx_o[1]
      rx_expr: outgoing_alert_englishbreakfast_rx_i[1]
      async_expr: AsyncOnOutgoingAlertEnglishbreakfast[1]
      comments:
      [
        External alert group "englishbreakfast" [1]: fatal_fault
      ]
    }
    module_gpio0:
    {
      tx_expr: outgoing_alert_englishbreakfast_tx_o[2]
      rx_expr: outgoing_alert_englishbreakfast_rx_i[2]
      async_expr: AsyncOnOutgoingAlertEnglishbreakfast[2]
      comments:
      [
        External alert group "englishbreakfast" [2]: fatal_fault
      ]
    }
    module_spi_device:
    {
      tx_expr: outgoing_alert_englishbreakfast_tx_o[3]
      rx_expr: outgoing_alert_englishbreakfast_rx_i[3]
      async_expr: AsyncOnOutgoingAlertEnglishbreakfast[3]
      comments:
      [
        External alert group "englishbreakfast" [3]: fatal_fault
      ]
    }
    module_spi_host0:
    {
      tx_expr: outgoing_alert_englishbreakfast_tx_o[4]
      rx_expr: outgoing_alert_englishbreakfast_rx_i[4]
      async_expr: AsyncOnOutgoingAlertEnglishbreakfast[4]
      comments:
      [
        External alert group "englishbreakfast" [4]: fatal_fault
      ]
    }
    module_rv_timer:
    {
      tx_expr: outgoing_alert_englishbreakfast_tx_o[5]
      rx_expr: outgoing_alert_englishbreakfast_rx_i[5]
      async_expr: AsyncOnOutgoingAlertEnglishbreakfast[5]
      comments:
      [
        External alert group "englishbreakfast" [5]: fatal_fault
      ]
    }
    module_usbdev:
    {
      tx_expr: outgoing_alert_englishbreakfast_tx_o[6]
      rx_expr: outgoing_alert_englishbreakfast_rx_i[6]
      async_expr: AsyncOnOutgoingAlertEnglishbreakfast[6]
      comments:
      [
        External alert group "englishbreakfast" [6]: fatal_fault
      ]
    }
    module_pwrmgr:
    {
      tx_expr: outgoing_alert_englishbreakfast_tx_o[0]
      rx_expr: outgoing_alert_englishbreakfast_rx_i[0]
      async_expr: AsyncOnOutgoingAlertEnglishbreakfast[7]
      comments:
      [
        External alert group "englishbreakfast" [7]: fatal_fault
      ]
    }
    module_rstmgr:
    {
      tx_expr: outgoing_alert_englishbreakfast_tx_o[2:1]
      rx_expr: outgoing_alert_englishbreakfast_rx_i[2:1]
      async_expr: AsyncOnOutgoingAlertEnglishbreakfast[9:8]
      comments:
      [
        External alert group "englishbreakfast" [8]: fatal_fault
        External alert group "englishbreakfast" [9]: fatal_cnsty_fault
      ]
    }
    module_clkmgr:
    {
      tx_expr: outgoing_alert_englishbreakfast_tx_o[4:3]
      rx_expr: outgoing_alert_englishbreakfast_rx_i[4:3]
      async_expr: AsyncOnOutgoingAlertEnglishbreakfast[11:10]
      comments:
      [
        External alert group "englishbreakfast" [10]: recov_fault
        External alert group "englishbreakfast" [11]: fatal_fault
      ]
    }
    module_pinmux:
    {
      tx_expr: outgoing_alert_englishbreakfast_tx_o[7]
      rx_expr: outgoing_alert_englishbreakfast_rx_i[7]
      async_expr: AsyncOnOutgoingAlertEnglishbreakfast[12]
      comments:
      [
        External alert group "englishbreakfast" [12]: fatal_fault
      ]
    }
    module_aon_timer:
    {
      tx_expr: outgoing_alert_englishbreakfast_tx_o[5]
      rx_expr: outgoing_alert_englishbreakfast_rx_i[5]
      async_expr: AsyncOnOutgoingAlertEnglishbreakfast[13]
      comments:
      [
        External alert group "englishbreakfast" [13]: fatal_fault
      ]
    }
    module_flash_ctrl:
    {
      tx_expr: outgoing_alert_englishbreakfast_tx_o[12:8]
      rx_expr: outgoing_alert_englishbreakfast_rx_i[12:8]
      async_expr: AsyncOnOutgoingAlertEnglishbreakfast[18:14]
      comments:
      [
        External alert group "englishbreakfast" [14]: recov_err
        External alert group "englishbreakfast" [15]: fatal_std_err
        External alert group "englishbreakfast" [16]: fatal_err
        External alert group "englishbreakfast" [17]: fatal_prim_flash_alert
        External alert group "englishbreakfast" [18]: recov_prim_flash_alert
      ]
    }
    module_rv_plic:
    {
      tx_expr: outgoing_alert_englishbreakfast_tx_o[13]
      rx_expr: outgoing_alert_englishbreakfast_rx_i[13]
      async_expr: AsyncOnOutgoingAlertEnglishbreakfast[19]
      comments:
      [
        External alert group "englishbreakfast" [19]: fatal_fault
      ]
    }
    module_aes:
    {
      tx_expr: outgoing_alert_englishbreakfast_tx_o[15:14]
      rx_expr: outgoing_alert_englishbreakfast_rx_i[15:14]
      async_expr: AsyncOnOutgoingAlertEnglishbreakfast[21:20]
      comments:
      [
        External alert group "englishbreakfast" [20]: recov_ctrl_update_err
        External alert group "englishbreakfast" [21]: fatal_fault
      ]
    }
    module_sram_ctrl_main:
    {
      tx_expr: outgoing_alert_englishbreakfast_tx_o[16]
      rx_expr: outgoing_alert_englishbreakfast_rx_i[16]
      async_expr: AsyncOnOutgoingAlertEnglishbreakfast[22]
      comments:
      [
        External alert group "englishbreakfast" [22]: fatal_error
      ]
    }
    module_rom_ctrl:
    {
      tx_expr: outgoing_alert_englishbreakfast_tx_o[17]
      rx_expr: outgoing_alert_englishbreakfast_rx_i[17]
      async_expr: AsyncOnOutgoingAlertEnglishbreakfast[23]
      comments:
      [
        External alert group "englishbreakfast" [23]: fatal
      ]
    }
    module_rv_core_ibex:
    {
      tx_expr: outgoing_alert_englishbreakfast_tx_o[21:18]
      rx_expr: outgoing_alert_englishbreakfast_rx_i[21:18]
      async_expr: AsyncOnOutgoingAlertEnglishbreakfast[27:24]
      comments:
      [
        External alert group "englishbreakfast" [24]: fatal_sw_err
        External alert group "englishbreakfast" [25]: recov_sw_err
        External alert group "englishbreakfast" [26]: fatal_hw_err
        External alert group "englishbreakfast" [27]: recov_hw_err
      ]
    }
  }
  alert_handler_info:
  {
    englishbreakfast:
    {
      domain: external
      count_tot: 28
      count_pd:
      {
        Aon: 6
        Main: 22
      }
    }
  }
  outgoing_alert_module:
  {
    englishbreakfast:
    [
      uart0
      uart1
      gpio0
      spi_device
      spi_host0
      rv_timer
      usbdev
      pwrmgr
      rstmgr
      clkmgr
      pinmux
      aon_timer
      flash_ctrl
      rv_plic
      aes
      sram_ctrl_main
      rom_ctrl
      rv_core_ibex
    ]
  }
  outgoing_interrupt_module: {}
  alert_lpgs:
  [
    {
      name: secure_lc_io_div4_Main
      clock_group:
      {
        name: secure
        src: top
        sw_cg: no
        unique: no
        clocks:
        {
          clk_io_div4_secure: io_div4
          clk_aon_gated_secure: aon
          clk_main_secure: main
        }
      }
      clock_connection: clkmgr_clocks_i.clk_io_div4_secure
      unmanaged_clock: false
      unmanaged_reset: false
      reset_connection:
      {
        name: lc_io_div4
        domain: Main
      }
    }
  ]
  outgoing_alert_lpgs:
  {
    englishbreakfast:
    [
      {
        name: peri_lc_io_div4_Main
        clock_group:
        {
          name: peri
          src: top
          sw_cg: yes
          unique: no
          clocks:
          {
            clk_io_div4_peri: io_div4
            clk_io_peri: io
            clk_usb_peri: usb
            clk_aon_gated_peri: aon
          }
        }
        clock_connection: clkmgr_clocks_i.clk_io_div4_peri
        unmanaged_clock: false
        unmanaged_reset: false
        reset_connection:
        {
          name: lc_io_div4
          domain: Main
        }
      }
      {
        name: peri_sys_io_div4_Main
        clock_group:
        {
          name: peri
          src: top
          sw_cg: yes
          unique: no
          clocks:
          {
            clk_io_div4_peri: io_div4
            clk_io_peri: io
            clk_usb_peri: usb
            clk_aon_gated_peri: aon
          }
        }
        clock_connection: clkmgr_clocks_i.clk_io_div4_peri
        unmanaged_clock: false
        unmanaged_reset: false
        reset_connection:
        {
          name: sys_io_div4
          domain: Main
        }
      }
      {
        name: peri_spi_device_Main
        clock_group:
        {
          name: peri
          src: top
          sw_cg: yes
          unique: no
          clocks:
          {
            clk_io_div4_peri: io_div4
            clk_io_peri: io
            clk_usb_peri: usb
            clk_aon_gated_peri: aon
          }
        }
        clock_connection: clkmgr_clocks_i.clk_io_div4_peri
        unmanaged_clock: false
        unmanaged_reset: false
        reset_connection:
        {
          name: spi_device
          domain: Main
        }
      }
      {
        name: peri_spi_host0_Main
        clock_group:
        {
          name: peri
          src: top
          sw_cg: yes
          unique: no
          clocks:
          {
            clk_io_div4_peri: io_div4
            clk_io_peri: io
            clk_usb_peri: usb
            clk_aon_gated_peri: aon
          }
        }
        clock_connection: clkmgr_clocks_i.clk_io_peri
        unmanaged_clock: false
        unmanaged_reset: false
        reset_connection:
        {
          name: spi_host0
          domain: Main
        }
      }
      {
        name: timers_sys_io_div4_Main
        clock_group:
        {
          name: timers
          src: top
          sw_cg: no
          unique: no
          clocks:
          {
            clk_io_div4_timers: io_div4
            clk_aon_timers: aon
          }
        }
        clock_connection: clkmgr_clocks_i.clk_io_div4_timers
        unmanaged_clock: false
        unmanaged_reset: false
        reset_connection:
        {
          name: sys_io_div4
          domain: Main
        }
      }
      {
        name: peri_usb_Main
        clock_group:
        {
          name: peri
          src: top
          sw_cg: yes
          unique: no
          clocks:
          {
            clk_io_div4_peri: io_div4
            clk_io_peri: io
            clk_usb_peri: usb
            clk_aon_gated_peri: aon
          }
        }
        clock_connection: clkmgr_clocks_i.clk_usb_peri
        unmanaged_clock: false
        unmanaged_reset: false
        reset_connection:
        {
          name: usb
          domain: Main
        }
      }
      {
        name: powerup_por_io_div4_Aon
        clock_group:
        {
          name: powerup
          src: top
          sw_cg: no
          unique: no
          clocks:
          {
            clk_io_div4_powerup: io_div4
            clk_aon_powerup: aon
            clk_aon_gated_powerup: aon
            clk_main_powerup: main
            clk_io_powerup: io
            clk_usb_powerup: usb
          }
        }
        clock_connection: clkmgr_clocks.clk_io_div4_powerup
        unmanaged_clock: false
        unmanaged_reset: false
        reset_connection:
        {
          name: por_io_div4
          domain: Aon
        }
      }
      {
        name: powerup_lc_io_div4_Main
        clock_group:
        {
          name: powerup
          src: top
          sw_cg: no
          unique: no
          clocks:
          {
            clk_io_div4_powerup: io_div4
            clk_aon_powerup: aon
            clk_aon_gated_powerup: aon
            clk_main_powerup: main
            clk_io_powerup: io
            clk_usb_powerup: usb
          }
        }
        clock_connection: clkmgr_clocks.clk_io_div4_powerup
        unmanaged_clock: false
        unmanaged_reset: false
        reset_connection:
        {
          name: lc_io_div4
          domain: Main
        }
      }
      {
        name: powerup_por_aon_Aon
        clock_group:
        {
          name: powerup
          src: top
          sw_cg: no
          unique: no
          clocks:
          {
            clk_io_div4_powerup: io_div4
            clk_aon_powerup: aon
            clk_aon_gated_powerup: aon
            clk_main_powerup: main
            clk_io_powerup: io
            clk_usb_powerup: usb
          }
        }
        clock_connection: clkmgr_clocks_secondary.clk_aon_powerup
        unmanaged_clock: false
        unmanaged_reset: false
        reset_connection:
        {
          name: por_aon
          domain: Aon
        }
      }
      {
        name: powerup_por_io_div4_Main
        clock_group:
        {
          name: powerup
          src: top
          sw_cg: no
          unique: no
          clocks:
          {
            clk_io_div4_powerup: io_div4
            clk_aon_powerup: aon
            clk_aon_gated_powerup: aon
            clk_main_powerup: main
            clk_io_powerup: io
            clk_usb_powerup: usb
          }
        }
        clock_connection: clkmgr_clocks.clk_io_div4_powerup
        unmanaged_clock: false
        unmanaged_reset: false
        reset_connection:
        {
          name: por_io_div4
          domain: Main
        }
      }
      {
        name: timers_sys_io_div4_Aon
        clock_group:
        {
          name: timers
          src: top
          sw_cg: no
          unique: no
          clocks:
          {
            clk_io_div4_timers: io_div4
            clk_aon_timers: aon
          }
        }
        clock_connection: clkmgr_clocks.clk_io_div4_timers
        unmanaged_clock: false
        unmanaged_reset: false
        reset_connection:
        {
          name: sys_io_div4
          domain: Aon
        }
      }
      {
        name: infra_lc_Main
        clock_group:
        {
          name: infra
          src: top
          sw_cg: no
          unique: no
          clocks:
          {
            clk_main_infra: main
            clk_io_div4_infra: io_div4
            clk_io_infra: io
            clk_usb_infra: usb
          }
        }
        clock_connection: clkmgr_clocks_i.clk_main_infra
        unmanaged_clock: false
        unmanaged_reset: false
        reset_connection:
        {
          name: lc
          domain: Main
        }
      }
      {
        name: secure_sys_Main
        clock_group:
        {
          name: secure
          src: top
          sw_cg: no
          unique: no
          clocks:
          {
            clk_io_div4_secure: io_div4
            clk_aon_gated_secure: aon
            clk_main_secure: main
          }
        }
        clock_connection: clkmgr_clocks_i.clk_main_secure
        unmanaged_clock: false
        unmanaged_reset: false
        reset_connection:
        {
          name: sys
          domain: Main
        }
      }
      {
        name: aes_trans_sys_Main
        clock_group:
        {
          name: trans
          src: top
          sw_cg: hint
          unique: yes
          clocks:
          {
            clk_main_aes: main
          }
        }
        clock_connection: clkmgr_clocks_i.clk_main_aes
        unmanaged_clock: false
        unmanaged_reset: false
        reset_connection:
        {
          name: sys
          domain: Main
        }
      }
      {
        name: infra_sys_Main
        clock_group:
        {
          name: infra
          src: top
          sw_cg: no
          unique: no
          clocks:
          {
            clk_main_infra: main
            clk_io_div4_infra: io_div4
            clk_io_infra: io
            clk_usb_infra: usb
          }
        }
        clock_connection: clkmgr_clocks_i.clk_main_infra
        unmanaged_clock: false
        unmanaged_reset: false
        reset_connection:
        {
          name: sys
          domain: Main
        }
      }
    ]
  }
  inter_signal:
  {
    signals:
    [
      {
        name: lsio_trigger
        desc:
          '''
          Self-clearing status trigger for the DMA.
          Set when RX or TX FIFOs are past their configured watermarks matching watermark interrupt behaviour.
          '''
        struct: logic
        type: uni
        act: req
        width: 1
        inst_name: uart0
        index: -1
      }
      {
        name: racl_policies
        desc:
          '''
          Incoming RACL policy vector from a racl_ctrl instance.
          The policy selection vector (parameter) selects the policy for each register.
          '''
        struct: racl_policy_vec
        package: top_racl_pkg
        type: uni
        act: rcv
        width: 1
        inst_name: uart0
        index: -1
      }
      {
        name: racl_error
        desc: RACL error log information of this module.
        struct: racl_error_log
        package: top_racl_pkg
        type: uni
        act: req
        width: 1
        inst_name: uart0
        index: -1
      }
      {
        name: tl
        struct: tl
        package: tlul_pkg
        type: req_rsp
        act: rsp
        width: 1
        inst_name: uart0
        default: ""
        end_idx: -1
        top_type: one-to-one
        top_signame: uart0_tl
        index: -1
      }
      {
        name: lsio_trigger
        desc:
          '''
          Self-clearing status trigger for the DMA.
          Set when RX or TX FIFOs are past their configured watermarks matching watermark interrupt behaviour.
          '''
        struct: logic
        type: uni
        act: req
        width: 1
        inst_name: uart1
        index: -1
      }
      {
        name: racl_policies
        desc:
          '''
          Incoming RACL policy vector from a racl_ctrl instance.
          The policy selection vector (parameter) selects the policy for each register.
          '''
        struct: racl_policy_vec
        package: top_racl_pkg
        type: uni
        act: rcv
        width: 1
        inst_name: uart1
        index: -1
      }
      {
        name: racl_error
        desc: RACL error log information of this module.
        struct: racl_error_log
        package: top_racl_pkg
        type: uni
        act: req
        width: 1
        inst_name: uart1
        index: -1
      }
      {
        name: tl
        struct: tl
        package: tlul_pkg
        type: req_rsp
        act: rsp
        width: 1
        inst_name: uart1
        default: ""
        end_idx: -1
        top_type: one-to-one
        top_signame: uart1_tl
        index: -1
      }
      {
        name: strap_en
        desc:
          '''
          The strap enable signal tells gpio to take a snapshot of the input pins.
          The behaviour of this signal after that event will have no effect.

          If the `GpioAsHwStrapsEn` synthesis parameter is false this interface is unused.
          '''
        struct: logic
        type: uni
        act: rcv
        width: 1
        default: 1'b0
        inst_name: gpio0
        index: -1
      }
      {
        name: sampled_straps
        desc:
          '''
          This vector contains the sampled strap values.

          If the `GpioAsHwStrapsEn` synthesis parameter is false this interface is unused.
          '''
        struct: gpio_straps
        package: gpio_pkg
        type: uni
        act: req
        width: 1
        default: "'0"
        inst_name: gpio0
        index: -1
      }
      {
        name: racl_policies
        desc:
          '''
          Incoming RACL policy vector from a racl_ctrl instance.
          The policy selection vector (parameter) selects the policy for each register.

          If the `EnableRacl` synthesis parameter is false this interface is unused.
          '''
        struct: racl_policy_vec
        package: top_racl_pkg
        type: uni
        act: rcv
        width: 1
        inst_name: gpio0
        index: -1
      }
      {
        name: racl_error
        desc:
          '''
          RACL error log information of this module.

          If the `EnableRacl` synthesis parameter is false this interface is unused.
          '''
        struct: racl_error_log
        package: top_racl_pkg
        type: uni
        act: req
        width: 1
        inst_name: gpio0
        index: -1
      }
      {
        name: tl
        struct: tl
        package: tlul_pkg
        type: req_rsp
        act: rsp
        width: 1
        inst_name: gpio0
        default: ""
        end_idx: -1
        top_type: one-to-one
        top_signame: gpio0_tl
        index: -1
      }
      {
        name: ram_cfg_sys2spi
        struct: ram_1r1w_cfg
        package: prim_ram_1r1w_pkg
        type: req_rsp
        act: rsp
        width: 1
        inst_name: spi_device
        index: -1
      }
      {
        name: ram_cfg_spi2sys
        struct: ram_1r1w_cfg
        package: prim_ram_1r1w_pkg
        type: req_rsp
        act: rsp
        width: 1
        inst_name: spi_device
        index: -1
      }
      {
        name: passthrough
        struct: passthrough
        package: spi_device_pkg
        type: req_rsp
        act: req
        width: 1
        inst_name: spi_device
        default: ""
        end_idx: -1
        top_type: one-to-one
        top_signame: spi_device_passthrough
        index: -1
      }
      {
        name: mbist_en
        struct: logic
        type: uni
        act: rcv
        width: 1
        inst_name: spi_device
        index: -1
      }
      {
        name: sck_monitor
        struct: logic
        type: uni
        act: req
        width: 1
        inst_name: spi_device
        default: ""
        package: ""
        external: true
        conn_type: false
        index: -1
        top_signame: sck_monitor
      }
      {
        name: racl_policies
        desc:
          '''
          Incoming RACL policy vector from a racl_ctrl instance.
          The policy selection vector (parameter) selects the policy for each register.
          '''
        struct: racl_policy_vec
        package: top_racl_pkg
        type: uni
        act: rcv
        width: 1
        inst_name: spi_device
        index: -1
      }
      {
        name: racl_error
        desc: RACL error log information of this module.
        struct: racl_error_log
        package: top_racl_pkg
        type: uni
        act: req
        width: 1
        inst_name: spi_device
        index: -1
      }
      {
        name: tl
        struct: tl
        package: tlul_pkg
        type: req_rsp
        act: rsp
        width: 1
        inst_name: spi_device
        default: ""
        end_idx: -1
        top_type: one-to-one
        top_signame: spi_device_tl
        index: -1
      }
      {
        name: passthrough
        struct: passthrough
        package: spi_device_pkg
        type: req_rsp
        act: rsp
        width: 1
        inst_name: spi_host0
        default: ""
        domain: Main
        top_signame: spi_device_passthrough
        index: -1
      }
      {
        name: lsio_trigger
        desc:
          '''
          Self-clearing status trigger for the DMA.
          Set when RX or TX FIFOs are past their configured watermarks matching watermark interrupt behaviour.
          '''
        struct: logic
        type: uni
        act: req
        width: 1
        inst_name: spi_host0
        index: -1
      }
      {
        name: racl_policies
        desc:
          '''
          Incoming RACL policy vector from a racl_ctrl instance.
          The policy selection vector (parameter) selects the policy for each register.
          '''
        struct: racl_policy_vec
        package: top_racl_pkg
        type: uni
        act: rcv
        width: 1
        inst_name: spi_host0
        index: -1
      }
      {
        name: racl_error
        desc: RACL error log information of this module.
        struct: racl_error_log
        package: top_racl_pkg
        type: uni
        act: req
        width: 1
        inst_name: spi_host0
        index: -1
      }
      {
        name: tl
        struct: tl
        package: tlul_pkg
        type: req_rsp
        act: rsp
        width: 1
        inst_name: spi_host0
        default: ""
        end_idx: -1
        top_type: one-to-one
        top_signame: spi_host0_tl
        index: -1
      }
      {
        name: racl_policies
        desc:
          '''
          Incoming RACL policy vector from a racl_ctrl instance.
          The policy selection vector (parameter) selects the policy for each register.
          '''
        struct: racl_policy_vec
        package: top_racl_pkg
        type: uni
        act: rcv
        width: 1
        inst_name: rv_timer
        index: -1
      }
      {
        name: racl_error
        desc: RACL error log information of this module.
        struct: racl_error_log
        package: top_racl_pkg
        type: uni
        act: req
        width: 1
        inst_name: rv_timer
        index: -1
      }
      {
        name: tl
        struct: tl
        package: tlul_pkg
        type: req_rsp
        act: rsp
        width: 1
        inst_name: rv_timer
        default: ""
        end_idx: -1
        top_type: one-to-one
        top_signame: rv_timer_tl
        index: -1
      }
      {
        name: usb_rx_d
        desc: USB RX data from an external differential receiver, if available
        struct: logic
        type: uni
        act: rcv
        width: 1
        inst_name: usbdev
        default: ""
        package: ""
        external: true
        conn_type: false
        index: -1
        top_signame: usbdev_usb_rx_d
      }
      {
        name: usb_tx_d
        desc: USB transmit data value (not used if usb_tx_se0 is set)
        struct: logic
        type: uni
        act: req
        width: 1
        inst_name: usbdev
        default: ""
        package: ""
        external: true
        conn_type: false
        index: -1
        top_signame: usbdev_usb_tx_d
      }
      {
        name: usb_tx_se0
        desc: Force transmission of a USB single-ended zero (i.e. both D+ and D- are low) regardless of usb_tx_d
        struct: logic
        type: uni
        act: req
        width: 1
        inst_name: usbdev
        default: ""
        package: ""
        external: true
        conn_type: false
        index: -1
        top_signame: usbdev_usb_tx_se0
      }
      {
        name: usb_tx_use_d_se0
        desc: Use the usb_tx_d and usb_tx_se0 TX interface, instead of usb_dp_o and usb_dn_o
        struct: logic
        type: uni
        act: req
        width: 1
        inst_name: usbdev
        default: ""
        package: ""
        external: true
        conn_type: false
        index: -1
        top_signame: usbdev_usb_tx_use_d_se0
      }
      {
        name: usb_dp_pullup
        desc: USB D+ pullup control
        struct: logic
        type: uni
        act: req
        width: 1
        inst_name: usbdev
        default: ""
        package: ""
        end_idx: -1
        top_type: broadcast
        top_signame: usbdev_usb_dp_pullup
        index: -1
      }
      {
        name: usb_dn_pullup
        desc: USB D- pullup control
        struct: logic
        type: uni
        act: req
        width: 1
        inst_name: usbdev
        default: ""
        package: ""
        end_idx: -1
        top_type: broadcast
        top_signame: usbdev_usb_dn_pullup
        index: -1
      }
      {
        name: usb_rx_enable
        desc: USB differential receiver enable
        struct: logic
        type: uni
        act: req
        width: 1
        inst_name: usbdev
        default: ""
        package: ""
        external: true
        conn_type: false
        index: -1
        top_signame: usbdev_usb_rx_enable
      }
      {
        name: usb_ref_val
        desc: This indicates that USB timing reference signal 'usb_ref_pulse' is valid
        struct: logic
        type: uni
        act: req
        width: 1
        inst_name: usbdev
        default: ""
        package: ""
        external: true
        conn_type: false
        index: -1
        top_signame: usbdev_usb_ref_val
      }
      {
        name: usb_ref_pulse
        desc: USB timing reference signal. This signal pulses for a single 48MHz clock every 1ms USB frame
        struct: logic
        type: uni
        act: req
        width: 1
        inst_name: usbdev
        default: ""
        package: ""
        external: true
        conn_type: false
        index: -1
        top_signame: usbdev_usb_ref_pulse
      }
      {
        name: usb_aon_suspend_req
        desc: Request to activate the AON/Wake module and take control of the USB pullups
        struct: logic
        type: uni
        act: req
        width: 1
        inst_name: usbdev
        default: ""
        package: ""
        end_idx: -1
        top_type: broadcast
        top_signame: usbdev_usb_aon_suspend_req
        index: -1
      }
      {
        name: usb_aon_wake_ack
        desc: Acknowledge a wake signal from the AON/Wake and relinquish control of the USB pullups
        struct: logic
        type: uni
        act: req
        width: 1
        inst_name: usbdev
        default: ""
        package: ""
        end_idx: -1
        top_type: broadcast
        top_signame: usbdev_usb_aon_wake_ack
        index: -1
      }
      {
        name: usb_aon_bus_reset
        desc: Indicates that the reason for waking was that a USB Bus Reset occurred
        struct: logic
        type: uni
        act: rcv
        width: 1
        inst_name: usbdev
        default: ""
        package: ""
        end_idx: -1
        top_type: broadcast
        top_signame: usbdev_usb_aon_bus_reset
        index: -1
      }
      {
        name: usb_aon_sense_lost
        desc: Indicates that the reason for waking was that the VBUS/SENSE signal became deasserted
        struct: logic
        type: uni
        act: rcv
        width: 1
        inst_name: usbdev
        default: ""
        package: ""
        end_idx: -1
        top_type: broadcast
        top_signame: usbdev_usb_aon_sense_lost
        index: -1
      }
      {
        name: usb_aon_bus_not_idle
        desc: Indicates that the reason for waking was that the USB is in a non-idle state
        struct: logic
        type: uni
        act: rcv
        width: 1
        inst_name: usbdev
        index: -1
      }
      {
        name: usb_aon_wake_detect_active
        desc: Indicates that the external AON/Wake module is active and controlling the USB pullups
        struct: logic
        type: uni
        act: rcv
        width: 1
        inst_name: usbdev
        default: ""
        package: ""
        domain: Main
        top_signame: pinmux_usbdev_wake_detect_active
        index: -1
      }
      {
        name: ram_cfg
        struct: ram_1p_cfg
        package: prim_ram_1p_pkg
        type: req_rsp
        act: rsp
        width: 1
        inst_name: usbdev
        index: -1
      }
      {
        name: tl
        struct: tl
        package: tlul_pkg
        type: req_rsp
        act: rsp
        width: 1
        inst_name: usbdev
        default: ""
        end_idx: -1
        top_type: one-to-one
        top_signame: usbdev_tl
        index: -1
      }
      {
        name: pwr_ast
        struct: pwr_ast
        package: pwrmgr_pkg
        type: req_rsp
        act: req
        width: 1
        inst_name: pwrmgr
        default: ""
        external: true
        conn_type: false
        index: -1
        top_signame: pwrmgr_ast
      }
      {
        name: pwr_rst
        struct: pwr_rst
        package: pwrmgr_pkg
        type: req_rsp
        act: req
        width: 1
        inst_name: pwrmgr
        default: ""
        end_idx: -1
        top_type: one-to-one
        top_signame: pwrmgr_pwr_rst
        index: -1
      }
      {
        name: pwr_clk
        struct: pwr_clk
        package: pwrmgr_pkg
        type: req_rsp
        act: req
        width: 1
        inst_name: pwrmgr
        default: ""
        end_idx: -1
        top_type: one-to-one
        top_signame: pwrmgr_pwr_clk
        index: -1
      }
      {
        name: pwr_otp
        struct: pwr_otp
        package: pwrmgr_pkg
        type: req_rsp
        act: req
        width: 1
        inst_name: pwrmgr
        index: -1
      }
      {
        name: pwr_lc
        struct: pwr_lc
        package: lc_ctrl_pkg
        type: req_rsp
        act: req
        width: 1
        inst_name: pwrmgr
        index: -1
      }
      {
        name: pwr_nvm
        struct: pwr_nvm
        package: pwrmgr_pkg
        type: uni
        act: rcv
        width: 1
        inst_name: pwrmgr
        default: ""
        end_idx: -1
        top_type: broadcast
        top_signame: pwrmgr_pwr_nvm
        index: -1
        external: true
        conn_type: false
      }
      {
        name: esc_rst_tx
        struct: esc_tx
        package: prim_esc_pkg
        type: uni
        act: rcv
        width: 1
        inst_name: pwrmgr
        index: -1
      }
      {
        name: esc_rst_rx
        struct: esc_rx
        package: prim_esc_pkg
        type: uni
        act: req
        width: 1
        inst_name: pwrmgr
        index: -1
      }
      {
        name: pwr_cpu
        struct: cpu_pwrmgr
        package: rv_core_ibex_pkg
        type: uni
        act: rcv
        width: 1
        inst_name: pwrmgr
        default: ""
        domain: Aon
        top_signame: rv_core_ibex_pwrmgr
        index: -1
        external: true
        conn_type: false
      }
      {
        name: wakeups
        struct: logic
        type: uni
        act: rcv
        width: 3
        inst_name: pwrmgr
        default: ""
        package: ""
        end_idx: -1
        top_type: one-to-N
        top_signame: pwrmgr_wakeups
        index:
        [
          0
          1
        ]
        external: true
        conn_type: true
      }
      {
        name: rstreqs
        struct: logic
        type: uni
        act: rcv
        width: 1
        inst_name: pwrmgr
        default: ""
        package: ""
        end_idx: -1
        top_type: broadcast
        top_signame: pwrmgr_rstreqs
        index: -1
      }
      {
        name: ndmreset_req
        struct: logic
        type: uni
        act: rcv
        width: 1
        inst_name: pwrmgr
        index: -1
      }
      {
        name: strap
        struct: logic
        type: uni
        act: req
        width: 1
        inst_name: pwrmgr
        default: ""
        package: ""
        end_idx: -1
        top_type: broadcast
        top_signame: pwrmgr_strap
        index: -1
        external: true
        conn_type: false
      }
      {
        name: low_power
        struct: logic
        type: uni
        act: req
        width: 1
        inst_name: pwrmgr
        default: ""
        package: ""
        end_idx: -1
        top_type: broadcast
        top_signame: pwrmgr_low_power
        index: -1
        external: true
        conn_type: true
      }
      {
        name: main_pd_aon_clk_en
        desc:
          '''
          The clkmgr uses this signal to gate clk_aon to the Main power domain. The clock is
          passed from the Aon power domain, where it is free-running, to the Main power domain.
          To prevent glitches, the clock is enabled after the isolation (pwr_clamp) is released
          and gated before the isolation is asserted. In the slow FSM's terminal state, the
          clock is gated in the same cycle as the isolation is asserted. This signal is
          synchronous to the always-on clock (clk_slow_i/clk_aon) and is the inverse of the
          pwr_clamp_env signal.
          '''
        struct: logic
        type: uni
        act: req
        width: 1
        inst_name: pwrmgr
        default: ""
        package: ""
        end_idx: -1
        top_type: broadcast
        top_signame: pwrmgr_main_pd_aon_clk_en
        index: -1
      }
      {
        name: rom_ctrl
        struct: pwrmgr_data
        package: rom_ctrl_pkg
        type: uni
        act: rcv
        width: 1
        default: rom_ctrl_pkg::PWRMGR_DATA_DEFAULT
        inst_name: pwrmgr
        index: -1
      }
      {
        name: fetch_en
        struct: lc_tx
        package: lc_ctrl_pkg
        type: uni
        act: req
        width: 1
        inst_name: pwrmgr
        default: ""
        end_idx: -1
        top_type: broadcast
        top_signame: pwrmgr_fetch_en
        index: -1
        external: true
        conn_type: false
      }
      {
        name: lc_dft_en
        struct: lc_tx
        package: lc_ctrl_pkg
        type: uni
        act: rcv
        width: 1
        inst_name: pwrmgr
        index: -1
      }
      {
        name: lc_hw_debug_en
        struct: lc_tx
        package: lc_ctrl_pkg
        type: uni
        act: rcv
        width: 1
        inst_name: pwrmgr
        index: -1
      }
      {
        name: sw_rst_req
        struct: mubi4
        package: prim_mubi_pkg
        type: uni
        act: rcv
        width: 1
        inst_name: pwrmgr
        default: ""
        domain: Aon
        top_signame: rstmgr_sw_rst_req
        index: -1
      }
      {
        name: tl
        struct: tl
        package: tlul_pkg
        type: req_rsp
        act: rsp
        width: 1
        inst_name: pwrmgr
        default: ""
        end_idx: -1
        top_type: one-to-one
        top_signame: pwrmgr_tl
        index: -1
        external: true
        conn_type: false
      }
      {
        name: por_n
        desc:
          '''
          Root power on reset signals from ast.
          There is one root reset signal for each core power domain.
          '''
        struct: logic
        type: uni
        act: rcv
        width: 2
        partition: secondary
        inst_name: rstmgr
        default: ""
        package: ""
        external: true
        conn_type: false
        index: -1
        top_signame: por_n
      }
      {
        name: pwr
        desc:
          '''
          Reset request signals from power manager.
          Power manager can request for specific domains of the lc/sys reset tree to assert.
          '''
        struct: pwr_rst
        type: req_rsp
        act: rsp
        width: 1
        partition: secondary
        inst_name: rstmgr
        default: ""
        package: pwrmgr_pkg
        domain: Aon
        top_signame: pwrmgr_pwr_rst
        index: -1
      }
      {
        name: resets
        desc: Leaf resets fed to the system.
        struct: rstmgr_out_primary
        package: rstmgr_pkg
        type: uni
        act: req
        width: 1
        inst_name: rstmgr
        default: ""
        top_signame: rstmgr_resets
        index: -1
        external: true
        conn_type: true
      }
      {
        name: resets_secondary
        desc: Leaf resets fed to the system.
        struct: rstmgr_out_secondary
        package: rstmgr_pkg
        type: uni
        act: req
        width: 1
        partition: secondary
        inst_name: rstmgr
        default: ""
        top_signame: rstmgr_resets_secondary
        index: -1
        external: true
        conn_type: true
      }
      {
        name: rst_en
        desc: Low-power-group outputs used by alert handler.
        struct: rstmgr_rst_en_primary
        package: rstmgr_pkg
        type: uni
        act: req
        width: 1
        inst_name: rstmgr
        default: ""
        top_signame: rstmgr_rst_en
        index: -1
        external: true
        conn_type: true
      }
      {
        name: alert_dump
        desc: Alert handler crash dump information.
        struct: alert_crashdump
        package: alert_handler_pkg
        type: uni
        act: rcv
        width: 1
        inst_name: rstmgr
        index: -1
      }
      {
        name: cpu_dump
        desc: Main processing element crash dump information.
        struct: cpu_crash_dump
        package: rv_core_ibex_pkg
        type: uni
        act: rcv
        width: 1
        inst_name: rstmgr
        default: ""
        domain: Aon
        top_signame: rv_core_ibex_crash_dump
        index: -1
        external: true
        conn_type: false
      }
      {
        name: sw_rst_req
        desc: Software requested system reset to pwrmgr.
        struct: mubi4
        package: prim_mubi_pkg
        type: uni
        act: req
        width: 1
        partition: secondary
        inst_name: rstmgr
        default: ""
        end_idx: -1
        top_type: broadcast
        top_signame: rstmgr_sw_rst_req
        index: -1
      }
      {
        name: intraip_s2p
        desc: Secondary-to-primary partition communication
        struct: intraip_s2p
        package: rstmgr_pkg
        type: uni
        act: req
        width: 1
        partition: secondary
        inst_name: rstmgr
        default: ""
        end_idx: -1
        top_type: broadcast
        top_signame: rstmgr_intraip_s2p
        index: -1
      }
      {
        name: intraip_s2p
        desc: Secondary-to-primary partition communication
        struct: intraip_s2p
        package: rstmgr_pkg
        type: uni
        act: rcv
        width: 1
        inst_name: rstmgr
        default: ""
        domain: Aon
        top_signame: rstmgr_intraip_s2p
        index: -1
      }
      {
        name: intraip_p2s
        desc: Primary-to-secondary partition communication
        struct: intraip_p2s
        package: rstmgr_pkg
        type: uni
        act: req
        width: 1
        inst_name: rstmgr
        default: ""
        end_idx: -1
        top_type: broadcast
        top_signame: rstmgr_intraip_p2s
        index: -1
      }
      {
        name: intraip_p2s
        desc: Primary-to-secondary partition communication
        struct: intraip_p2s
        package: rstmgr_pkg
        type: uni
        act: rcv
        width: 1
        partition: secondary
        inst_name: rstmgr
        default: ""
        domain: Aon
        top_signame: rstmgr_intraip_p2s
        index: -1
      }
      {
        name: tl
        struct: tl
        package: tlul_pkg
        type: req_rsp
        act: rsp
        width: 1
        inst_name: rstmgr
        default: ""
        end_idx: -1
        top_type: one-to-one
        top_signame: rstmgr_tl
        index: -1
        external: true
        conn_type: false
      }
      {
        name: clocks
        desc: Clocks hosted in the primary partition.
        struct: clkmgr_out_primary
        package: clkmgr_pkg
        type: uni
        act: req
        width: 1
        inst_name: clkmgr
        default: ""
        top_signame: clkmgr_clocks
        index: -1
        external: true
        conn_type: true
      }
      {
        name: clocks_secondary
        desc: Clocks hosted in the secondary partition.
        struct: clkmgr_out_secondary
        package: clkmgr_pkg
        type: uni
        act: req
        width: 1
        partition: secondary
        inst_name: clkmgr
        default: ""
        top_signame: clkmgr_clocks_secondary
        index: -1
      }
      {
        name: cg_en
        desc: Clock gating indications for all the clocks (output by the primary partition).
        struct: clkmgr_cg_en_primary
        package: clkmgr_pkg
        type: uni
        act: req
        width: 1
        inst_name: clkmgr
        default: ""
        top_signame: clkmgr_cg_en
        index: -1
        external: true
        conn_type: true
      }
      {
        name: main_pd_aon_clk_en
        desc:
          '''
          The clkmgr uses this signal to gate clk_aon to the Main power domain during a
          power-down. The gate prevents glitches on the clock. See the pwrmgr interface
          definition for more details of main_pd_aon_clk_en_o.
          '''
        struct: logic
        type: uni
        act: rcv
        width: 1
        partition: secondary
        inst_name: clkmgr
        default: ""
        package: ""
        domain: Aon
        top_signame: pwrmgr_main_pd_aon_clk_en
        index: -1
      }
      {
        name: intraip_s2p
        desc: Secondary-to-primary partition communication.
        struct: intraip_s2p
        package: clkmgr_pkg
        type: uni
        act: req
        width: 1
        partition: secondary
        inst_name: clkmgr
        default: ""
        end_idx: -1
        top_type: broadcast
        top_signame: clkmgr_intraip_s2p
        index: -1
      }
      {
        name: intraip_s2p
        desc: Secondary-to-primary partition communication.
        struct: intraip_s2p
        package: clkmgr_pkg
        type: uni
        act: rcv
        width: 1
        inst_name: clkmgr
        default: ""
        domain: Aon
        top_signame: clkmgr_intraip_s2p
        index: -1
      }
      {
        name: intraip_p2s
        desc: Primary-to-secondary partition communication.
        struct: intraip_p2s
        package: clkmgr_pkg
        type: uni
        act: req
        width: 1
        inst_name: clkmgr
        default: ""
        end_idx: -1
        top_type: broadcast
        top_signame: clkmgr_intraip_p2s
        index: -1
      }
      {
        name: intraip_p2s
        desc: Primary-to-secondary partition communication.
        struct: intraip_p2s
        package: clkmgr_pkg
        type: uni
        act: rcv
        width: 1
        partition: secondary
        inst_name: clkmgr
        default: ""
        domain: Aon
        top_signame: clkmgr_intraip_p2s
        index: -1
      }
      {
        name: lc_hw_debug_en
        struct: lc_tx
        package: lc_ctrl_pkg
        type: uni
        act: rcv
        width: 1
        inst_name: clkmgr
        index: -1
      }
      {
        name: io_clk_byp_req
        struct: mubi4
        package: prim_mubi_pkg
        type: uni
        act: req
        width: 1
        inst_name: clkmgr
        default: ""
        external: true
        conn_type: false
        index: -1
        top_signame: io_clk_byp_req
      }
      {
        name: io_clk_byp_ack
        struct: mubi4
        package: prim_mubi_pkg
        type: uni
        act: rcv
        width: 1
        inst_name: clkmgr
        default: ""
        external: true
        conn_type: false
        index: -1
        top_signame: io_clk_byp_ack
      }
      {
        name: all_clk_byp_req
        struct: mubi4
        package: prim_mubi_pkg
        type: uni
        act: req
        width: 1
        inst_name: clkmgr
        default: ""
        external: true
        conn_type: false
        index: -1
        top_signame: all_clk_byp_req
      }
      {
        name: all_clk_byp_ack
        struct: mubi4
        package: prim_mubi_pkg
        type: uni
        act: rcv
        width: 1
        inst_name: clkmgr
        default: ""
        external: true
        conn_type: false
        index: -1
        top_signame: all_clk_byp_ack
      }
      {
        name: hi_speed_sel
        struct: mubi4
        package: prim_mubi_pkg
        type: uni
        act: req
        width: 1
        inst_name: clkmgr
        default: ""
        external: true
        conn_type: false
        index: -1
        top_signame: hi_speed_sel
      }
      {
        name: div_step_down_req
        struct: mubi4
        package: prim_mubi_pkg
        type: uni
        act: rcv
        width: 1
        inst_name: clkmgr
        default: ""
        external: true
        conn_type: false
        index: -1
        top_signame: div_step_down_req
      }
      {
        name: lc_clk_byp_req
        struct: lc_tx
        package: lc_ctrl_pkg
        type: uni
        act: rcv
        width: 1
        inst_name: clkmgr
        index: -1
      }
      {
        name: lc_clk_byp_ack
        struct: lc_tx
        package: lc_ctrl_pkg
        type: uni
        act: req
        width: 1
        inst_name: clkmgr
        index: -1
      }
      {
        name: jitter_en
        struct: mubi4
        package: prim_mubi_pkg
        type: uni
        act: req
        width: 1
        inst_name: clkmgr
        default: ""
        external: true
        conn_type: false
        index: -1
        top_signame: clk_main_jitter_en
      }
      {
        name: pwr
        struct: pwr_clk
        type: req_rsp
        act: rsp
        width: 1
        partition: secondary
        inst_name: clkmgr
        default: ""
        package: pwrmgr_pkg
        domain: Aon
        top_signame: pwrmgr_pwr_clk
        index: -1
      }
      {
        name: idle
        struct: mubi4
        package: prim_mubi_pkg
        type: uni
        act: rcv
        width: 1
        inst_name: clkmgr
        default: ""
        end_idx: -1
        top_type: broadcast
        top_signame: clkmgr_idle
        index: -1
        external: true
        conn_type: false
      }
      {
        name: calib_rdy
        desc: Indicates clocks are calibrated and frequencies accurate
        struct: mubi4
        package: prim_mubi_pkg
        type: uni
        act: rcv
        width: 1
        default: prim_mubi_pkg::MuBi4True
        inst_name: clkmgr
        index: -1
      }
      {
        name: tl
        struct: tl
        package: tlul_pkg
        type: req_rsp
        act: rsp
        width: 1
        inst_name: clkmgr
        default: ""
        end_idx: -1
        top_type: one-to-one
        top_signame: clkmgr_tl
        index: -1
        external: true
        conn_type: false
      }
      {
        name: lc_hw_debug_clr
        desc: Debug clear signal coming from life cycle controller, used for HW strap qualification.
        struct: lc_tx
        package: lc_ctrl_pkg
        type: uni
        act: rcv
        width: 1
        default: lc_ctrl_pkg::Off
        inst_name: pinmux
        index: -1
      }
      {
        name: lc_hw_debug_en
        desc: Debug enable qualifier coming from life cycle controller, used for HW strap qualification.
        struct: lc_tx
        package: lc_ctrl_pkg
        type: uni
        act: rcv
        width: 1
        default: lc_ctrl_pkg::Off
        inst_name: pinmux
        index: -1
      }
      {
        name: lc_dft_en
        desc: Test enable qualifier coming from life cycle controller, used for HW strap qualification.
        struct: lc_tx
        package: lc_ctrl_pkg
        type: uni
        act: rcv
        width: 1
        default: lc_ctrl_pkg::Off
        inst_name: pinmux
        index: -1
      }
      {
        name: lc_escalate_en
        desc:
          '''
          Escalation enable signal coming from life cycle controller, used for invalidating
          the latched lc_hw_debug_en state inside the strap sampling logic.
          '''
        struct: lc_tx
        package: lc_ctrl_pkg
        type: uni
        act: rcv
        width: 1
        default: lc_ctrl_pkg::Off
        inst_name: pinmux
        index: -1
      }
      {
        name: lc_check_byp_en
        desc:
          '''
          Check bypass enable signal coming from life cycle controller, used for invalidating
          the latched lc_hw_debug_en state inside the strap sampling logic. This signal is asserted
          whenever the life cycle controller performs a life cycle transition. Its main use is
          to skip any background checks inside the life cycle partition of the OTP controller while
          a life cycle transition is in progress.
          '''
        struct: lc_tx
        package: lc_ctrl_pkg
        type: uni
        act: rcv
        width: 1
        default: lc_ctrl_pkg::Off
        inst_name: pinmux
        index: -1
      }
      {
        name: pinmux_hw_debug_en
        desc:
          '''
          This is the latched version of lc_hw_debug_en_i. We use it exclusively to gate the JTAG
          signals and TAP side of the RV_DM so that RV_DM can remain live during an NDM reset cycle.
          '''
        struct: lc_tx
        package: lc_ctrl_pkg
        type: uni
        act: req
        width: 1
        default: lc_ctrl_pkg::Off
        inst_name: pinmux
        index: -1
      }
      {
        name: lc_jtag
        desc: Qualified JTAG signals for life cycle controller TAP.
        struct: jtag
        package: jtag_pkg
        type: req_rsp
        act: req
        width: 1
        inst_name: pinmux
        index: -1
      }
      {
        name: rv_jtag
        desc: Qualified JTAG signals for RISC-V processor TAP.
        struct: jtag
        package: jtag_pkg
        type: req_rsp
        act: req
        width: 1
        inst_name: pinmux
        index: -1
      }
      {
        name: dft_jtag
        desc: Qualified JTAG signals for DFT TAP.
        struct: jtag
        package: jtag_pkg
        type: req_rsp
        act: req
        width: 1
        inst_name: pinmux
        default: ""
        top_signame: pinmux_dft_jtag
        index: -1
      }
      {
        name: dft_strap_test
        desc: Sampled DFT strap values, going to the DFT TAP.
        struct: dft_strap_test_req
        package: pinmux_pkg
        type: uni
        act: req
        width: 1
        default: "'0"
        inst_name: pinmux
        external: true
        conn_type: false
        index: -1
        top_signame: dft_strap_test
      }
      {
        name: dft_hold_tap_sel
        desc: TAP selection hold indication, asserted by the DFT TAP during boundary scan.
        struct: logic
        type: uni
        act: rcv
        width: 1
        default: "'0"
        inst_name: pinmux
        package: ""
        external: true
        conn_type: false
        index: -1
        top_signame: dft_hold_tap_sel
      }
      {
        name: sleep_en
        desc: Level signal that is asserted when the power manager enters sleep.
        struct: logic
        type: uni
        act: rcv
        width: 1
        default: 1'b0
        inst_name: pinmux
        package: ""
        domain: Main
        top_signame: pwrmgr_low_power
        index: -1
        external: true
        conn_type: false
      }
      {
        name: strap_en
        desc: This signal is pulsed high by the power manager after reset in order to sample the HW straps.
        struct: logic
        type: uni
        act: rcv
        width: 1
        default: 1'b0
        inst_name: pinmux
        package: ""
        domain: Main
        top_signame: pwrmgr_strap
        index: -1
        external: true
        conn_type: false
      }
      {
        name: strap_en_override
        desc:
          '''
          This signal transitions from 0 -> 1 by the lc_ctrl manager after volatile RAW_UNLOCK in order to re-sample the HW straps.
          The signal must stay at 1 until reset.
          Note that this is only used in test chips when SecVolatileRawUnlockEn = 1.
          Otherwise this signal is unused.
          '''
        struct: logic
        type: uni
        act: rcv
        width: 1
        default: 1'b0
        inst_name: pinmux
        index: -1
      }
      {
        name: pin_wkup_req
        desc: Wakeup request from wakeup detectors, to the power manager, running on the AON clock.
        struct: logic
        type: uni
        act: req
        width: 1
        default: 1'b0
        inst_name: pinmux
        package: ""
        domain: Main
        top_signame: pwrmgr_wakeups
        index: 0
        external: true
        conn_type: false
      }
      {
        name: usbdev_dppullup_en
        desc: Pullup enable signal coming from the USB IP.
        struct: logic
        type: uni
        act: rcv
        width: 1
        inst_name: pinmux
        default: ""
        package: ""
        domain: Main
        top_signame: usbdev_usb_dp_pullup
        index: -1
      }
      {
        name: usbdev_dnpullup_en
        desc: Pullup enable signal coming from the USB IP.
        struct: logic
        type: uni
        act: rcv
        width: 1
        inst_name: pinmux
        default: ""
        package: ""
        domain: Main
        top_signame: usbdev_usb_dn_pullup
        index: -1
      }
      {
        name: usb_dppullup_en
        desc: " Pullup enable signal going to USB PHY, needs to be maintained in low-power mode."
        struct: logic
        type: uni
        act: req
        width: 1
        default: 1'b0
        inst_name: pinmux
        package: ""
        external: true
        conn_type: false
        index: -1
        top_signame: usb_dp_pullup_en
      }
      {
        name: usb_dnpullup_en
        desc: Pullup enable signal going to USB PHY, needs to be maintained in low-power mode.
        struct: logic
        type: uni
        act: req
        width: 1
        default: 1'b0
        inst_name: pinmux
        package: ""
        external: true
        conn_type: false
        index: -1
        top_signame: usb_dn_pullup_en
      }
      {
        name: usb_wkup_req
        desc: Wakeup request from USB wakeup detector, going to the power manager, running on the AON clock.
        struct: logic
        type: uni
        act: req
        width: 1
        default: 1'b0
        inst_name: pinmux
        package: ""
        domain: Main
        top_signame: pwrmgr_wakeups
        index: 1
        external: true
        conn_type: false
      }
      {
        name: usbdev_suspend_req
        desc: Indicates whether USB is in suspended state, coming from the USB device.
        struct: logic
        type: uni
        act: rcv
        width: 1
        inst_name: pinmux
        default: ""
        package: ""
        domain: Main
        top_signame: usbdev_usb_aon_suspend_req
        index: -1
      }
      {
        name: usbdev_wake_ack
        desc: Acknowledges the USB wakeup request, coming from the USB device.
        struct: logic
        type: uni
        act: rcv
        width: 1
        inst_name: pinmux
        default: ""
        package: ""
        domain: Main
        top_signame: usbdev_usb_aon_wake_ack
        index: -1
      }
      {
        name: usbdev_bus_not_idle
        desc: Event signal that indicates that the USB was not idle while monitoring.
        struct: logic
        type: uni
        act: req
        width: 1
        default: 1'b0
        inst_name: pinmux
        index: -1
      }
      {
        name: usbdev_bus_reset
        desc: Event signal that indicates that the USB issued a Bus Reset while monitoring.
        struct: logic
        type: uni
        act: req
        width: 1
        default: 1'b0
        inst_name: pinmux
        package: ""
        domain: Main
        top_signame: usbdev_usb_aon_bus_reset
        index: -1
      }
      {
        name: usbdev_sense_lost
        desc: Event signal that indicates that USB SENSE signal was lost while monitoring.
        struct: logic
        type: uni
        act: req
        width: 1
        default: 1'b0
        inst_name: pinmux
        package: ""
        domain: Main
        top_signame: usbdev_usb_aon_sense_lost
        index: -1
      }
      {
        name: usbdev_wake_detect_active
        desc: State debug information.
        struct: logic
        type: uni
        act: req
        width: 1
        default: 1'b0
        inst_name: pinmux
        package: ""
        end_idx: -1
        top_type: broadcast
        top_signame: pinmux_usbdev_wake_detect_active
        index: -1
      }
      {
        name: tl
        struct: tl
        package: tlul_pkg
        type: req_rsp
        act: rsp
        width: 1
        inst_name: pinmux
        default: ""
        end_idx: -1
        top_type: one-to-one
        top_signame: pinmux_tl
        index: -1
      }
      {
        name: nmi_wdog_timer_bark
        struct: logic
        type: uni
        act: req
        width: 1
        default: 1'b0
        inst_name: aon_timer
        index: -1
      }
      {
        name: wkup_req
        struct: logic
        type: uni
        act: req
        width: 1
        default: 1'b0
        inst_name: aon_timer
        package: ""
        domain: Aon
        top_signame: pwrmgr_wakeups
        index: 2
      }
      {
        name: aon_timer_rst_req
        struct: logic
        type: uni
        act: req
        width: 1
        default: 1'b0
        inst_name: aon_timer
        package: ""
        domain: Aon
        top_signame: pwrmgr_rstreqs
        index: -1
      }
      {
        name: lc_escalate_en
        struct: lc_tx
        package: lc_ctrl_pkg
        type: uni
        act: rcv
        width: 1
        default: lc_ctrl_pkg::Off
        inst_name: aon_timer
        index: -1
      }
      {
        name: sleep_mode
        struct: logic
        type: uni
        act: rcv
        width: 1
        inst_name: aon_timer
        default: ""
        package: ""
        domain: Aon
        top_signame: pwrmgr_low_power
        index: -1
      }
      {
        name: racl_policies
        desc:
          '''
          Incoming RACL policy vector from a racl_ctrl instance.
          The policy selection vector (parameter) selects the policy for each register.
          '''
        struct: racl_policy_vec
        package: top_racl_pkg
        type: uni
        act: rcv
        width: 1
        inst_name: aon_timer
        index: -1
      }
      {
        name: racl_error
        desc: RACL error log information of this module.
        struct: racl_error_log
        package: top_racl_pkg
        type: uni
        act: req
        width: 1
        inst_name: aon_timer
        index: -1
      }
      {
        name: tl
        struct: tl
        package: tlul_pkg
        type: req_rsp
        act: rsp
        width: 1
        inst_name: aon_timer
        index: -1
      }
      {
        name: tl
        struct: tl
        package: tlul_pkg
        type: req_rsp
        act: rsp
        width: 1
        inst_name: ast
        index: -1
      }
      {
        name: otp
        struct: nvm_otp_key
        package: otp_ctrl_pkg
        type: req_rsp
        act: req
        width: 1
        inst_name: flash_ctrl
        index: -1
      }
      {
        name: lc_nvm_debug_en
        struct: lc_tx
        package: lc_ctrl_pkg
        type: uni
        act: rcv
        width: 1
        inst_name: flash_ctrl
        index: -1
      }
      {
        name: flash_bist_enable
        struct: mubi4
        package: prim_mubi_pkg
        type: uni
        act: rcv
        width: 1
        inst_name: flash_ctrl
        default: ""
        external: true
        conn_type: false
        index: -1
        top_signame: flash_bist_enable
      }
      {
        name: flash_power_down_h
        struct: logic
        type: uni
        act: rcv
        width: 1
        inst_name: flash_ctrl
        default: ""
        package: ""
        external: true
        conn_type: false
        index: -1
        top_signame: flash_power_down_h
      }
      {
        name: flash_power_ready_h
        struct: logic
        type: uni
        act: rcv
        width: 1
        inst_name: flash_ctrl
        default: ""
        package: ""
        external: true
        conn_type: false
        index: -1
        top_signame: flash_power_ready_h
      }
      {
        name: flash_test_mode_a
        struct: ""
        type: io
        act: none
        width: 2
        inst_name: flash_ctrl
        index: -1
      }
      {
        name: flash_test_voltage_h
        struct: ""
        type: io
        act: none
        width: 1
        inst_name: flash_ctrl
        index: -1
      }
      {
        name: lc_creator_seed_sw_rw_en
        struct: lc_tx
        package: lc_ctrl_pkg
        type: uni
        act: rcv
        width: 1
        inst_name: flash_ctrl
        index: -1
      }
      {
        name: lc_owner_seed_sw_rw_en
        struct: lc_tx
        package: lc_ctrl_pkg
        type: uni
        act: rcv
        width: 1
        inst_name: flash_ctrl
        index: -1
      }
      {
        name: lc_iso_part_sw_rd_en
        struct: lc_tx
        package: lc_ctrl_pkg
        type: uni
        act: rcv
        width: 1
        inst_name: flash_ctrl
        index: -1
      }
      {
        name: lc_iso_part_sw_wr_en
        struct: lc_tx
        package: lc_ctrl_pkg
        type: uni
        act: rcv
        width: 1
        inst_name: flash_ctrl
        index: -1
      }
      {
        name: lc_seed_hw_rd_en
        struct: lc_tx
        package: lc_ctrl_pkg
        type: uni
        act: rcv
        width: 1
        inst_name: flash_ctrl
        index: -1
      }
      {
        name: lc_escalate_en
        struct: lc_tx
        package: lc_ctrl_pkg
        type: uni
        act: rcv
        width: 1
        inst_name: flash_ctrl
        index: -1
      }
      {
        name: rma_req
        struct: lc_tx
        package: lc_ctrl_pkg
        type: uni
        act: rcv
        width: 1
        inst_name: flash_ctrl
        index: -1
      }
      {
        name: rma_ack
        struct: lc_tx
        package: lc_ctrl_pkg
        type: uni
        act: req
        width: 1
        inst_name: flash_ctrl
        index: -1
      }
      {
        name: rma_seed
        struct: lc_nvm_rma_seed
        package: lc_ctrl_pkg
        type: uni
        act: rcv
        width: 1
        inst_name: flash_ctrl
        index: -1
      }
      {
        name: pwrmgr
        struct: pwr_nvm
        package: pwrmgr_pkg
        type: uni
        act: req
        width: 1
        inst_name: flash_ctrl
        default: ""
        domain: Main
        top_signame: pwrmgr_pwr_nvm
        index: -1
        external: true
        conn_type: false
      }
      {
        name: keymgr
        struct: keymgr_flash
        package: flash_ctrl_pkg
        type: uni
        act: req
        width: 1
        inst_name: flash_ctrl
        index: -1
      }
      {
        name: obs_ctrl
        struct: ast_obs_ctrl
        package: ast_pkg
        type: uni
        act: rcv
        width: 1
        inst_name: flash_ctrl
        default: ""
        external: true
        conn_type: false
        index: -1
        top_signame: obs_ctrl
      }
      {
        name: fla_obs
        struct: logic
        type: uni
        act: req
        width: 8
        inst_name: flash_ctrl
        default: ""
        package: ""
        external: true
        conn_type: false
        index: -1
        top_signame: flash_obs
      }
      {
        name: core_tl
        struct: tl
        package: tlul_pkg
        type: req_rsp
        act: rsp
        width: 1
        inst_name: flash_ctrl
        default: ""
        end_idx: -1
        top_type: one-to-one
        top_signame: flash_ctrl_core_tl
        index: -1
      }
      {
        name: prim_tl
        struct: tl
        package: tlul_pkg
        type: req_rsp
        act: rsp
        width: 1
        inst_name: flash_ctrl
        default: ""
        end_idx: -1
        top_type: one-to-one
        top_signame: flash_ctrl_prim_tl
        index: -1
      }
      {
        name: mem_tl
        struct: tl
        package: tlul_pkg
        type: req_rsp
        act: rsp
        width: 1
        inst_name: flash_ctrl
        default: ""
        end_idx: -1
        top_type: one-to-one
        top_signame: flash_ctrl_mem_tl
        index: -1
      }
      {
        name: irq
        struct: logic
        type: uni
        act: req
        width: 1
        inst_name: rv_plic
        default: ""
        package: ""
        end_idx: -1
        top_type: broadcast
        top_signame: rv_plic_irq
        index: -1
      }
      {
        name: irq_id
        struct: logic
        type: uni
        act: req
        width: 1
        inst_name: rv_plic
        index: -1
      }
      {
        name: msip
        struct: logic
        type: uni
        act: req
        width: 1
        inst_name: rv_plic
        default: ""
        package: ""
        end_idx: -1
        top_type: broadcast
        top_signame: rv_plic_msip
        index: -1
      }
      {
        name: tl
        struct: tl
        package: tlul_pkg
        type: req_rsp
        act: rsp
        width: 1
        inst_name: rv_plic
        default: ""
        end_idx: -1
        top_type: one-to-one
        top_signame: rv_plic_tl
        index: -1
      }
      {
        name: idle
        struct: mubi4
        package: prim_mubi_pkg
        type: uni
        act: req
        width: 1
        inst_name: aes
        default: ""
        domain: Main
        top_signame: clkmgr_idle
        index: -1
        external: true
        conn_type: false
      }
      {
        name: output_valid
        struct: logic
        type: uni
        act: req
        width: 1
        inst_name: aes
        index: -1
      }
      {
        name: input_ready
        struct: logic
        type: uni
        act: req
        width: 1
        inst_name: aes
        index: -1
      }
      {
        name: lc_escalate_en
        struct: lc_tx
        package: lc_ctrl_pkg
        type: uni
        act: rcv
        width: 1
        default: lc_ctrl_pkg::Off
        inst_name: aes
        index: -1
      }
      {
        name: edn
        struct: edn
        package: edn_pkg
        type: req_rsp
        act: req
        width: 1
        inst_name: aes
        index: -1
      }
      {
        name: keymgr_key
        struct: hw_key_req
        package: keymgr_dpe_pkg
        type: uni
        act: rcv
        width: 1
        inst_name: aes
        index: -1
      }
      {
        name: tl
        struct: tl
        package: tlul_pkg
        type: req_rsp
        act: rsp
        width: 1
        inst_name: aes
        default: ""
        end_idx: -1
        top_type: one-to-one
        top_signame: aes_tl
        index: -1
      }
      {
        name: sram_otp_key
        struct: sram_otp_key
        package: otp_ctrl_pkg
        type: req_rsp
        act: req
        width: 1
        inst_name: sram_ctrl_main
        index: -1
      }
      {
        name: ram_cfg
        struct: ram_1p_cfg
        package: prim_ram_1p_pkg
        type: req_rsp
        act: rsp
        width:
        {
          name: NumRamInst
          desc: Number of internal RAM instances. Must be the same as ceil(MemSizeRam / InstSize) .
          param_type: int
          unpacked_dimensions: null
          default: 1
          local: false
          expose: true
          name_top: SramCtrlMainNumRamInst
        }
        inst_name: sram_ctrl_main
        index: -1
      }
      {
        name: lc_escalate_en
        struct: lc_tx
        package: lc_ctrl_pkg
        type: uni
        act: rcv
        width: 1
        default: lc_ctrl_pkg::Off
        inst_name: sram_ctrl_main
        index: -1
      }
      {
        name: lc_hw_debug_en
        struct: lc_tx
        package: lc_ctrl_pkg
        type: uni
        act: rcv
        width: 1
        default: lc_ctrl_pkg::Off
        inst_name: sram_ctrl_main
        index: -1
      }
      {
        name: otp_en_sram_ifetch
        struct: mubi8
        package: prim_mubi_pkg
        type: uni
        act: rcv
        width: 1
        default: prim_mubi_pkg::MuBi8False
        inst_name: sram_ctrl_main
        index: -1
      }
      {
        name: racl_policies
        desc:
          '''
          Incoming RACL policy vector from a racl_ctrl instance.
          The policy selection vector (parameter) selects the policy for each register.
          '''
        struct: racl_policy_vec
        package: top_racl_pkg
        type: uni
        act: rcv
        width: 1
        inst_name: sram_ctrl_main
        index: -1
      }
      {
        name: racl_error
        desc: RACL error log information of this module.
        struct: racl_error_log
        package: top_racl_pkg
        type: uni
        act: req
        width: 1
        inst_name: sram_ctrl_main
        index: -1
      }
      {
        name: sram_rerror
        desc: SRAM read error indicating correctable and uncorrectable ECC errors.
        struct: sram_error_t
        package: sram_ctrl_pkg
        type: uni
        act: req
        width: 1
        inst_name: sram_ctrl_main
        index: -1
      }
      {
        name: regs_tl
        struct: tl
        package: tlul_pkg
        type: req_rsp
        act: rsp
        width: 1
        inst_name: sram_ctrl_main
        default: ""
        end_idx: -1
        top_type: one-to-one
        top_signame: sram_ctrl_main_regs_tl
        index: -1
      }
      {
        name: ram_tl
        struct: tl
        package: tlul_pkg
        type: req_rsp
        act: rsp
        width: 1
        inst_name: sram_ctrl_main
        default: ""
        end_idx: -1
        top_type: one-to-one
        top_signame: sram_ctrl_main_ram_tl
        index: -1
      }
      {
        name: rom_cfg
        struct: rom_cfg
        package: prim_rom_pkg
        type: req_rsp
        act: rsp
        width: 1
        inst_name: rom_ctrl
        index: -1
      }
      {
        name: pwrmgr_data
        struct: pwrmgr_data
        package: rom_ctrl_pkg
        type: uni
        act: req
        width: 1
        inst_name: rom_ctrl
        index: -1
      }
      {
        name: keymgr_data
        struct: keymgr_data
        package: rom_ctrl_pkg
        type: uni
        act: req
        width: 1
        inst_name: rom_ctrl
        index: -1
      }
      {
        name: kmac_data
        struct: app
        package: kmac_pkg
        type: req_rsp
        act: req
        width: 1
        inst_name: rom_ctrl
        index: -1
      }
      {
        name: regs_tl
        struct: tl
        package: tlul_pkg
        type: req_rsp
        act: rsp
        width: 1
        inst_name: rom_ctrl
        default: ""
        end_idx: -1
        top_type: one-to-one
        top_signame: rom_ctrl_regs_tl
        index: -1
      }
      {
        name: rom_tl
        struct: tl
        package: tlul_pkg
        type: req_rsp
        act: rsp
        width: 1
        inst_name: rom_ctrl
        default: ""
        end_idx: -1
        top_type: one-to-one
        top_signame: rom_ctrl_rom_tl
        index: -1
      }
      {
        name: rst_cpu_n
        struct: logic
        type: uni
        act: req
        width: 1
        inst_name: rv_core_ibex
        index: -1
      }
      {
        name: ram_cfg_icache_tag
        struct: ram_1p_cfg
        package: prim_ram_1p_pkg
        type: req_rsp
        act: rsp
        width:
        {
          name: ICacheNWays
          desc: Number of instruction cache ways
          param_type: int unsigned
          unpacked_dimensions: null
          default: 2
          local: false
          expose: true
          name_top: RvCoreIbexICacheNWays
        }
        inst_name: rv_core_ibex
        index: -1
      }
      {
        name: ram_cfg_icache_data
        struct: ram_1p_cfg
        package: prim_ram_1p_pkg
        type: req_rsp
        act: rsp
        width:
        {
          name: ICacheNWays
          desc: Number of instruction cache ways
          param_type: int unsigned
          unpacked_dimensions: null
          default: 2
          local: false
          expose: true
          name_top: RvCoreIbexICacheNWays
        }
        inst_name: rv_core_ibex
        index: -1
      }
      {
        name: hart_id
        struct: logic
        type: uni
        act: rcv
        width: 32
        inst_name: rv_core_ibex
        default: ""
        package: ""
        top_signame: rv_core_ibex_hart_id
        index: -1
      }
      {
        name: boot_addr
        struct: logic
        type: uni
        act: rcv
        width: 32
        inst_name: rv_core_ibex
        default: ""
        package: ""
        top_signame: rv_core_ibex_boot_addr
        index: -1
      }
      {
        name: irq_software
        struct: logic
        type: uni
        act: rcv
        width: 1
        inst_name: rv_core_ibex
        default: ""
        package: ""
        domain: Main
        top_signame: rv_plic_msip
        index: -1
      }
      {
        name: irq_timer
        struct: logic
        type: uni
        act: rcv
        width: 1
        inst_name: rv_core_ibex
        default: ""
        package: ""
        top_signame: rv_core_ibex_irq_timer
        index: -1
      }
      {
        name: irq_external
        struct: logic
        type: uni
        act: rcv
        width: 1
        inst_name: rv_core_ibex
        default: ""
        package: ""
        domain: Main
        top_signame: rv_plic_irq
        index: -1
      }
      {
        name: esc_tx
        struct: esc_tx
        package: prim_esc_pkg
        type: uni
        act: rcv
        width: 1
        inst_name: rv_core_ibex
        index: -1
      }
      {
        name: esc_rx
        struct: esc_rx
        package: prim_esc_pkg
        type: uni
        act: req
        width: 1
        inst_name: rv_core_ibex
        index: -1
      }
      {
        name: debug_req
        struct: logic
        type: uni
        act: rcv
        width: 1
        inst_name: rv_core_ibex
        index: -1
      }
      {
        name: crash_dump
        struct: cpu_crash_dump
        package: rv_core_ibex_pkg
        type: uni
        act: req
        width: 1
        inst_name: rv_core_ibex
        default: ""
        end_idx: -1
        top_type: broadcast
        top_signame: rv_core_ibex_crash_dump
        index: -1
        external: true
        conn_type: false
      }
      {
        name: lc_cpu_en
        struct: lc_tx
        package: lc_ctrl_pkg
        type: uni
        act: rcv
        width: 1
        default: lc_ctrl_pkg::On
        inst_name: rv_core_ibex
        index: -1
      }
      {
        name: pwrmgr_cpu_en
        struct: lc_tx
        package: lc_ctrl_pkg
        type: uni
        act: rcv
        width: 1
        inst_name: rv_core_ibex
        default: ""
        domain: Main
        top_signame: pwrmgr_fetch_en
        index: -1
        external: true
        conn_type: false
      }
      {
        name: pwrmgr
        struct: cpu_pwrmgr
        package: rv_core_ibex_pkg
        type: uni
        act: req
        width: 1
        inst_name: rv_core_ibex
        default: ""
        end_idx: -1
        top_type: broadcast
        top_signame: rv_core_ibex_pwrmgr
        index: -1
        external: true
        conn_type: false
      }
      {
        name: nmi_wdog
        struct: logic
        type: uni
        act: rcv
        width: 1
        inst_name: rv_core_ibex
        index: -1
      }
      {
        name: edn
        struct: edn
        package: edn_pkg
        type: req_rsp
        act: req
        width: 1
        inst_name: rv_core_ibex
        index: -1
      }
      {
        name: icache_otp_key
        struct: sram_otp_key
        package: otp_ctrl_pkg
        type: req_rsp
        act: req
        width: 1
        inst_name: rv_core_ibex
        index: -1
      }
      {
        name: corei_tl_h
        struct: tl
        package: tlul_pkg
        type: req_rsp
        act: req
        width: 1
        inst_name: rv_core_ibex
        default: ""
        domain: Main
        top_signame: main_tl_rv_core_ibex__corei
        index: -1
      }
      {
        name: cored_tl_h
        struct: tl
        package: tlul_pkg
        type: req_rsp
        act: req
        width: 1
        inst_name: rv_core_ibex
        default: ""
        domain: Main
        top_signame: main_tl_rv_core_ibex__cored
        index: -1
      }
      {
        name: cfg_tl_d
        struct: tl
        package: tlul_pkg
        type: req_rsp
        act: rsp
        width: 1
        inst_name: rv_core_ibex
        default: ""
        end_idx: -1
        top_type: one-to-one
        top_signame: rv_core_ibex_cfg_tl_d
        index: -1
      }
      {
        name: tl_rv_core_ibex__corei
        struct: tl
        package: tlul_pkg
        type: req_rsp
        act: rsp
        inst_name: main
        width: 1
        default: ""
        end_idx: -1
        top_type: one-to-one
        top_signame: main_tl_rv_core_ibex__corei
        index: -1
      }
      {
        name: tl_rv_core_ibex__cored
        struct: tl
        package: tlul_pkg
        type: req_rsp
        act: rsp
        inst_name: main
        width: 1
        default: ""
        end_idx: -1
        top_type: one-to-one
        top_signame: main_tl_rv_core_ibex__cored
        index: -1
      }
      {
        name: tl_rom_ctrl__rom
        struct: tl
        package: tlul_pkg
        type: req_rsp
        act: req
        inst_name: main
        width: 1
        default: ""
        domain: Main
        top_signame: rom_ctrl_rom_tl
        index: -1
      }
      {
        name: tl_rom_ctrl__regs
        struct: tl
        package: tlul_pkg
        type: req_rsp
        act: req
        inst_name: main
        width: 1
        default: ""
        domain: Main
        top_signame: rom_ctrl_regs_tl
        index: -1
      }
      {
        name: tl_peri
        struct: tl
        package: tlul_pkg
        type: req_rsp
        act: req
        inst_name: main
        width: 1
        default: ""
        end_idx: -1
        top_type: one-to-one
        top_signame: main_tl_peri
        index: -1
      }
      {
        name: tl_flash_ctrl__core
        struct: tl
        package: tlul_pkg
        type: req_rsp
        act: req
        inst_name: main
        width: 1
        default: ""
        domain: Main
        top_signame: flash_ctrl_core_tl
        index: -1
      }
      {
        name: tl_flash_ctrl__prim
        struct: tl
        package: tlul_pkg
        type: req_rsp
        act: req
        inst_name: main
        width: 1
        default: ""
        domain: Main
        top_signame: flash_ctrl_prim_tl
        index: -1
      }
      {
        name: tl_flash_ctrl__mem
        struct: tl
        package: tlul_pkg
        type: req_rsp
        act: req
        inst_name: main
        width: 1
        default: ""
        domain: Main
        top_signame: flash_ctrl_mem_tl
        index: -1
      }
      {
        name: tl_aes
        struct: tl
        package: tlul_pkg
        type: req_rsp
        act: req
        inst_name: main
        width: 1
        default: ""
        domain: Main
        top_signame: aes_tl
        index: -1
      }
      {
        name: tl_rv_plic
        struct: tl
        package: tlul_pkg
        type: req_rsp
        act: req
        inst_name: main
        width: 1
        default: ""
        domain: Main
        top_signame: rv_plic_tl
        index: -1
      }
      {
        name: tl_rv_core_ibex__cfg
        struct: tl
        package: tlul_pkg
        type: req_rsp
        act: req
        inst_name: main
        width: 1
        default: ""
        domain: Main
        top_signame: rv_core_ibex_cfg_tl_d
        index: -1
      }
      {
        name: tl_sram_ctrl_main__regs
        struct: tl
        package: tlul_pkg
        type: req_rsp
        act: req
        inst_name: main
        width: 1
        default: ""
        domain: Main
        top_signame: sram_ctrl_main_regs_tl
        index: -1
      }
      {
        name: tl_sram_ctrl_main__ram
        struct: tl
        package: tlul_pkg
        type: req_rsp
        act: req
        inst_name: main
        width: 1
        default: ""
        domain: Main
        top_signame: sram_ctrl_main_ram_tl
        index: -1
      }
      {
        name: tl_main
        struct: tl
        package: tlul_pkg
        type: req_rsp
        act: rsp
        inst_name: peri
        width: 1
        default: ""
        domain: Main
        top_signame: main_tl_peri
        index: -1
      }
      {
        name: tl_uart0
        struct: tl
        package: tlul_pkg
        type: req_rsp
        act: req
        inst_name: peri
        width: 1
        default: ""
        domain: Main
        top_signame: uart0_tl
        index: -1
      }
      {
        name: tl_uart1
        struct: tl
        package: tlul_pkg
        type: req_rsp
        act: req
        inst_name: peri
        width: 1
        default: ""
        domain: Main
        top_signame: uart1_tl
        index: -1
      }
      {
        name: tl_gpio0
        struct: tl
        package: tlul_pkg
        type: req_rsp
        act: req
        inst_name: peri
        width: 1
        default: ""
        domain: Main
        top_signame: gpio0_tl
        index: -1
      }
      {
        name: tl_spi_device
        struct: tl
        package: tlul_pkg
        type: req_rsp
        act: req
        inst_name: peri
        width: 1
        default: ""
        domain: Main
        top_signame: spi_device_tl
        index: -1
      }
      {
        name: tl_spi_host0
        struct: tl
        package: tlul_pkg
        type: req_rsp
        act: req
        inst_name: peri
        width: 1
        default: ""
        domain: Main
        top_signame: spi_host0_tl
        index: -1
      }
      {
        name: tl_rv_timer
        struct: tl
        package: tlul_pkg
        type: req_rsp
        act: req
        inst_name: peri
        width: 1
        default: ""
        domain: Main
        top_signame: rv_timer_tl
        index: -1
      }
      {
        name: tl_usbdev
        struct: tl
        package: tlul_pkg
        type: req_rsp
        act: req
        inst_name: peri
        width: 1
        default: ""
        domain: Main
        top_signame: usbdev_tl
        index: -1
      }
      {
        name: tl_pwrmgr
        struct: tl
        package: tlul_pkg
        type: req_rsp
        act: req
        inst_name: peri
        width: 1
        default: ""
        domain: Main
        top_signame: pwrmgr_tl
        index: -1
        external: true
        conn_type: false
      }
      {
        name: tl_rstmgr
        struct: tl
        package: tlul_pkg
        type: req_rsp
        act: req
        inst_name: peri
        width: 1
        default: ""
        domain: Main
        top_signame: rstmgr_tl
        index: -1
        external: true
        conn_type: false
      }
      {
        name: tl_clkmgr
        struct: tl
        package: tlul_pkg
        type: req_rsp
        act: req
        inst_name: peri
        width: 1
        default: ""
        domain: Main
        top_signame: clkmgr_tl
        index: -1
        external: true
        conn_type: false
      }
      {
        name: tl_pinmux
        struct: tl
        package: tlul_pkg
        type: req_rsp
        act: req
        inst_name: peri
        width: 1
        default: ""
        domain: Main
        top_signame: pinmux_tl
        index: -1
      }
      {
        name: tl_ast
        struct: tl
        package: tlul_pkg
        type: req_rsp
        act: req
        inst_name: peri
        width: 1
        default: ""
        external: true
        conn_type: false
        index: -1
        top_signame: ast_tl
      }
      {
        struct: edn
        type: req_rsp
        name: edn
        act: rsp
        package: edn_pkg
        inst_name: ast
        index: -1
      }
      {
        struct: lc_tx
        type: uni
        name: lc_dft_en
        act: req
        package: lc_ctrl_pkg
        inst_name: ast
        index: -1
      }
      {
        struct: ram_1p_cfg_req
        package: prim_ram_1p_pkg
        type: uni
        name: ram_1p_cfg
        act: rcv
        inst_name: ast
        index: -1
      }
      {
        struct: ram_1r1w_cfg_req
        package: prim_ram_1r1w_pkg
        type: uni
        name: ram_1r1w_cfg
        act: rcv
        inst_name: ast
        index: -1
      }
      {
        struct: rom_cfg_req
        package: prim_rom_pkg
        type: uni
        name: rom_cfg
        act: rcv
        inst_name: ast
        index: -1
      }
    ]
    external:
    [
      {
        package: pwrmgr_pkg
        struct: pwr_nvm
        domain: Aon
        inter_pd: true
        signame: pwrmgr_pwr_nvm_i
        signame_chip:
        {
          cw305: pwrmgr_pwr_nvm
          verilator: pwrmgr_pwr_nvm
        }
        width: 1
        type: uni
        default: ""
        direction: in
        conn_type: false
        index: -1
        netname: pwrmgr_pwr_nvm
      }
      {
        package: pwrmgr_pkg
        struct: pwr_nvm
        domain: Main
        inter_pd: true
        signame: pwrmgr_pwr_nvm_o
        signame_chip:
        {
          cw305: pwrmgr_pwr_nvm
          verilator: pwrmgr_pwr_nvm
        }
        width: 1
        type: uni
        default: ""
        direction: out
        conn_type: false
        index: -1
        netname: pwrmgr_pwr_nvm
      }
      {
        package: ""
        struct: logic
        domain: Aon
        inter_pd: true
        signame: pwrmgr_strap_o
        signame_chip:
        {
          cw305: pwrmgr_strap
          verilator: pwrmgr_strap
        }
        width: 1
        type: uni
        default: ""
        direction: out
        conn_type: false
        index: -1
        netname: pwrmgr_strap
      }
      {
        package: ""
        struct: logic
        domain: Main
        inter_pd: true
        signame: pwrmgr_strap_i
        signame_chip:
        {
          cw305: pwrmgr_strap
          verilator: pwrmgr_strap
        }
        width: 1
        type: uni
        default: ""
        direction: in
        conn_type: false
        index: -1
        netname: pwrmgr_strap
      }
      {
        package: ""
        struct: logic
        domain: Aon
        inter_pd: true
        signame: pwrmgr_low_power_o
        signame_chip:
        {
          cw305: pwrmgr_low_power
          verilator: pwrmgr_low_power
        }
        width: 1
        type: uni
        default: ""
        direction: out
        conn_type: true
        index: -1
        netname: pwrmgr_low_power
      }
      {
        package: ""
        struct: logic
        domain: Main
        inter_pd: true
        signame: pwrmgr_low_power_i
        signame_chip:
        {
          cw305: pwrmgr_low_power
          verilator: pwrmgr_low_power
        }
        width: 1
        type: uni
        default: ""
        direction: in
        conn_type: false
        index: -1
        netname: pwrmgr_low_power
      }
      {
        package: lc_ctrl_pkg
        struct: lc_tx
        domain: Aon
        inter_pd: true
        signame: pwrmgr_fetch_en_o
        signame_chip:
        {
          cw305: pwrmgr_fetch_en
          verilator: pwrmgr_fetch_en
        }
        width: 1
        type: uni
        default: ""
        direction: out
        conn_type: false
        index: -1
        netname: pwrmgr_fetch_en
      }
      {
        package: lc_ctrl_pkg
        struct: lc_tx
        domain: Main
        inter_pd: true
        signame: pwrmgr_fetch_en_i
        signame_chip:
        {
          cw305: pwrmgr_fetch_en
          verilator: pwrmgr_fetch_en
        }
        width: 1
        type: uni
        default: ""
        direction: in
        conn_type: false
        index: -1
        netname: pwrmgr_fetch_en
      }
      {
        package: prim_mubi_pkg
        struct: mubi4
        domain: Aon
        inter_pd: true
        signame: clkmgr_idle_i
        signame_chip:
        {
          cw305: clkmgr_idle
          verilator: clkmgr_idle
        }
        width: 1
        type: uni
        default: ""
        direction: in
        conn_type: false
        index: -1
        netname: clkmgr_idle
      }
      {
        package: prim_mubi_pkg
        struct: mubi4
        domain: Main
        inter_pd: true
        signame: clkmgr_idle_o
        signame_chip:
        {
          cw305: clkmgr_idle
          verilator: clkmgr_idle
        }
        width: 1
        type: uni
        default: ""
        direction: out
        conn_type: false
        index: -1
        netname: clkmgr_idle
      }
      {
        package: rv_core_ibex_pkg
        struct: cpu_crash_dump
        domain: Main
        inter_pd: true
        signame: rv_core_ibex_crash_dump_o
        signame_chip:
        {
          cw305: rv_core_ibex_crash_dump
          verilator: rv_core_ibex_crash_dump
        }
        width: 1
        type: uni
        default: ""
        direction: out
        conn_type: false
        index: -1
        netname: rv_core_ibex_crash_dump
      }
      {
        package: rv_core_ibex_pkg
        struct: cpu_crash_dump
        domain: Aon
        inter_pd: true
        signame: rv_core_ibex_crash_dump_i
        signame_chip:
        {
          cw305: rv_core_ibex_crash_dump
          verilator: rv_core_ibex_crash_dump
        }
        width: 1
        type: uni
        default: ""
        direction: in
        conn_type: false
        index: -1
        netname: rv_core_ibex_crash_dump
      }
      {
        package: rv_core_ibex_pkg
        struct: cpu_pwrmgr
        domain: Main
        inter_pd: true
        signame: rv_core_ibex_pwrmgr_o
        signame_chip:
        {
          cw305: rv_core_ibex_pwrmgr
          verilator: rv_core_ibex_pwrmgr
        }
        width: 1
        type: uni
        default: ""
        direction: out
        conn_type: false
        index: -1
        netname: rv_core_ibex_pwrmgr
      }
      {
        package: rv_core_ibex_pkg
        struct: cpu_pwrmgr
        domain: Aon
        inter_pd: true
        signame: rv_core_ibex_pwrmgr_i
        signame_chip:
        {
          cw305: rv_core_ibex_pwrmgr
          verilator: rv_core_ibex_pwrmgr
        }
        width: 1
        type: uni
        default: ""
        direction: in
        conn_type: false
        index: -1
        netname: rv_core_ibex_pwrmgr
      }
      {
        package: ""
        struct: logic
        domain: Aon
        inter_pd: true
        signame: pwrmgr_wakeups_i
        signame_chip:
        {
          cw305: pwrmgr_wakeups
          verilator: pwrmgr_wakeups
        }
        width: 2
        type: uni
        default: ""
        direction: in
        conn_type: true
        index:
        [
          0
          1
        ]
        netname: pwrmgr_wakeups
      }
      {
        package: ""
        struct: logic
        domain: Main
        inter_pd: true
        signame: pwrmgr_wakeups_o
        signame_chip:
        {
          cw305: pwrmgr_wakeups
          verilator: pwrmgr_wakeups
        }
        width: 2
        type: uni
        default: ""
        direction: out
        conn_type: false
        index:
        [
          0
          1
        ]
        netname: pwrmgr_wakeups
      }
      {
        package: tlul_pkg
        struct: tl_h2d
        domain: Aon
        inter_pd: true
        signame: pwrmgr_tl_req_i
        signame_chip:
        {
          cw305: pwrmgr_tl_req
          verilator: pwrmgr_tl_req
        }
        width: 1
        type: req_rsp
        default: ""
        direction: in
        conn_type: false
        index: -1
        netname: pwrmgr_tl_h2d
      }
      {
        package: tlul_pkg
        struct: tl_d2h
        domain: Aon
        inter_pd: true
        signame: pwrmgr_tl_rsp_o
        signame_chip:
        {
          cw305: pwrmgr_tl_rsp
          verilator: pwrmgr_tl_rsp
        }
        width: 1
        type: req_rsp
        default: ""
        direction: out
        conn_type: false
        index: -1
        netname: pwrmgr_tl_d2h
      }
      {
        package: tlul_pkg
        struct: tl_h2d
        domain: Main
        inter_pd: true
        signame: pwrmgr_tl_req_o
        signame_chip:
        {
          cw305: pwrmgr_tl_req
          verilator: pwrmgr_tl_req
        }
        width: 1
        type: req_rsp
        default: ""
        direction: out
        conn_type: false
        index: -1
        netname: pwrmgr_tl_h2d
      }
      {
        package: tlul_pkg
        struct: tl_d2h
        domain: Main
        inter_pd: true
        signame: pwrmgr_tl_rsp_i
        signame_chip:
        {
          cw305: pwrmgr_tl_rsp
          verilator: pwrmgr_tl_rsp
        }
        width: 1
        type: req_rsp
        default: ""
        direction: in
        conn_type: false
        index: -1
        netname: pwrmgr_tl_d2h
      }
      {
        package: tlul_pkg
        struct: tl_h2d
        domain: Aon
        inter_pd: true
        signame: rstmgr_tl_req_i
        signame_chip:
        {
          cw305: rstmgr_tl_req
          verilator: rstmgr_tl_req
        }
        width: 1
        type: req_rsp
        default: ""
        direction: in
        conn_type: false
        index: -1
        netname: rstmgr_tl_h2d
      }
      {
        package: tlul_pkg
        struct: tl_d2h
        domain: Aon
        inter_pd: true
        signame: rstmgr_tl_rsp_o
        signame_chip:
        {
          cw305: rstmgr_tl_rsp
          verilator: rstmgr_tl_rsp
        }
        width: 1
        type: req_rsp
        default: ""
        direction: out
        conn_type: false
        index: -1
        netname: rstmgr_tl_d2h
      }
      {
        package: tlul_pkg
        struct: tl_h2d
        domain: Main
        inter_pd: true
        signame: rstmgr_tl_req_o
        signame_chip:
        {
          cw305: rstmgr_tl_req
          verilator: rstmgr_tl_req
        }
        width: 1
        type: req_rsp
        default: ""
        direction: out
        conn_type: false
        index: -1
        netname: rstmgr_tl_h2d
      }
      {
        package: tlul_pkg
        struct: tl_d2h
        domain: Main
        inter_pd: true
        signame: rstmgr_tl_rsp_i
        signame_chip:
        {
          cw305: rstmgr_tl_rsp
          verilator: rstmgr_tl_rsp
        }
        width: 1
        type: req_rsp
        default: ""
        direction: in
        conn_type: false
        index: -1
        netname: rstmgr_tl_d2h
      }
      {
        package: tlul_pkg
        struct: tl_h2d
        domain: Aon
        inter_pd: true
        signame: clkmgr_tl_req_i
        signame_chip:
        {
          cw305: clkmgr_tl_req
          verilator: clkmgr_tl_req
        }
        width: 1
        type: req_rsp
        default: ""
        direction: in
        conn_type: false
        index: -1
        netname: clkmgr_tl_h2d
      }
      {
        package: tlul_pkg
        struct: tl_d2h
        domain: Aon
        inter_pd: true
        signame: clkmgr_tl_rsp_o
        signame_chip:
        {
          cw305: clkmgr_tl_rsp
          verilator: clkmgr_tl_rsp
        }
        width: 1
        type: req_rsp
        default: ""
        direction: out
        conn_type: false
        index: -1
        netname: clkmgr_tl_d2h
      }
      {
        package: tlul_pkg
        struct: tl_h2d
        domain: Main
        inter_pd: true
        signame: clkmgr_tl_req_o
        signame_chip:
        {
          cw305: clkmgr_tl_req
          verilator: clkmgr_tl_req
        }
        width: 1
        type: req_rsp
        default: ""
        direction: out
        conn_type: false
        index: -1
        netname: clkmgr_tl_h2d
      }
      {
        package: tlul_pkg
        struct: tl_d2h
        domain: Main
        inter_pd: true
        signame: clkmgr_tl_rsp_i
        signame_chip:
        {
          cw305: clkmgr_tl_rsp
          verilator: clkmgr_tl_rsp
        }
        width: 1
        type: req_rsp
        default: ""
        direction: in
        conn_type: false
        index: -1
        netname: clkmgr_tl_d2h
      }
      {
        package: clkmgr_pkg
        struct: clkmgr_out_primary
        domain: Aon
        inter_pd: false
        signame: clkmgr_clocks_o
        signame_chip:
        {
          cw305: clkmgr_clocks
          verilator: clkmgr_clocks
        }
        width: 1
        type: uni
        default: ""
        direction: out
        conn_type: true
        index: -1
        netname: clkmgr_clocks
      }
      {
        package: clkmgr_pkg
        struct: clkmgr_cg_en_primary
        domain: Aon
        inter_pd: false
        signame: clkmgr_cg_en_o
        signame_chip:
        {
          cw305: ""
          verilator: ""
        }
        width: 1
        type: uni
        default: ""
        direction: out
        conn_type: true
        index: -1
        netname: clkmgr_cg_en
      }
      {
        package: prim_mubi_pkg
        struct: mubi4
        domain: Aon
        inter_pd: false
        signame: clk_main_jitter_en_o
        signame_chip:
        {
          cw305: clk_main_jitter_en
          verilator: clk_main_jitter_en
        }
        width: 1
        type: uni
        default: ""
        direction: out
        conn_type: false
        index: -1
        netname: clk_main_jitter_en
      }
      {
        package: prim_mubi_pkg
        struct: mubi4
        domain: Aon
        inter_pd: false
        signame: hi_speed_sel_o
        signame_chip:
        {
          cw305: hi_speed_sel
          verilator: hi_speed_sel
        }
        width: 1
        type: uni
        default: ""
        direction: out
        conn_type: false
        index: -1
        netname: hi_speed_sel
      }
      {
        package: prim_mubi_pkg
        struct: mubi4
        domain: Aon
        inter_pd: false
        signame: div_step_down_req_i
        signame_chip:
        {
          cw305: div_step_down_req
          verilator: div_step_down_req
        }
        width: 1
        type: uni
        default: ""
        direction: in
        conn_type: false
        index: -1
        netname: div_step_down_req
      }
      {
        package: prim_mubi_pkg
        struct: mubi4
        domain: Aon
        inter_pd: false
        signame: all_clk_byp_req_o
        signame_chip:
        {
          cw305: all_clk_byp_req
          verilator: all_clk_byp_req
        }
        width: 1
        type: uni
        default: ""
        direction: out
        conn_type: false
        index: -1
        netname: all_clk_byp_req
      }
      {
        package: prim_mubi_pkg
        struct: mubi4
        domain: Aon
        inter_pd: false
        signame: all_clk_byp_ack_i
        signame_chip:
        {
          cw305: all_clk_byp_ack
          verilator: all_clk_byp_ack
        }
        width: 1
        type: uni
        default: ""
        direction: in
        conn_type: false
        index: -1
        netname: all_clk_byp_ack
      }
      {
        package: prim_mubi_pkg
        struct: mubi4
        domain: Aon
        inter_pd: false
        signame: io_clk_byp_req_o
        signame_chip:
        {
          cw305: io_clk_byp_req
          verilator: io_clk_byp_req
        }
        width: 1
        type: uni
        default: ""
        direction: out
        conn_type: false
        index: -1
        netname: io_clk_byp_req
      }
      {
        package: prim_mubi_pkg
        struct: mubi4
        domain: Aon
        inter_pd: false
        signame: io_clk_byp_ack_i
        signame_chip:
        {
          cw305: io_clk_byp_ack
          verilator: io_clk_byp_ack
        }
        width: 1
        type: uni
        default: ""
        direction: in
        conn_type: false
        index: -1
        netname: io_clk_byp_ack
      }
      {
        package: prim_mubi_pkg
        struct: mubi4
        domain: Main
        inter_pd: false
        signame: flash_bist_enable_i
        signame_chip:
        {
          cw305: flash_bist_enable
          verilator: flash_bist_enable
        }
        width: 1
        type: uni
        default: ""
        direction: in
        conn_type: false
        index: -1
        netname: flash_bist_enable
      }
      {
        package: ""
        struct: logic
        domain: Main
        inter_pd: false
        signame: flash_power_down_h_i
        signame_chip:
        {
          cw305: 1'b0
          verilator: flash_power_down_h
        }
        width: 1
        type: uni
        default: ""
        direction: in
        conn_type: false
        index: -1
        netname: flash_power_down_h
      }
      {
        package: ""
        struct: logic
        domain: Main
        inter_pd: false
        signame: flash_power_ready_h_i
        signame_chip:
        {
          cw305: 1'b1
          verilator: flash_power_ready_h
        }
        width: 1
        type: uni
        default: ""
        direction: in
        conn_type: false
        index: -1
        netname: flash_power_ready_h
      }
      {
        package: ast_pkg
        struct: ast_obs_ctrl
        domain: Main
        inter_pd: false
        signame: obs_ctrl_i
        signame_chip:
        {
          cw305: obs_ctrl
          verilator: obs_ctrl
        }
        width: 1
        type: uni
        default: ""
        direction: in
        conn_type: false
        index: -1
        netname: obs_ctrl
      }
      {
        package: ""
        struct: logic
        domain: Main
        inter_pd: false
        signame: flash_obs_o
        signame_chip:
        {
          cw305: flash_obs
          verilator: flash_obs
        }
        width: 8
        type: uni
        default: ""
        direction: out
        conn_type: false
        index: -1
        netname: flash_obs
      }
      {
        package: tlul_pkg
        struct: tl_h2d
        domain: Main
        inter_pd: false
        signame: ast_tl_req_o
        signame_chip:
        {
          cw305: ast_tl_req
          verilator: ast_tl_req
        }
        width: 1
        type: req_rsp
        default: ""
        direction: out
        conn_type: false
        index: -1
        netname: ast_tl_h2d
      }
      {
        package: tlul_pkg
        struct: tl_d2h
        domain: Main
        inter_pd: false
        signame: ast_tl_rsp_i
        signame_chip:
        {
          cw305: ast_tl_rsp
          verilator: ast_tl_rsp
        }
        width: 1
        type: req_rsp
        default: ""
        direction: in
        conn_type: false
        index: -1
        netname: ast_tl_d2h
      }
      {
        package: pinmux_pkg
        struct: dft_strap_test_req
        domain: Main
        inter_pd: false
        signame: dft_strap_test_o
        signame_chip:
        {
          cw305: ""
          verilator: dft_strap_test
        }
        width: 1
        type: uni
        default: "'0"
        direction: out
        conn_type: false
        index: -1
        netname: dft_strap_test
      }
      {
        package: ""
        struct: logic
        domain: Main
        inter_pd: false
        signame: dft_hold_tap_sel_i
        signame_chip:
        {
          cw305: "'0"
          verilator: "'0"
        }
        width: 1
        type: uni
        default: "'0"
        direction: in
        conn_type: false
        index: -1
        netname: dft_hold_tap_sel
      }
      {
        package: ""
        struct: logic
        domain: Main
        inter_pd: false
        signame: usb_dp_pullup_en_o
        signame_chip:
        {
          cw305: usb_dp_pullup_en
          verilator: usb_dp_pullup_en
        }
        width: 1
        type: uni
        default: 1'b0
        direction: out
        conn_type: false
        index: -1
        netname: usb_dp_pullup_en
      }
      {
        package: ""
        struct: logic
        domain: Main
        inter_pd: false
        signame: usb_dn_pullup_en_o
        signame_chip:
        {
          cw305: usb_dn_pullup_en
          verilator: usb_dn_pullup_en
        }
        width: 1
        type: uni
        default: 1'b0
        direction: out
        conn_type: false
        index: -1
        netname: usb_dn_pullup_en
      }
      {
        package: pwrmgr_pkg
        struct: pwr_ast_req
        domain: Aon
        inter_pd: false
        signame: pwrmgr_ast_req_o
        signame_chip:
        {
          cw305: pwrmgr_ast_req
          verilator: pwrmgr_ast_req
        }
        width: 1
        type: req_rsp
        default: ""
        direction: out
        conn_type: false
        index: -1
        netname: pwrmgr_ast_req
      }
      {
        package: pwrmgr_pkg
        struct: pwr_ast_rsp
        domain: Aon
        inter_pd: false
        signame: pwrmgr_ast_rsp_i
        signame_chip:
        {
          cw305: pwrmgr_ast_rsp
          verilator: pwrmgr_ast_rsp
        }
        width: 1
        type: req_rsp
        default: ""
        direction: in
        conn_type: false
        index: -1
        netname: pwrmgr_ast_rsp
      }
      {
        package: ""
        struct: logic
        domain: Aon
        inter_pd: false
        signame: por_n_i
        signame_chip:
        {
          cw305: por_n
          verilator: por_n
        }
        width: 2
        type: uni
        default: ""
        direction: in
        conn_type: false
        index: -1
        netname: por_n
      }
      {
        package: rstmgr_pkg
        struct: rstmgr_out_primary
        domain: Aon
        inter_pd: false
        signame: rstmgr_resets_o
        signame_chip:
        {
          cw305: rstmgr_resets
          verilator: rstmgr_resets
        }
        width: 1
        type: uni
        default: ""
        direction: out
        conn_type: true
        index: -1
        netname: rstmgr_resets
      }
      {
        package: rstmgr_pkg
        struct: rstmgr_out_secondary
        domain: Aon
        inter_pd: false
        signame: rstmgr_resets_secondary_o
        signame_chip:
        {
          cw305: ""
          verilator: ""
        }
        width: 1
        type: uni
        default: ""
        direction: out
        conn_type: true
        index: -1
        netname: rstmgr_resets_secondary
      }
      {
        package: rstmgr_pkg
        struct: rstmgr_rst_en_primary
        domain: Aon
        inter_pd: false
        signame: rstmgr_rst_en_o
        signame_chip:
        {
          cw305: ""
          verilator: ""
        }
        width: 1
        type: uni
        default: ""
        direction: out
        conn_type: true
        index: -1
        netname: rstmgr_rst_en
      }
      {
        package: ""
        struct: logic
        domain: Main
        inter_pd: false
        signame: usbdev_usb_rx_d_i
        signame_chip:
        {
          cw305: 1'b0
          verilator: usb_rx_d
        }
        width: 1
        type: uni
        default: ""
        direction: in
        conn_type: false
        index: -1
        netname: usbdev_usb_rx_d
      }
      {
        package: ""
        struct: logic
        domain: Main
        inter_pd: false
        signame: usbdev_usb_tx_d_o
        signame_chip:
        {
          cw305: ""
          verilator: usb_tx_d
        }
        width: 1
        type: uni
        default: ""
        direction: out
        conn_type: false
        index: -1
        netname: usbdev_usb_tx_d
      }
      {
        package: ""
        struct: logic
        domain: Main
        inter_pd: false
        signame: usbdev_usb_tx_se0_o
        signame_chip:
        {
          cw305: ""
          verilator: usb_tx_se0
        }
        width: 1
        type: uni
        default: ""
        direction: out
        conn_type: false
        index: -1
        netname: usbdev_usb_tx_se0
      }
      {
        package: ""
        struct: logic
        domain: Main
        inter_pd: false
        signame: usbdev_usb_tx_use_d_se0_o
        signame_chip:
        {
          cw305: ""
          verilator: usb_tx_use_d_se0
        }
        width: 1
        type: uni
        default: ""
        direction: out
        conn_type: false
        index: -1
        netname: usbdev_usb_tx_use_d_se0
      }
      {
        package: ""
        struct: logic
        domain: Main
        inter_pd: false
        signame: usbdev_usb_rx_enable_o
        signame_chip:
        {
          cw305: ""
          verilator: usb_rx_enable
        }
        width: 1
        type: uni
        default: ""
        direction: out
        conn_type: false
        index: -1
        netname: usbdev_usb_rx_enable
      }
      {
        package: ""
        struct: logic
        domain: Main
        inter_pd: false
        signame: usbdev_usb_ref_val_o
        signame_chip:
        {
          cw305: usb_ref_val
          verilator: usb_ref_val
        }
        width: 1
        type: uni
        default: ""
        direction: out
        conn_type: false
        index: -1
        netname: usbdev_usb_ref_val
      }
      {
        package: ""
        struct: logic
        domain: Main
        inter_pd: false
        signame: usbdev_usb_ref_pulse_o
        signame_chip:
        {
          cw305: usb_ref_pulse
          verilator: usb_ref_pulse
        }
        width: 1
        type: uni
        default: ""
        direction: out
        conn_type: false
        index: -1
        netname: usbdev_usb_ref_pulse
      }
      {
        package: ""
        struct: logic
        domain: Main
        inter_pd: false
        signame: sck_monitor_o
        signame_chip:
        {
          cw305: sck_monitor
          verilator: sck_monitor
        }
        width: 1
        type: uni
        default: ""
        direction: out
        conn_type: false
        index: -1
        netname: sck_monitor
      }
    ]
    definitions:
    [
      {
        package: pwrmgr_pkg
        struct: pwr_rst_req
        domain: Aon
        signame: pwrmgr_pwr_rst_req
        width: 1
        type: req_rsp
        end_idx: -1
        act: req
        suffix: req
        default: ""
      }
      {
        package: pwrmgr_pkg
        struct: pwr_rst_rsp
        domain: Aon
        signame: pwrmgr_pwr_rst_rsp
        width: 1
        type: req_rsp
        end_idx: -1
        act: req
        suffix: rsp
        default: pwrmgr_pkg::PWR_RST_RSP_DEFAULT
      }
      {
        package: pwrmgr_pkg
        struct: pwr_clk_req
        domain: Aon
        signame: pwrmgr_pwr_clk_req
        width: 1
        type: req_rsp
        end_idx: -1
        act: req
        suffix: req
        default: ""
      }
      {
        package: pwrmgr_pkg
        struct: pwr_clk_rsp
        domain: Aon
        signame: pwrmgr_pwr_clk_rsp
        width: 1
        type: req_rsp
        end_idx: -1
        act: req
        suffix: rsp
        default: pwrmgr_pkg::PWR_CLK_RSP_DEFAULT
      }
      {
        package: ""
        struct: logic
        domain: Aon
        signame: pwrmgr_main_pd_aon_clk_en
        width: 1
        type: uni
        end_idx: -1
        act: req
        suffix: ""
        default: 1'b0
      }
      {
        package: ""
        struct: logic
        domain: Aon
        signame: pwrmgr_low_power
        width: 1
        type: uni
        end_idx: -1
        act: req
        suffix: ""
        default: 1'b0
      }
      {
        package: ""
        struct: logic
        domain: Main
        signame: usbdev_usb_dp_pullup
        width: 1
        type: uni
        end_idx: -1
        act: req
        suffix: ""
        default: 1'b0
      }
      {
        package: ""
        struct: logic
        domain: Main
        signame: usbdev_usb_dn_pullup
        width: 1
        type: uni
        end_idx: -1
        act: req
        suffix: ""
        default: 1'b0
      }
      {
        package: ""
        struct: logic
        domain: Main
        signame: usbdev_usb_aon_suspend_req
        width: 1
        type: uni
        end_idx: -1
        act: req
        suffix: ""
        default: 1'b0
      }
      {
        package: ""
        struct: logic
        domain: Main
        signame: usbdev_usb_aon_wake_ack
        width: 1
        type: uni
        end_idx: -1
        act: req
        suffix: ""
        default: 1'b0
      }
      {
        package: ""
        struct: logic
        domain: Main
        signame: usbdev_usb_aon_bus_reset
        width: 1
        type: uni
        end_idx: -1
        act: rcv
        suffix: ""
        default: 1'b0
      }
      {
        package: ""
        struct: logic
        domain: Main
        signame: usbdev_usb_aon_sense_lost
        width: 1
        type: uni
        end_idx: -1
        act: rcv
        suffix: ""
        default: 1'b0
      }
      {
        package: ""
        struct: logic
        domain: Main
        signame: pinmux_usbdev_wake_detect_active
        width: 1
        type: uni
        end_idx: -1
        act: req
        suffix: ""
        default: 1'b0
      }
      {
        package: ""
        struct: logic
        domain: Main
        signame: rv_plic_msip
        width: 1
        type: uni
        end_idx: -1
        act: req
        suffix: ""
        default: 1'b0
      }
      {
        package: ""
        struct: logic
        domain: Main
        signame: rv_plic_irq
        width: 1
        type: uni
        end_idx: -1
        act: req
        suffix: ""
        default: 1'b0
      }
      {
        package: spi_device_pkg
        struct: passthrough_req
        domain: Main
        signame: spi_device_passthrough_req
        width: 1
        type: req_rsp
        end_idx: -1
        act: req
        suffix: req
        default: ""
      }
      {
        package: spi_device_pkg
        struct: passthrough_rsp
        domain: Main
        signame: spi_device_passthrough_rsp
        width: 1
        type: req_rsp
        end_idx: -1
        act: req
        suffix: rsp
        default: spi_device_pkg::PASSTHROUGH_RSP_DEFAULT
      }
      {
        package: prim_mubi_pkg
        struct: mubi4
        domain: Aon
        signame: rstmgr_sw_rst_req
        width: 1
        type: uni
        end_idx: -1
        act: req
        suffix: ""
        default: prim_mubi_pkg::MUBI4_DEFAULT
      }
      {
        package: ""
        struct: logic
        domain: Aon
        signame: pwrmgr_wakeups
        width: 3
        type: uni
        end_idx: -1
        act: rcv
        suffix: ""
        default: "'0"
      }
      {
        package: ""
        struct: logic
        domain: Aon
        signame: pwrmgr_rstreqs
        width: 1
        type: uni
        end_idx: -1
        act: rcv
        suffix: ""
        default: 1'b0
      }
      {
        package: rstmgr_pkg
        struct: intraip_s2p
        domain: Aon
        signame: rstmgr_intraip_s2p
        width: 1
        type: uni
        end_idx: -1
        act: req
        suffix: ""
        default: rstmgr_pkg::INTRAIP_S2P_DEFAULT
      }
      {
        package: rstmgr_pkg
        struct: intraip_p2s
        domain: Aon
        signame: rstmgr_intraip_p2s
        width: 1
        type: uni
        end_idx: -1
        act: req
        suffix: ""
        default: rstmgr_pkg::INTRAIP_P2S_DEFAULT
      }
      {
        package: clkmgr_pkg
        struct: intraip_s2p
        domain: Aon
        signame: clkmgr_intraip_s2p
        width: 1
        type: uni
        end_idx: -1
        act: req
        suffix: ""
        default: clkmgr_pkg::INTRAIP_S2P_DEFAULT
      }
      {
        package: clkmgr_pkg
        struct: intraip_p2s
        domain: Aon
        signame: clkmgr_intraip_p2s
        width: 1
        type: uni
        end_idx: -1
        act: req
        suffix: ""
        default: clkmgr_pkg::INTRAIP_P2S_DEFAULT
      }
      {
        package: tlul_pkg
        struct: tl_h2d
        domain: Main
        signame: main_tl_rv_core_ibex__corei_req
        width: 1
        type: req_rsp
        end_idx: -1
        act: rsp
        suffix: req
        default: tlul_pkg::TL_H2D_DEFAULT
      }
      {
        package: tlul_pkg
        struct: tl_d2h
        domain: Main
        signame: main_tl_rv_core_ibex__corei_rsp
        width: 1
        type: req_rsp
        end_idx: -1
        act: rsp
        suffix: rsp
        default: ""
      }
      {
        package: tlul_pkg
        struct: tl_h2d
        domain: Main
        signame: main_tl_rv_core_ibex__cored_req
        width: 1
        type: req_rsp
        end_idx: -1
        act: rsp
        suffix: req
        default: tlul_pkg::TL_H2D_DEFAULT
      }
      {
        package: tlul_pkg
        struct: tl_d2h
        domain: Main
        signame: main_tl_rv_core_ibex__cored_rsp
        width: 1
        type: req_rsp
        end_idx: -1
        act: rsp
        suffix: rsp
        default: ""
      }
      {
        package: tlul_pkg
        struct: tl_h2d
        domain: Main
        signame: rom_ctrl_rom_tl_req
        width: 1
        type: req_rsp
        end_idx: -1
        act: rsp
        suffix: req
        default: tlul_pkg::TL_H2D_DEFAULT
      }
      {
        package: tlul_pkg
        struct: tl_d2h
        domain: Main
        signame: rom_ctrl_rom_tl_rsp
        width: 1
        type: req_rsp
        end_idx: -1
        act: rsp
        suffix: rsp
        default: ""
      }
      {
        package: tlul_pkg
        struct: tl_h2d
        domain: Main
        signame: rom_ctrl_regs_tl_req
        width: 1
        type: req_rsp
        end_idx: -1
        act: rsp
        suffix: req
        default: tlul_pkg::TL_H2D_DEFAULT
      }
      {
        package: tlul_pkg
        struct: tl_d2h
        domain: Main
        signame: rom_ctrl_regs_tl_rsp
        width: 1
        type: req_rsp
        end_idx: -1
        act: rsp
        suffix: rsp
        default: ""
      }
      {
        package: tlul_pkg
        struct: tl_h2d
        domain: Main
        signame: main_tl_peri_req
        width: 1
        type: req_rsp
        end_idx: -1
        act: req
        suffix: req
        default: ""
      }
      {
        package: tlul_pkg
        struct: tl_d2h
        domain: Main
        signame: main_tl_peri_rsp
        width: 1
        type: req_rsp
        end_idx: -1
        act: req
        suffix: rsp
        default: tlul_pkg::TL_D2H_DEFAULT
      }
      {
        package: tlul_pkg
        struct: tl_h2d
        domain: Main
        signame: flash_ctrl_core_tl_req
        width: 1
        type: req_rsp
        end_idx: -1
        act: rsp
        suffix: req
        default: tlul_pkg::TL_H2D_DEFAULT
      }
      {
        package: tlul_pkg
        struct: tl_d2h
        domain: Main
        signame: flash_ctrl_core_tl_rsp
        width: 1
        type: req_rsp
        end_idx: -1
        act: rsp
        suffix: rsp
        default: ""
      }
      {
        package: tlul_pkg
        struct: tl_h2d
        domain: Main
        signame: flash_ctrl_prim_tl_req
        width: 1
        type: req_rsp
        end_idx: -1
        act: rsp
        suffix: req
        default: tlul_pkg::TL_H2D_DEFAULT
      }
      {
        package: tlul_pkg
        struct: tl_d2h
        domain: Main
        signame: flash_ctrl_prim_tl_rsp
        width: 1
        type: req_rsp
        end_idx: -1
        act: rsp
        suffix: rsp
        default: ""
      }
      {
        package: tlul_pkg
        struct: tl_h2d
        domain: Main
        signame: flash_ctrl_mem_tl_req
        width: 1
        type: req_rsp
        end_idx: -1
        act: rsp
        suffix: req
        default: tlul_pkg::TL_H2D_DEFAULT
      }
      {
        package: tlul_pkg
        struct: tl_d2h
        domain: Main
        signame: flash_ctrl_mem_tl_rsp
        width: 1
        type: req_rsp
        end_idx: -1
        act: rsp
        suffix: rsp
        default: ""
      }
      {
        package: tlul_pkg
        struct: tl_h2d
        domain: Main
        signame: aes_tl_req
        width: 1
        type: req_rsp
        end_idx: -1
        act: rsp
        suffix: req
        default: tlul_pkg::TL_H2D_DEFAULT
      }
      {
        package: tlul_pkg
        struct: tl_d2h
        domain: Main
        signame: aes_tl_rsp
        width: 1
        type: req_rsp
        end_idx: -1
        act: rsp
        suffix: rsp
        default: ""
      }
      {
        package: tlul_pkg
        struct: tl_h2d
        domain: Main
        signame: rv_plic_tl_req
        width: 1
        type: req_rsp
        end_idx: -1
        act: rsp
        suffix: req
        default: tlul_pkg::TL_H2D_DEFAULT
      }
      {
        package: tlul_pkg
        struct: tl_d2h
        domain: Main
        signame: rv_plic_tl_rsp
        width: 1
        type: req_rsp
        end_idx: -1
        act: rsp
        suffix: rsp
        default: ""
      }
      {
        package: tlul_pkg
        struct: tl_h2d
        domain: Main
        signame: rv_core_ibex_cfg_tl_d_req
        width: 1
        type: req_rsp
        end_idx: -1
        act: rsp
        suffix: req
        default: tlul_pkg::TL_H2D_DEFAULT
      }
      {
        package: tlul_pkg
        struct: tl_d2h
        domain: Main
        signame: rv_core_ibex_cfg_tl_d_rsp
        width: 1
        type: req_rsp
        end_idx: -1
        act: rsp
        suffix: rsp
        default: ""
      }
      {
        package: tlul_pkg
        struct: tl_h2d
        domain: Main
        signame: sram_ctrl_main_regs_tl_req
        width: 1
        type: req_rsp
        end_idx: -1
        act: rsp
        suffix: req
        default: tlul_pkg::TL_H2D_DEFAULT
      }
      {
        package: tlul_pkg
        struct: tl_d2h
        domain: Main
        signame: sram_ctrl_main_regs_tl_rsp
        width: 1
        type: req_rsp
        end_idx: -1
        act: rsp
        suffix: rsp
        default: ""
      }
      {
        package: tlul_pkg
        struct: tl_h2d
        domain: Main
        signame: sram_ctrl_main_ram_tl_req
        width: 1
        type: req_rsp
        end_idx: -1
        act: rsp
        suffix: req
        default: tlul_pkg::TL_H2D_DEFAULT
      }
      {
        package: tlul_pkg
        struct: tl_d2h
        domain: Main
        signame: sram_ctrl_main_ram_tl_rsp
        width: 1
        type: req_rsp
        end_idx: -1
        act: rsp
        suffix: rsp
        default: ""
      }
      {
        package: tlul_pkg
        struct: tl_h2d
        domain: Main
        signame: uart0_tl_req
        width: 1
        type: req_rsp
        end_idx: -1
        act: rsp
        suffix: req
        default: tlul_pkg::TL_H2D_DEFAULT
      }
      {
        package: tlul_pkg
        struct: tl_d2h
        domain: Main
        signame: uart0_tl_rsp
        width: 1
        type: req_rsp
        end_idx: -1
        act: rsp
        suffix: rsp
        default: ""
      }
      {
        package: tlul_pkg
        struct: tl_h2d
        domain: Main
        signame: uart1_tl_req
        width: 1
        type: req_rsp
        end_idx: -1
        act: rsp
        suffix: req
        default: tlul_pkg::TL_H2D_DEFAULT
      }
      {
        package: tlul_pkg
        struct: tl_d2h
        domain: Main
        signame: uart1_tl_rsp
        width: 1
        type: req_rsp
        end_idx: -1
        act: rsp
        suffix: rsp
        default: ""
      }
      {
        package: tlul_pkg
        struct: tl_h2d
        domain: Main
        signame: gpio0_tl_req
        width: 1
        type: req_rsp
        end_idx: -1
        act: rsp
        suffix: req
        default: tlul_pkg::TL_H2D_DEFAULT
      }
      {
        package: tlul_pkg
        struct: tl_d2h
        domain: Main
        signame: gpio0_tl_rsp
        width: 1
        type: req_rsp
        end_idx: -1
        act: rsp
        suffix: rsp
        default: ""
      }
      {
        package: tlul_pkg
        struct: tl_h2d
        domain: Main
        signame: spi_device_tl_req
        width: 1
        type: req_rsp
        end_idx: -1
        act: rsp
        suffix: req
        default: tlul_pkg::TL_H2D_DEFAULT
      }
      {
        package: tlul_pkg
        struct: tl_d2h
        domain: Main
        signame: spi_device_tl_rsp
        width: 1
        type: req_rsp
        end_idx: -1
        act: rsp
        suffix: rsp
        default: ""
      }
      {
        package: tlul_pkg
        struct: tl_h2d
        domain: Main
        signame: spi_host0_tl_req
        width: 1
        type: req_rsp
        end_idx: -1
        act: rsp
        suffix: req
        default: tlul_pkg::TL_H2D_DEFAULT
      }
      {
        package: tlul_pkg
        struct: tl_d2h
        domain: Main
        signame: spi_host0_tl_rsp
        width: 1
        type: req_rsp
        end_idx: -1
        act: rsp
        suffix: rsp
        default: ""
      }
      {
        package: tlul_pkg
        struct: tl_h2d
        domain: Main
        signame: rv_timer_tl_req
        width: 1
        type: req_rsp
        end_idx: -1
        act: rsp
        suffix: req
        default: tlul_pkg::TL_H2D_DEFAULT
      }
      {
        package: tlul_pkg
        struct: tl_d2h
        domain: Main
        signame: rv_timer_tl_rsp
        width: 1
        type: req_rsp
        end_idx: -1
        act: rsp
        suffix: rsp
        default: ""
      }
      {
        package: tlul_pkg
        struct: tl_h2d
        domain: Main
        signame: usbdev_tl_req
        width: 1
        type: req_rsp
        end_idx: -1
        act: rsp
        suffix: req
        default: tlul_pkg::TL_H2D_DEFAULT
      }
      {
        package: tlul_pkg
        struct: tl_d2h
        domain: Main
        signame: usbdev_tl_rsp
        width: 1
        type: req_rsp
        end_idx: -1
        act: rsp
        suffix: rsp
        default: ""
      }
      {
        package: tlul_pkg
        struct: tl_h2d
        domain: Main
        signame: pinmux_tl_req
        width: 1
        type: req_rsp
        end_idx: -1
        act: rsp
        suffix: req
        default: tlul_pkg::TL_H2D_DEFAULT
      }
      {
        package: tlul_pkg
        struct: tl_d2h
        domain: Main
        signame: pinmux_tl_rsp
        width: 1
        type: req_rsp
        end_idx: -1
        act: rsp
        suffix: rsp
        default: ""
      }
      {
        package: clkmgr_pkg
        struct: clkmgr_out_primary
        signame: clkmgr_clocks
        domain: Aon
        width: 1
        type: uni
        end_idx: -1
        default: ""
      }
      {
        package: clkmgr_pkg
        struct: clkmgr_out_secondary
        signame: clkmgr_clocks_secondary
        domain: Aon
        width: 1
        type: uni
        end_idx: -1
        default: ""
      }
      {
        package: clkmgr_pkg
        struct: clkmgr_cg_en_primary
        signame: clkmgr_cg_en
        domain: Aon
        width: 1
        type: uni
        end_idx: -1
        default: ""
      }
      {
        package: rstmgr_pkg
        struct: rstmgr_out_primary
        signame: rstmgr_resets
        domain: Aon
        width: 1
        type: uni
        end_idx: -1
        default: ""
      }
      {
        package: rstmgr_pkg
        struct: rstmgr_out_secondary
        signame: rstmgr_resets_secondary
        domain: Aon
        width: 1
        type: uni
        end_idx: -1
        default: ""
      }
      {
        package: rstmgr_pkg
        struct: rstmgr_rst_en_primary
        signame: rstmgr_rst_en
        domain: Aon
        width: 1
        type: uni
        end_idx: -1
        default: ""
      }
      {
        package: ""
        struct: logic
        signame: rv_core_ibex_irq_timer
        domain: Main
        width: 1
        type: uni
        end_idx: -1
        default: ""
      }
      {
        package: ""
        struct: logic
        signame: rv_core_ibex_hart_id
        domain: Main
        width: 32
        type: uni
        end_idx: -1
        default: ""
      }
      {
        package: ""
        struct: logic
        signame: rv_core_ibex_boot_addr
        domain: Main
        width: 32
        type: uni
        end_idx: -1
        default: ""
      }
      {
        package: jtag_pkg
        struct: jtag_req
        domain: Main
        signame: pinmux_dft_jtag_req
        width: 1
        type: req_rsp
        end_idx: -1
        default: ""
      }
      {
        package: jtag_pkg
        struct: jtag_rsp
        domain: Main
        signame: pinmux_dft_jtag_rsp
        width: 1
        type: req_rsp
        end_idx: -1
        default: ""
      }
    ]
  }
}
